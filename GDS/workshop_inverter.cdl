* workshop_inverter: LVS reference netlist (generated by gen_lvs_netlist.py)

.subckt vco_only VCTRL VCO_EN IN OUT FOUT INV_IN VDD_DEC VSS INV_OUT VDD_INV
*.PININFO VCTRL:I VCO_EN:I IN:B OUT:B FOUT:O INV_IN:B VDD_DEC:B VSS:B INV_OUT:B VDD_INV:B
X2 VCTRL VBP VBN VDD_INV VSS vco_bias_5v0
X3 R0 R1 VBP VDD_INV VBN VSS cs_inv_5v0
X4 R1 R2 VBP VDD_INV VBN VSS cs_inv_5v0
X5 R2 R3 VBP VDD_INV VBN VSS cs_inv_5v0
X6 R3 R4 VBP VDD_INV VBN VSS cs_inv_5v0
X7 R4 R5 VBP VDD_INV VBN VSS cs_inv_5v0
X8 R5 R6 VBP VDD_INV VBN VSS cs_inv_x4_5v0
MPD R0 VCO_ENB1 VSS VSS nfet_05v0 L=0.60u W=0.42u nf=1
X9 R3 FB VDD_INV VSS vco_buf1_5v0
X10 FB FOUT VDD_INV VSS vco_buf2_5v0
X11 R6 INV_IN VCO_EN VCO_ENB3 VDD_DEC VSS tgate_5v0
X12 IN INV_IN VCO_ENB4 VCO_EN VDD_DEC VSS tgate_5v0
X13 INV_OUT R0 VCO_EN VCO_ENB1 VDD_DEC VSS tgate_5v0
X14 INV_OUT OUT VCO_ENB2 VCO_EN VDD_DEC VSS tgate_5v0
DANT2 VSS VCTRL diode_nw2ps_06v0 A='1.4u * 1.2u ' P='2*1.4u + 2*1.2u '
X15 VCO_EN VCO_ENB3 VDD_DEC VSS inv_ctrl_5v0
X16 VCO_EN VCO_ENB4 VDD_DEC VSS inv_ctrl_5v0
X17 VCO_EN VCO_ENB1 VDD_DEC VSS inv_ctrl_5v0
X18 VCO_EN VCO_ENB2 VDD_DEC VSS inv_ctrl_5v0
DANT3 VSS VCO_EN diode_nw2ps_06v0 A='1.4u * 1.2u ' P='2*1.4u + 2*1.2u '
DANT4 VSS VCO_EN diode_nw2ps_06v0 A='1.4u * 1.2u ' P='2*1.4u + 2*1.2u '
DANT5 VSS VCO_EN diode_nw2ps_06v0 A='1.4u * 1.2u ' P='2*1.4u + 2*1.2u '
DANT6 VSS VCO_EN diode_nw2ps_06v0 A='1.4u * 1.2u ' P='2*1.4u + 2*1.2u '
.ends

.subckt vco_bias_5v0 VCTRL VBP VBN VDD VSS
*.PININFO VCTRL:I VBP:O VBN:O VDD:B VSS:B
MPB VBP VBP VDD VDD pfet_05v0 L=1u W=16u nf=1
MNI VBP VCTRL VSS VSS nfet_05v0 L=2u W=2u nf=1
MPM VBN VBP VDD VDD pfet_05v0 L=1u W=16u nf=1
MNM VBN VBN VSS VSS nfet_05v0 L=1u W=4u nf=1
.ends

.subckt cs_inv_5v0 A Y VBP VDD VBN VSS
*.PININFO A:I Y:O VBP:I VDD:B VBN:I VSS:B
MPC NP VBP VDD VDD pfet_05v0 L=1u W=16u nf=1
MP Y A NP VDD pfet_05v0 L=0.50u W=4u nf=1
MN Y A NN VSS nfet_05v0 L=0.60u W=2u nf=1
MNC NN VBN VSS VSS nfet_05v0 L=1u W=4u nf=1
.ends

.subckt cs_inv_x4_5v0 A Y VBP VDD VBN VSS
*.PININFO A:I Y:O VBP:I VDD:B VBN:I VSS:B
MPC NP VBP VDD VDD pfet_05v0 L=1u W=64u nf=1
MP Y A NP VDD pfet_05v0 L=0.50u W=12u nf=1
MN Y A NN VSS nfet_05v0 L=0.60u W=6u nf=1
MNC NN VBN VSS VSS nfet_05v0 L=1u W=16u nf=1
.ends

.subckt vco_buf1_5v0 A Y VDD VSS
*.PININFO A:I Y:O VDD:B VSS:B
MP Y A VDD VDD pfet_05v0 L=0.50u W=2u nf=1
MN Y A VSS VSS nfet_05v0 L=0.60u W=1u nf=1
.ends

.subckt vco_buf2_5v0 A Y VDD VSS
*.PININFO A:I Y:O VDD:B VSS:B
MP Y A VDD VDD pfet_05v0 L=0.50u W=8u nf=1
MN Y A VSS VSS nfet_05v0 L=0.60u W=4u nf=1
.ends

.subckt tgate_5v0 A B EN ENB VDD VSS
*.PININFO A:B B:B EN:I ENB:I VDD:B VSS:B
MN A EN B VSS nfet_05v0 L=0.60u W=2u nf=1
MP B ENB A VDD pfet_05v0 L=0.50u W=6u nf=1
.ends

.subckt inv_ctrl_5v0 A Y VDD VSS
*.PININFO A:I Y:O VDD:B VSS:B
MP Y A VDD VDD pfet_05v0 L=0.50u W=2u nf=1
MN Y A VSS VSS nfet_05v0 L=0.60u W=1u nf=1
.ends

.subckt tgate_5v0_in IN SEL VDD_DEC VSS DUT_IN
*.PININFO IN:B SEL:I VDD_DEC:B VSS:B DUT_IN:B
X0_SELB SEL SELB VDD_DEC VSS inv_ctrl_5v0
X0_TGIN IN DUT_IN SEL SELB VDD_DEC VSS tgate_5v0
MPD DUT_IN SELB VSS VSS nfet_05v0 L=0.60u W=0.42u nf=1
DANT VSS SEL diode_nw2ps_06v0 A='1.4u * 1.2u ' P='2*1.4u + 2*1.2u '
.ends

.subckt tgate_5v0_out OUT SEL VDD_DEC VSS DUT_OUT
*.PININFO OUT:B SEL:I VDD_DEC:B VSS:B DUT_OUT:B
X0_SELB SEL SELB VDD_DEC VSS inv_ctrl_5v0
DANT VSS SEL diode_nw2ps_06v0 A='1.4u * 1.2u ' P='2*1.4u + 2*1.2u '
X0_TGOUT DUT_OUT OUT SEL SELB VDD_DEC VSS tgate_5v0
.ends

.subckt decoder_7to128 VDD VSS dec_in[0] dec_in[1] dec_in[2] dec_in[3] dec_in[4] dec_in[5] dec_in[6] dec_out[0] dec_out[100] dec_out[101] dec_out[102] dec_out[103] dec_out[104] dec_out[105] dec_out[106] dec_out[107] dec_out[108] dec_out[109] dec_out[10] dec_out[110] dec_out[111] dec_out[112] dec_out[113] dec_out[114] dec_out[115] dec_out[116] dec_out[117] dec_out[118] dec_out[119] dec_out[11] dec_out[120] dec_out[121] dec_out[122] dec_out[123] dec_out[124] dec_out[125] dec_out[126] dec_out[127] dec_out[12] dec_out[13] dec_out[14] dec_out[15] dec_out[16] dec_out[17] dec_out[18] dec_out[19] dec_out[1] dec_out[20] dec_out[21] dec_out[22] dec_out[23] dec_out[24] dec_out[25] dec_out[26] dec_out[27] dec_out[28] dec_out[29] dec_out[2] dec_out[30] dec_out[31] dec_out[32] dec_out[33] dec_out[34] dec_out[35] dec_out[36] dec_out[37] dec_out[38] dec_out[39] dec_out[3] dec_out[40] dec_out[41] dec_out[42] dec_out[43] dec_out[44] dec_out[45] dec_out[46] dec_out[47] dec_out[48] dec_out[49] dec_out[4] dec_out[50] dec_out[51] dec_out[52] dec_out[53] dec_out[54] dec_out[55] dec_out[56] dec_out[57] dec_out[58] dec_out[59] dec_out[5] dec_out[60] dec_out[61] dec_out[62] dec_out[63] dec_out[64] dec_out[65] dec_out[66] dec_out[67] dec_out[68] dec_out[69] dec_out[6] dec_out[70] dec_out[71] dec_out[72] dec_out[73] dec_out[74] dec_out[75] dec_out[76] dec_out[77] dec_out[78] dec_out[79] dec_out[7] dec_out[80] dec_out[81] dec_out[82] dec_out[83] dec_out[84] dec_out[85] dec_out[86] dec_out[87] dec_out[88] dec_out[89] dec_out[8] dec_out[90] dec_out[91] dec_out[92] dec_out[93] dec_out[94] dec_out[95] dec_out[96] dec_out[97] dec_out[98] dec_out[99] dec_out[9]
X0_TAP_TAPCELL_ROW_15_106 VDD VSS gf180mcu_fd_sc_mcu7t5v0__filltie
X0_fanout149 _208_/A3 _198_/A2 VDD VDD VSS VSS gf180mcu_fd_sc_mcu7t5v0__dlyb_1
X0_FILLER_12_10 VDD VDD VSS VSS gf180mcu_fd_sc_mcu7t5v0__fillcap_4
X0_FILLER_6_107 VDD VDD VSS VSS gf180mcu_fd_sc_mcu7t5v0__fill_1
X0_TAP_TAPCELL_ROW_8_77 VDD VSS gf180mcu_fd_sc_mcu7t5v0__filltie
X0_FILLER_15_206 VDD VDD VSS VSS gf180mcu_fd_sc_mcu7t5v0__fillcap_4
X0__062_ _042_/I _080_/A2 _044_/I _093_/A2 _095_/A4 VDD VDD VSS VSS gf180mcu_fd_sc_mcu7t5v0__nand4_1
X0__131_ _134_/A1 _133_/A3 _197_/A3 _131_/ZN VDD VDD VSS VSS gf180mcu_fd_sc_mcu7t5v0__nor3_1
X0__200_ _207_/A1 _207_/A2 _208_/A3 _200_/A4 _200_/ZN VDD VDD VSS VSS gf180mcu_fd_sc_mcu7t5v0__nor4_1
X0_FILLER_14_261 VDD VDD VSS VSS gf180mcu_fd_sc_mcu7t5v0__fill_2
X0_PHY_EDGE_ROW_8_Left_25 VDD VSS gf180mcu_fd_sc_mcu7t5v0__endcap
X0__114_ _122_/A1 _129_/A3 _182_/A3 _114_/ZN VDD VDD VSS VSS gf180mcu_fd_sc_mcu7t5v0__nor3_1
X0__045_ _045_/I _093_/A2 VDD VDD VSS VSS gf180mcu_fd_sc_mcu7t5v0__clkinv_1
X0_FILLER_16_312 VDD VDD VSS VSS gf180mcu_fd_sc_mcu7t5v0__fill_2
X0_FILLER_3_282 VDD VDD VSS VSS gf180mcu_fd_sc_mcu7t5v0__fill_2
X0_output31 _202_/ZN dec_out[120] VDD VDD VSS VSS gf180mcu_fd_sc_mcu7t5v0__dlyb_1
X0_output97 _147_/ZN dec_out[65] VDD VDD VSS VSS gf180mcu_fd_sc_mcu7t5v0__dlyb_1
X0_output75 _124_/ZN dec_out[45] VDD VDD VSS VSS gf180mcu_fd_sc_mcu7t5v0__dlyb_1
X0_output64 _113_/ZN dec_out[35] VDD VDD VSS VSS gf180mcu_fd_sc_mcu7t5v0__dlyb_1
X0_output53 _100_/ZN dec_out[25] VDD VDD VSS VSS gf180mcu_fd_sc_mcu7t5v0__dlyb_1
X0_output86 _135_/Z dec_out[55] VDD VDD VSS VSS gf180mcu_fd_sc_mcu7t5v0__dlyb_1
X0_output20 _192_/ZN dec_out[110] VDD VDD VSS VSS gf180mcu_fd_sc_mcu7t5v0__dlyb_1
X0_output42 _086_/ZN dec_out[15] VDD VDD VSS VSS gf180mcu_fd_sc_mcu7t5v0__dlyb_1
X0_FILLER_10_329 VDD VDD VSS VSS gf180mcu_fd_sc_mcu7t5v0__fill_2
X0_TAP_TAPCELL_ROW_15_107 VDD VSS gf180mcu_fd_sc_mcu7t5v0__filltie
X0_FILLER_13_178 VDD VDD VSS VSS gf180mcu_fd_sc_mcu7t5v0__fillcap_32
X0_TAP_TAPCELL_ROW_8_78 VDD VSS gf180mcu_fd_sc_mcu7t5v0__filltie
X0_PHY_EDGE_ROW_12_Right_12 VDD VSS gf180mcu_fd_sc_mcu7t5v0__endcap
X0__130_ _134_/A1 _138_/A2 _143_/A3 _196_/A4 _130_/ZN VDD VDD VSS VSS gf180mcu_fd_sc_mcu7t5v0__nor4_1
X0__061_ _089_/A1 _089_/A3 _182_/A3 _061_/ZN VDD VDD VSS VSS gf180mcu_fd_sc_mcu7t5v0__nor3_1
X0_FILLER_2_177 VDD VDD VSS VSS gf180mcu_fd_sc_mcu7t5v0__fillcap_4
X0_FILLER_3_2 VDD VDD VSS VSS gf180mcu_fd_sc_mcu7t5v0__fillcap_4
X0__113_ _122_/A1 _129_/A3 _181_/A3 _113_/ZN VDD VDD VSS VSS gf180mcu_fd_sc_mcu7t5v0__nor3_1
X0__044_ _044_/I _102_/A1 VDD VDD VSS VSS gf180mcu_fd_sc_mcu7t5v0__clkinv_1
X0_FILLER_1_209 VDD VDD VSS VSS gf180mcu_fd_sc_mcu7t5v0__fill_1
X0_PHY_EDGE_ROW_6_Right_6 VDD VSS gf180mcu_fd_sc_mcu7t5v0__endcap
X0_FILLER_15_99 VDD VDD VSS VSS gf180mcu_fd_sc_mcu7t5v0__fillcap_4
X0_output32 _203_/ZN dec_out[121] VDD VDD VSS VSS gf180mcu_fd_sc_mcu7t5v0__dlyb_1
X0_output65 _114_/ZN dec_out[36] VDD VDD VSS VSS gf180mcu_fd_sc_mcu7t5v0__dlyb_1
X0_TAP_TAPCELL_ROW_2_47 VDD VSS gf180mcu_fd_sc_mcu7t5v0__filltie
X0_output10 _183_/ZN dec_out[101] VDD VDD VSS VSS gf180mcu_fd_sc_mcu7t5v0__dlyb_1
X0_output98 _148_/ZN dec_out[66] VDD VDD VSS VSS gf180mcu_fd_sc_mcu7t5v0__dlyb_1
X0_output87 _137_/ZN dec_out[56] VDD VDD VSS VSS gf180mcu_fd_sc_mcu7t5v0__dlyb_1
X0_output76 _125_/ZN dec_out[46] VDD VDD VSS VSS gf180mcu_fd_sc_mcu7t5v0__dlyb_1
X0_output54 _101_/ZN dec_out[26] VDD VDD VSS VSS gf180mcu_fd_sc_mcu7t5v0__dlyb_1
X0_output8 _052_/ZN dec_out[0] VDD VDD VSS VSS gf180mcu_fd_sc_mcu7t5v0__dlyb_1
X0_output43 _088_/ZN dec_out[16] VDD VDD VSS VSS gf180mcu_fd_sc_mcu7t5v0__dlyb_1
X0_output21 _193_/ZN dec_out[111] VDD VDD VSS VSS gf180mcu_fd_sc_mcu7t5v0__dlyb_1
X0_TAP_TAPCELL_ROW_15_108 VDD VSS gf180mcu_fd_sc_mcu7t5v0__filltie
X0_FILLER_9_139 VDD VDD VSS VSS gf180mcu_fd_sc_mcu7t5v0__fill_1
X0_FILLER_5_6 VDD VDD VSS VSS gf180mcu_fd_sc_mcu7t5v0__fill_2
X0_FILLER_5_142 VDD VDD VSS VSS gf180mcu_fd_sc_mcu7t5v0__fillcap_4
X0__060_ _044_/I _093_/A2 _101_/A2 _104_/A4 _182_/A3 VDD VDD VSS VSS gf180mcu_fd_sc_mcu7t5v0__nand4_1
X0__189_ _197_/A1 _198_/A2 _189_/A3 _189_/ZN VDD VDD VSS VSS gf180mcu_fd_sc_mcu7t5v0__nor3_1
X0__112_ _122_/A1 _124_/A2 _129_/A3 _196_/A4 _112_/ZN VDD VDD VSS VSS gf180mcu_fd_sc_mcu7t5v0__nor4_1
X0_FILLER_11_200 VDD VDD VSS VSS gf180mcu_fd_sc_mcu7t5v0__fill_2
X0_FILLER_7_204 VDD VDD VSS VSS gf180mcu_fd_sc_mcu7t5v0__fillcap_4
X0__043_ _043_/I _080_/A2 VDD VDD VSS VSS gf180mcu_fd_sc_mcu7t5v0__clkinv_1
X0_FILLER_16_314 VDD VDD VSS VSS gf180mcu_fd_sc_mcu7t5v0__fill_1
X0_FILLER_16_133 VDD VDD VSS VSS gf180mcu_fd_sc_mcu7t5v0__fill_2
X0_FILLER_15_89 VDD VDD VSS VSS gf180mcu_fd_sc_mcu7t5v0__fill_2
X0_FILLER_15_34 VDD VDD VSS VSS gf180mcu_fd_sc_mcu7t5v0__fillcap_4
X0_output33 _204_/ZN dec_out[122] VDD VDD VSS VSS gf180mcu_fd_sc_mcu7t5v0__dlyb_1
X0_output22 _194_/ZN dec_out[112] VDD VDD VSS VSS gf180mcu_fd_sc_mcu7t5v0__dlyb_1
X0_TAP_TAPCELL_ROW_2_48 VDD VSS gf180mcu_fd_sc_mcu7t5v0__filltie
X0_output9 _182_/ZN dec_out[100] VDD VDD VSS VSS gf180mcu_fd_sc_mcu7t5v0__dlyb_1
X0_output99 _149_/ZN dec_out[67] VDD VDD VSS VSS gf180mcu_fd_sc_mcu7t5v0__dlyb_1
X0_output88 _138_/ZN dec_out[57] VDD VDD VSS VSS gf180mcu_fd_sc_mcu7t5v0__dlyb_1
X0_output44 _089_/ZN dec_out[17] VDD VDD VSS VSS gf180mcu_fd_sc_mcu7t5v0__dlyb_1
X0_output77 _126_/ZN dec_out[47] VDD VDD VSS VSS gf180mcu_fd_sc_mcu7t5v0__dlyb_1
X0_output11 _184_/ZN dec_out[102] VDD VDD VSS VSS gf180mcu_fd_sc_mcu7t5v0__dlyb_1
X0_output66 _115_/ZN dec_out[37] VDD VDD VSS VSS gf180mcu_fd_sc_mcu7t5v0__dlyb_1
X0_output55 _103_/ZN dec_out[27] VDD VDD VSS VSS gf180mcu_fd_sc_mcu7t5v0__dlyb_1
X0_FILLER_16_188 VDD VDD VSS VSS gf180mcu_fd_sc_mcu7t5v0__fillcap_16
X0_FILLER_11_2 VDD VDD VSS VSS gf180mcu_fd_sc_mcu7t5v0__fillcap_8
X0_TAP_TAPCELL_ROW_15_109 VDD VSS gf180mcu_fd_sc_mcu7t5v0__filltie
X0_FILLER_13_169 VDD VDD VSS VSS gf180mcu_fd_sc_mcu7t5v0__fill_1
X0_FILLER_13_114 VDD VDD VSS VSS gf180mcu_fd_sc_mcu7t5v0__fill_1
X0_FILLER_2_327 VDD VDD VSS VSS gf180mcu_fd_sc_mcu7t5v0__fillcap_4
X0__188_ _197_/A1 _046_/I _208_/A3 _204_/A4 _188_/ZN VDD VDD VSS VSS gf180mcu_fd_sc_mcu7t5v0__nor4_1
X0_FILLER_11_212 VDD VDD VSS VSS gf180mcu_fd_sc_mcu7t5v0__fill_2
X0_FILLER_9_290 VDD VDD VSS VSS gf180mcu_fd_sc_mcu7t5v0__fill_1
X0__111_ _122_/A1 _124_/A2 _129_/A3 _195_/A4 _111_/ZN VDD VDD VSS VSS gf180mcu_fd_sc_mcu7t5v0__nor4_1
X0__042_ _042_/I _082_/A1 VDD VDD VSS VSS gf180mcu_fd_sc_mcu7t5v0__clkinv_1
X0_wire136 _071_/ZN wire136/Z VDD VDD VSS VSS gf180mcu_fd_sc_mcu7t5v0__clkbuf_1
X0_FILLER_6_37 VDD VDD VSS VSS gf180mcu_fd_sc_mcu7t5v0__fill_2
X0_output34 _205_/ZN dec_out[123] VDD VDD VSS VSS gf180mcu_fd_sc_mcu7t5v0__dlyb_1
X0_TAP_TAPCELL_ROW_2_49 VDD VSS gf180mcu_fd_sc_mcu7t5v0__filltie
X0_output67 _116_/ZN dec_out[38] VDD VDD VSS VSS gf180mcu_fd_sc_mcu7t5v0__dlyb_1
X0_output56 _105_/ZN dec_out[28] VDD VDD VSS VSS gf180mcu_fd_sc_mcu7t5v0__dlyb_1
X0_output12 _185_/Z dec_out[103] VDD VDD VSS VSS gf180mcu_fd_sc_mcu7t5v0__dlyb_1
X0_output89 _139_/ZN dec_out[58] VDD VDD VSS VSS gf180mcu_fd_sc_mcu7t5v0__dlyb_1
X0_output78 _128_/ZN dec_out[48] VDD VDD VSS VSS gf180mcu_fd_sc_mcu7t5v0__dlyb_1
X0_output23 _195_/ZN dec_out[113] VDD VDD VSS VSS gf180mcu_fd_sc_mcu7t5v0__dlyb_1
X0_output45 _090_/ZN dec_out[18] VDD VDD VSS VSS gf180mcu_fd_sc_mcu7t5v0__dlyb_1
X0_FILLER_16_112 VDD VDD VSS VSS gf180mcu_fd_sc_mcu7t5v0__fillcap_4
X0_FILLER_12_14 VDD VDD VSS VSS gf180mcu_fd_sc_mcu7t5v0__fill_2
X0_FILLER_10_118 VDD VDD VSS VSS gf180mcu_fd_sc_mcu7t5v0__fill_2
X0_FILLER_8_141 VDD VDD VSS VSS gf180mcu_fd_sc_mcu7t5v0__fill_1
X0_FILLER_8_152 VDD VDD VSS VSS gf180mcu_fd_sc_mcu7t5v0__fill_1
X0_FILLER_5_8 VDD VDD VSS VSS gf180mcu_fd_sc_mcu7t5v0__fill_1
X0_FILLER_4_92 VDD VDD VSS VSS gf180mcu_fd_sc_mcu7t5v0__fill_2
X0_FILLER_14_243 VDD VDD VSS VSS gf180mcu_fd_sc_mcu7t5v0__fill_2
X0__187_ _197_/A1 _046_/I _198_/A2 _203_/A4 _187_/ZN VDD VDD VSS VSS gf180mcu_fd_sc_mcu7t5v0__nor4_1
X0_TAP_TAPCELL_ROW_9_80 VDD VSS gf180mcu_fd_sc_mcu7t5v0__filltie
X0_wire137 _083_/A4 _208_/A4 VDD VDD VSS VSS gf180mcu_fd_sc_mcu7t5v0__buf_2
X0_FILLER_11_279 VDD VDD VSS VSS gf180mcu_fd_sc_mcu7t5v0__fill_1
X0__041_ _041_/I _186_/A1 VDD VDD VSS VSS gf180mcu_fd_sc_mcu7t5v0__clkinv_1
X0__110_ _139_/A1 _135_/A2 _133_/A3 _178_/A4 _110_/ZN VDD VDD VSS VSS gf180mcu_fd_sc_mcu7t5v0__nor4_1
X0_FILLER_1_2 VDD VDD VSS VSS gf180mcu_fd_sc_mcu7t5v0__fillcap_4
X0_PHY_EDGE_ROW_12_Left_29 VDD VSS gf180mcu_fd_sc_mcu7t5v0__endcap
X0_output35 _206_/ZN dec_out[124] VDD VDD VSS VSS gf180mcu_fd_sc_mcu7t5v0__dlyb_1
X0_output57 _106_/ZN dec_out[29] VDD VDD VSS VSS gf180mcu_fd_sc_mcu7t5v0__dlyb_1
X0_output46 _092_/ZN dec_out[19] VDD VDD VSS VSS gf180mcu_fd_sc_mcu7t5v0__dlyb_1
X0_output24 _196_/ZN dec_out[114] VDD VDD VSS VSS gf180mcu_fd_sc_mcu7t5v0__dlyb_1
X0_output13 _186_/ZN dec_out[104] VDD VDD VSS VSS gf180mcu_fd_sc_mcu7t5v0__dlyb_1
X0_FILLER_16_135 VDD VDD VSS VSS gf180mcu_fd_sc_mcu7t5v0__fill_1
X0_output79 _129_/ZN dec_out[49] VDD VDD VSS VSS gf180mcu_fd_sc_mcu7t5v0__dlyb_1
X0_output68 _117_/Z dec_out[39] VDD VDD VSS VSS gf180mcu_fd_sc_mcu7t5v0__dlyb_1
X0_FILLER_8_312 VDD VDD VSS VSS gf180mcu_fd_sc_mcu7t5v0__fill_2
X0_PHY_EDGE_ROW_15_Left_32 VDD VSS gf180mcu_fd_sc_mcu7t5v0__endcap
X0_FILLER_12_37 VDD VDD VSS VSS gf180mcu_fd_sc_mcu7t5v0__fill_1
X0_FILLER_12_26 VDD VDD VSS VSS gf180mcu_fd_sc_mcu7t5v0__fill_1
X0_PHY_EDGE_ROW_0_Left_17 VDD VSS gf180mcu_fd_sc_mcu7t5v0__endcap
X0_FILLER_14_211 VDD VDD VSS VSS gf180mcu_fd_sc_mcu7t5v0__fill_1
X0__186_ _186_/A1 _186_/A2 _186_/ZN VDD VDD VSS VSS gf180mcu_fd_sc_mcu7t5v0__nor2_1
X0_TAP_TAPCELL_ROW_9_81 VDD VSS gf180mcu_fd_sc_mcu7t5v0__filltie
X0_FILLER_11_247 VDD VDD VSS VSS gf180mcu_fd_sc_mcu7t5v0__fillcap_4
X0_FILLER_11_214 VDD VDD VSS VSS gf180mcu_fd_sc_mcu7t5v0__fill_1
X0_PHY_EDGE_ROW_3_Left_20 VDD VSS gf180mcu_fd_sc_mcu7t5v0__endcap
X0_FILLER_1_72 VDD VDD VSS VSS gf180mcu_fd_sc_mcu7t5v0__fillcap_4
X0__169_ _041_/I _169_/A2 _182_/A2 _201_/A4 _169_/Z VDD VDD VSS VSS gf180mcu_fd_sc_mcu7t5v0__and4_1
X0_FILLER_3_276 VDD VDD VSS VSS gf180mcu_fd_sc_mcu7t5v0__fillcap_4
X0_output36 _207_/ZN dec_out[125] VDD VDD VSS VSS gf180mcu_fd_sc_mcu7t5v0__dlyb_1
X0_output14 _187_/ZN dec_out[105] VDD VDD VSS VSS gf180mcu_fd_sc_mcu7t5v0__dlyb_1
X0_output69 _059_/ZN dec_out[3] VDD VDD VSS VSS gf180mcu_fd_sc_mcu7t5v0__dlyb_1
X0_output58 _056_/ZN dec_out[2] VDD VDD VSS VSS gf180mcu_fd_sc_mcu7t5v0__dlyb_1
X0_output47 _054_/ZN dec_out[1] VDD VDD VSS VSS gf180mcu_fd_sc_mcu7t5v0__dlyb_1
X0_output25 _197_/ZN dec_out[115] VDD VDD VSS VSS gf180mcu_fd_sc_mcu7t5v0__dlyb_1
X0_TAP_TAPCELL_ROW_14_101 VDD VSS gf180mcu_fd_sc_mcu7t5v0__filltie
X0_FILLER_12_172 VDD VDD VSS VSS gf180mcu_fd_sc_mcu7t5v0__fill_2
X0_FILLER_12_183 VDD VDD VSS VSS gf180mcu_fd_sc_mcu7t5v0__fillcap_4
X0_FILLER_8_187 VDD VDD VSS VSS gf180mcu_fd_sc_mcu7t5v0__fillcap_4
X0_FILLER_12_16 VDD VDD VSS VSS gf180mcu_fd_sc_mcu7t5v0__fill_1
X0_FILLER_1_330 VDD VDD VSS VSS gf180mcu_fd_sc_mcu7t5v0__fill_1
X0_FILLER_5_146 VDD VDD VSS VSS gf180mcu_fd_sc_mcu7t5v0__fill_1
X0_FILLER_4_94 VDD VDD VSS VSS gf180mcu_fd_sc_mcu7t5v0__fill_1
X0__185_ _201_/A1 _207_/A2 _201_/A3 _201_/A4 _185_/Z VDD VDD VSS VSS gf180mcu_fd_sc_mcu7t5v0__and4_1
X0_TAP_TAPCELL_ROW_0_40 VDD VSS gf180mcu_fd_sc_mcu7t5v0__filltie
X0_TAP_TAPCELL_ROW_9_82 VDD VSS gf180mcu_fd_sc_mcu7t5v0__filltie
X0_FILLER_7_208 VDD VDD VSS VSS gf180mcu_fd_sc_mcu7t5v0__fill_2
X0_FILLER_6_274 VDD VDD VSS VSS gf180mcu_fd_sc_mcu7t5v0__fill_1
X0__168_ _175_/A1 _208_/A2 _047_/I _200_/A4 _168_/ZN VDD VDD VSS VSS gf180mcu_fd_sc_mcu7t5v0__nor4_1
X0__099_ _041_/I _164_/A3 _170_/A3 _099_/ZN VDD VDD VSS VSS gf180mcu_fd_sc_mcu7t5v0__nor3_1
X0_output37 _208_/ZN dec_out[126] VDD VDD VSS VSS gf180mcu_fd_sc_mcu7t5v0__dlyb_1
X0_output26 _198_/ZN dec_out[116] VDD VDD VSS VSS gf180mcu_fd_sc_mcu7t5v0__dlyb_1
X0_PHY_EDGE_ROW_1_Right_1 VDD VSS gf180mcu_fd_sc_mcu7t5v0__endcap
X0_output15 _188_/ZN dec_out[106] VDD VDD VSS VSS gf180mcu_fd_sc_mcu7t5v0__dlyb_1
X0_FILLER_0_203 VDD VDD VSS VSS gf180mcu_fd_sc_mcu7t5v0__fill_1
X0_output48 _094_/ZN dec_out[20] VDD VDD VSS VSS gf180mcu_fd_sc_mcu7t5v0__dlyb_1
X0_output59 _107_/ZN dec_out[30] VDD VDD VSS VSS gf180mcu_fd_sc_mcu7t5v0__dlyb_1
X0_FILLER_8_314 VDD VDD VSS VSS gf180mcu_fd_sc_mcu7t5v0__fill_1
X0_FILLER_7_72 VDD VDD VSS VSS gf180mcu_fd_sc_mcu7t5v0__fillcap_4
X0_TAP_TAPCELL_ROW_14_102 VDD VSS gf180mcu_fd_sc_mcu7t5v0__filltie
X0__184_ _197_/A1 _046_/I _198_/A2 _200_/A4 _184_/ZN VDD VDD VSS VSS gf180mcu_fd_sc_mcu7t5v0__nor4_1
X0_TAP_TAPCELL_ROW_0_41 VDD VSS gf180mcu_fd_sc_mcu7t5v0__filltie
X0__098_ _136_/A1 _159_/A2 _136_/A4 _170_/A3 VDD VDD VSS VSS gf180mcu_fd_sc_mcu7t5v0__nand3_1
X0__167_ _175_/A1 _208_/A2 _047_/I _199_/A4 _167_/ZN VDD VDD VSS VSS gf180mcu_fd_sc_mcu7t5v0__nor4_1
X0_FILLER_16_308 VDD VDD VSS VSS gf180mcu_fd_sc_mcu7t5v0__fillcap_4
X0_FILLER_10_83 VDD VDD VSS VSS gf180mcu_fd_sc_mcu7t5v0__fill_2
X0_TAP_TAPCELL_ROW_10_83 VDD VSS gf180mcu_fd_sc_mcu7t5v0__filltie
X0_FILLER_16_138 VDD VDD VSS VSS gf180mcu_fd_sc_mcu7t5v0__fillcap_32
X0_FILLER_16_116 VDD VDD VSS VSS gf180mcu_fd_sc_mcu7t5v0__fill_1
X0_output38 _209_/ZN dec_out[127] VDD VDD VSS VSS gf180mcu_fd_sc_mcu7t5v0__dlyb_1
X0_output49 _095_/ZN dec_out[21] VDD VDD VSS VSS gf180mcu_fd_sc_mcu7t5v0__dlyb_1
X0_output16 _189_/ZN dec_out[107] VDD VDD VSS VSS gf180mcu_fd_sc_mcu7t5v0__dlyb_1
X0_output27 _199_/ZN dec_out[117] VDD VDD VSS VSS gf180mcu_fd_sc_mcu7t5v0__dlyb_1
X0_PHY_EDGE_ROW_15_Right_15 VDD VSS gf180mcu_fd_sc_mcu7t5v0__endcap
X0_TAP_TAPCELL_ROW_14_103 VDD VSS gf180mcu_fd_sc_mcu7t5v0__filltie
X0_FILLER_12_174 VDD VDD VSS VSS gf180mcu_fd_sc_mcu7t5v0__fill_1
X0_TAP_TAPCELL_ROW_3_52 VDD VSS gf180mcu_fd_sc_mcu7t5v0__filltie
X0_FILLER_8_123 VDD VDD VSS VSS gf180mcu_fd_sc_mcu7t5v0__fillcap_4
X0_FILLER_4_41 VDD VDD VSS VSS gf180mcu_fd_sc_mcu7t5v0__fill_2
X0_FILLER_2_107 VDD VDD VSS VSS gf180mcu_fd_sc_mcu7t5v0__fillcap_4
X0__183_ _197_/A1 _046_/I _198_/A2 _199_/A4 _183_/ZN VDD VDD VSS VSS gf180mcu_fd_sc_mcu7t5v0__nor4_1
X0_FILLER_13_72 VDD VDD VSS VSS gf180mcu_fd_sc_mcu7t5v0__fill_1
X0_TAP_TAPCELL_ROW_0_42 VDD VSS gf180mcu_fd_sc_mcu7t5v0__filltie
X0__166_ _175_/A1 _047_/I _198_/A3 _166_/ZN VDD VDD VSS VSS gf180mcu_fd_sc_mcu7t5v0__nor3_1
X0__097_ _135_/A1 _124_/A2 _133_/A3 _201_/A4 _097_/Z VDD VDD VSS VSS gf180mcu_fd_sc_mcu7t5v0__and4_1
X0_TAP_TAPCELL_ROW_10_84 VDD VSS gf180mcu_fd_sc_mcu7t5v0__filltie
X0_PHY_EDGE_ROW_7_Left_24 VDD VSS gf180mcu_fd_sc_mcu7t5v0__endcap
X0__149_ _159_/A1 _158_/A2 _181_/A3 _149_/ZN VDD VDD VSS VSS gf180mcu_fd_sc_mcu7t5v0__nor3_1
X0_output39 _079_/ZN dec_out[12] VDD VDD VSS VSS gf180mcu_fd_sc_mcu7t5v0__dlyb_1
X0_output17 _190_/ZN dec_out[108] VDD VDD VSS VSS gf180mcu_fd_sc_mcu7t5v0__dlyb_1
X0_output28 _200_/ZN dec_out[118] VDD VDD VSS VSS gf180mcu_fd_sc_mcu7t5v0__dlyb_1
X0_FILLER_8_327 VDD VDD VSS VSS gf180mcu_fd_sc_mcu7t5v0__fillcap_4
X0_TAP_TAPCELL_ROW_14_104 VDD VSS gf180mcu_fd_sc_mcu7t5v0__filltie
X0_TAP_TAPCELL_ROW_3_53 VDD VSS gf180mcu_fd_sc_mcu7t5v0__filltie
X0__182_ _182_/A1 _182_/A2 _182_/A3 _182_/ZN VDD VDD VSS VSS gf180mcu_fd_sc_mcu7t5v0__nor3_1
X0__096_ _096_/A1 _101_/A2 _096_/A3 _096_/A4 _096_/ZN VDD VDD VSS VSS gf180mcu_fd_sc_mcu7t5v0__nor4_1
X0_FILLER_10_240 VDD VDD VSS VSS gf180mcu_fd_sc_mcu7t5v0__fillcap_4
X0__165_ _175_/A1 _047_/I _197_/A3 _165_/ZN VDD VDD VSS VSS gf180mcu_fd_sc_mcu7t5v0__nor3_1
X0_TAP_TAPCELL_ROW_10_85 VDD VSS gf180mcu_fd_sc_mcu7t5v0__filltie
X0_FILLER_15_321 VDD VDD VSS VSS gf180mcu_fd_sc_mcu7t5v0__fillcap_8
X0__148_ _159_/A1 _159_/A2 _158_/A2 _196_/A4 _148_/ZN VDD VDD VSS VSS gf180mcu_fd_sc_mcu7t5v0__nor4_1
X0_output29 _201_/Z dec_out[119] VDD VDD VSS VSS gf180mcu_fd_sc_mcu7t5v0__dlyb_1
X0__079_ _096_/A1 _096_/A3 _190_/A3 _079_/ZN VDD VDD VSS VSS gf180mcu_fd_sc_mcu7t5v0__nor3_1
X0_output18 _191_/ZN dec_out[109] VDD VDD VSS VSS gf180mcu_fd_sc_mcu7t5v0__dlyb_1
X0_FILLER_12_313 VDD VDD VSS VSS gf180mcu_fd_sc_mcu7t5v0__fill_2
X0_PHY_EDGE_ROW_5_Right_5 VDD VSS gf180mcu_fd_sc_mcu7t5v0__endcap
X0_TAP_TAPCELL_ROW_14_105 VDD VSS gf180mcu_fd_sc_mcu7t5v0__filltie
X0_FILLER_12_187 VDD VDD VSS VSS gf180mcu_fd_sc_mcu7t5v0__fill_1
X0_TAP_TAPCELL_ROW_3_54 VDD VSS gf180mcu_fd_sc_mcu7t5v0__filltie
X0_FILLER_16_290 VDD VDD VSS VSS gf180mcu_fd_sc_mcu7t5v0__fillcap_16
X0_FILLER_4_43 VDD VDD VSS VSS gf180mcu_fd_sc_mcu7t5v0__fill_1
X0_FILLER_14_227 VDD VDD VSS VSS gf180mcu_fd_sc_mcu7t5v0__fillcap_4
X0__181_ _182_/A1 _182_/A2 _181_/A3 _181_/ZN VDD VDD VSS VSS gf180mcu_fd_sc_mcu7t5v0__nor3_1
X0_FILLER_1_142 VDD VDD VSS VSS gf180mcu_fd_sc_mcu7t5v0__fill_2
X0__095_ _096_/A1 _101_/A2 _096_/A3 _095_/A4 _095_/ZN VDD VDD VSS VSS gf180mcu_fd_sc_mcu7t5v0__nor4_1
X0__164_ _175_/A1 _208_/A2 _164_/A3 _196_/A4 _164_/ZN VDD VDD VSS VSS gf180mcu_fd_sc_mcu7t5v0__nor4_1
X0_TAP_TAPCELL_ROW_10_86 VDD VSS gf180mcu_fd_sc_mcu7t5v0__filltie
X0_TAP_TAPCELL_ROW_6_65 VDD VSS gf180mcu_fd_sc_mcu7t5v0__filltie
X0__078_ input3/Z _045_/I _101_/A2 _104_/A4 _190_/A3 VDD VDD VSS VSS gf180mcu_fd_sc_mcu7t5v0__nand4_1
X0__147_ _159_/A1 _159_/A2 _158_/A2 _195_/A4 _147_/ZN VDD VDD VSS VSS gf180mcu_fd_sc_mcu7t5v0__nor4_1
X0_FILLER_12_325 VDD VDD VSS VSS gf180mcu_fd_sc_mcu7t5v0__fillcap_4
X0_output19 _075_/ZN dec_out[10] VDD VDD VSS VSS gf180mcu_fd_sc_mcu7t5v0__dlyb_1
X0_FILLER_16_52 VDD VDD VSS VSS gf180mcu_fd_sc_mcu7t5v0__fill_2
X0_PHY_EDGE_ROW_11_Right_11 VDD VSS gf180mcu_fd_sc_mcu7t5v0__endcap
X0_TAP_TAPCELL_ROW_3_55 VDD VSS gf180mcu_fd_sc_mcu7t5v0__filltie
X0_FILLER_8_137 VDD VDD VSS VSS gf180mcu_fd_sc_mcu7t5v0__fillcap_4
X0_FILLER_14_239 VDD VDD VSS VSS gf180mcu_fd_sc_mcu7t5v0__fillcap_4
X0_FILLER_14_217 VDD VDD VSS VSS gf180mcu_fd_sc_mcu7t5v0__fill_2
X0_TAP_TAPCELL_ROW_13_97 VDD VSS gf180mcu_fd_sc_mcu7t5v0__filltie
X0__180_ _182_/A1 _046_/I _182_/A2 _196_/A4 _180_/ZN VDD VDD VSS VSS gf180mcu_fd_sc_mcu7t5v0__nor4_1
X0_TAP_TAPCELL_ROW_0_34 VDD VSS gf180mcu_fd_sc_mcu7t5v0__filltie
X0__094_ _096_/A1 _096_/A3 _198_/A3 _094_/ZN VDD VDD VSS VSS gf180mcu_fd_sc_mcu7t5v0__nor3_1
X0__163_ _175_/A1 _208_/A2 _164_/A3 _195_/A4 _163_/ZN VDD VDD VSS VSS gf180mcu_fd_sc_mcu7t5v0__nor4_1
X0_TAP_TAPCELL_ROW_10_87 VDD VSS gf180mcu_fd_sc_mcu7t5v0__filltie
X0__077_ _089_/A1 _096_/A3 _189_/A3 _077_/ZN VDD VDD VSS VSS gf180mcu_fd_sc_mcu7t5v0__nor3_1
X0_TAP_TAPCELL_ROW_6_66 VDD VSS gf180mcu_fd_sc_mcu7t5v0__filltie
X0__146_ _159_/A1 _169_/A2 _164_/A3 _178_/A4 _146_/ZN VDD VDD VSS VSS gf180mcu_fd_sc_mcu7t5v0__nor4_1
X0_FILLER_15_142 VDD VDD VSS VSS gf180mcu_fd_sc_mcu7t5v0__fillcap_64
X0__129_ _134_/A1 _138_/A2 _129_/A3 _195_/A4 _129_/ZN VDD VDD VSS VSS gf180mcu_fd_sc_mcu7t5v0__nor4_1
X0_FILLER_12_101 VDD VDD VSS VSS gf180mcu_fd_sc_mcu7t5v0__fillcap_4
X0_TAP_TAPCELL_ROW_13_98 VDD VSS gf180mcu_fd_sc_mcu7t5v0__filltie
X0_FILLER_1_144 VDD VDD VSS VSS gf180mcu_fd_sc_mcu7t5v0__fill_1
X0_TAP_TAPCELL_ROW_0_35 VDD VSS gf180mcu_fd_sc_mcu7t5v0__filltie
X0__093_ input3/Z _093_/A2 _104_/A3 _104_/A4 _198_/A3 VDD VDD VSS VSS gf180mcu_fd_sc_mcu7t5v0__nand4_1
X0__162_ _162_/A1 _162_/A2 _162_/A3 _162_/ZN VDD VDD VSS VSS gf180mcu_fd_sc_mcu7t5v0__nor3_1
X0_input1 dec_in[0] input1/Z VDD VDD VSS VSS gf180mcu_fd_sc_mcu7t5v0__dlyb_1
X0__076_ _102_/A1 _045_/I _101_/A2 _057_/Z _189_/A3 VDD VDD VSS VSS gf180mcu_fd_sc_mcu7t5v0__nand4_1
X0_PHY_EDGE_ROW_11_Left_28 VDD VSS gf180mcu_fd_sc_mcu7t5v0__endcap
X0_TAP_TAPCELL_ROW_6_67 VDD VSS gf180mcu_fd_sc_mcu7t5v0__filltie
X0__145_ _201_/A1 _209_/A2 _145_/ZN VDD VDD VSS VSS gf180mcu_fd_sc_mcu7t5v0__nor2_1
X0_FILLER_16_2 VDD VDD VSS VSS gf180mcu_fd_sc_mcu7t5v0__fillcap_8
X0__059_ _089_/A1 _089_/A3 _181_/A3 _059_/ZN VDD VDD VSS VSS gf180mcu_fd_sc_mcu7t5v0__nor3_1
X0__128_ _139_/A1 _194_/A2 _128_/ZN VDD VDD VSS VSS gf180mcu_fd_sc_mcu7t5v0__nor2_1
X0_FILLER_16_10 VDD VDD VSS VSS gf180mcu_fd_sc_mcu7t5v0__fillcap_4
X0_PHY_EDGE_ROW_9_Right_9 VDD VSS gf180mcu_fd_sc_mcu7t5v0__endcap
X0_PHY_EDGE_ROW_14_Left_31 VDD VSS gf180mcu_fd_sc_mcu7t5v0__endcap
X0_TAP_TAPCELL_ROW_13_99 VDD VSS gf180mcu_fd_sc_mcu7t5v0__filltie
X0_FILLER_13_66 VDD VDD VSS VSS gf180mcu_fd_sc_mcu7t5v0__fillcap_4
X0_TAP_TAPCELL_ROW_0_36 VDD VSS gf180mcu_fd_sc_mcu7t5v0__filltie
X0_FILLER_13_252 VDD VDD VSS VSS gf180mcu_fd_sc_mcu7t5v0__fill_2
X0_FILLER_13_241 VDD VDD VSS VSS gf180mcu_fd_sc_mcu7t5v0__fill_1
X0_FILLER_10_244 VDD VDD VSS VSS gf180mcu_fd_sc_mcu7t5v0__fill_1
X0__161_ _162_/A1 _169_/A2 _162_/A2 _193_/A4 _161_/ZN VDD VDD VSS VSS gf180mcu_fd_sc_mcu7t5v0__nor4_1
X0__092_ _096_/A1 _096_/A3 _197_/A3 _092_/ZN VDD VDD VSS VSS gf180mcu_fd_sc_mcu7t5v0__nor3_1
X0_input2 dec_in[1] input2/Z VDD VDD VSS VSS gf180mcu_fd_sc_mcu7t5v0__dlyb_1
X0_FILLER_3_207 VDD VDD VSS VSS gf180mcu_fd_sc_mcu7t5v0__fill_2
X0__144_ _046_/I _201_/A3 _084_/Z _209_/A2 VDD VDD VSS VSS gf180mcu_fd_sc_mcu7t5v0__nand3_1
X0_TAP_TAPCELL_ROW_6_68 VDD VSS gf180mcu_fd_sc_mcu7t5v0__filltie
X0__075_ _096_/A1 _086_/A2 _096_/A3 _101_/A4 _075_/ZN VDD VDD VSS VSS gf180mcu_fd_sc_mcu7t5v0__nor4_1
X0_FILLER_12_317 VDD VDD VSS VSS gf180mcu_fd_sc_mcu7t5v0__fillcap_8
X0__127_ _135_/A2 _135_/A3 _127_/A3 _194_/A2 VDD VDD VSS VSS gf180mcu_fd_sc_mcu7t5v0__nand3_1
X0__058_ _102_/A1 _093_/A2 _101_/A2 _057_/Z _181_/A3 VDD VDD VSS VSS gf180mcu_fd_sc_mcu7t5v0__nand4_1
X0_FILLER_16_33 VDD VDD VSS VSS gf180mcu_fd_sc_mcu7t5v0__fill_1
X0_FILLER_4_187 VDD VDD VSS VSS gf180mcu_fd_sc_mcu7t5v0__fillcap_4
X0_FILLER_14_209 VDD VDD VSS VSS gf180mcu_fd_sc_mcu7t5v0__fill_2
X0_TAP_TAPCELL_ROW_0_37 VDD VSS gf180mcu_fd_sc_mcu7t5v0__filltie
X0_FILLER_13_275 VDD VDD VSS VSS gf180mcu_fd_sc_mcu7t5v0__fill_1
X0_TAP_TAPCELL_ROW_9_79 VDD VSS gf180mcu_fd_sc_mcu7t5v0__filltie
X0_FILLER_9_279 VDD VDD VSS VSS gf180mcu_fd_sc_mcu7t5v0__fill_1
X0__091_ _102_/A1 _093_/A2 _104_/A3 _057_/Z _197_/A3 VDD VDD VSS VSS gf180mcu_fd_sc_mcu7t5v0__nand4_1
X0_FILLER_6_2 VDD VDD VSS VSS gf180mcu_fd_sc_mcu7t5v0__fillcap_4
X0__160_ _162_/A1 _169_/A2 _162_/A2 _208_/A4 _160_/ZN VDD VDD VSS VSS gf180mcu_fd_sc_mcu7t5v0__nor4_1
X0_input3 dec_in[2] input3/Z VDD VDD VSS VSS gf180mcu_fd_sc_mcu7t5v0__dlyb_1
X0__143_ _041_/I _143_/A2 _143_/A3 _208_/A4 _143_/ZN VDD VDD VSS VSS gf180mcu_fd_sc_mcu7t5v0__nor4_1
X0_TAP_TAPCELL_ROW_6_69 VDD VSS gf180mcu_fd_sc_mcu7t5v0__filltie
X0__074_ _082_/A1 _043_/I _102_/A1 _045_/I _101_/A4 VDD VDD VSS VSS gf180mcu_fd_sc_mcu7t5v0__nand4_1
X0_FILLER_12_329 VDD VDD VSS VSS gf180mcu_fd_sc_mcu7t5v0__fill_2
X0__057_ _042_/I _043_/I _057_/Z VDD VDD VSS VSS gf180mcu_fd_sc_mcu7t5v0__and2_1
X0__126_ _139_/A1 _135_/A2 _133_/A3 _193_/A4 _126_/ZN VDD VDD VSS VSS gf180mcu_fd_sc_mcu7t5v0__nor4_1
X0_PHY_EDGE_ROW_0_Right_0 VDD VSS gf180mcu_fd_sc_mcu7t5v0__endcap
X0__109_ _041_/I _047_/I _177_/A3 _109_/ZN VDD VDD VSS VSS gf180mcu_fd_sc_mcu7t5v0__nor3_1
X0_FILLER_16_240 VDD VDD VSS VSS gf180mcu_fd_sc_mcu7t5v0__fillcap_32
X0_FILLER_4_37 VDD VDD VSS VSS gf180mcu_fd_sc_mcu7t5v0__fillcap_4
X0_TAP_TAPCELL_ROW_0_38 VDD VSS gf180mcu_fd_sc_mcu7t5v0__filltie
X0_FILLER_13_254 VDD VDD VSS VSS gf180mcu_fd_sc_mcu7t5v0__fill_1
X0__090_ _096_/A1 _101_/A2 _096_/A3 _090_/A4 _090_/ZN VDD VDD VSS VSS gf180mcu_fd_sc_mcu7t5v0__nor4_1
X0_input4 dec_in[3] input4/Z VDD VDD VSS VSS gf180mcu_fd_sc_mcu7t5v0__dlyb_1
X0_FILLER_15_305 VDD VDD VSS VSS gf180mcu_fd_sc_mcu7t5v0__fillcap_16
X0_FILLER_3_209 VDD VDD VSS VSS gf180mcu_fd_sc_mcu7t5v0__fill_1
X0__142_ _041_/I _143_/A2 _143_/A3 _207_/A4 _142_/ZN VDD VDD VSS VSS gf180mcu_fd_sc_mcu7t5v0__nor4_1
X0__073_ _089_/A1 _086_/A2 _089_/A3 _073_/A4 _073_/ZN VDD VDD VSS VSS gf180mcu_fd_sc_mcu7t5v0__nor4_1
X0_FILLER_11_330 VDD VDD VSS VSS gf180mcu_fd_sc_mcu7t5v0__fill_1
X0_TAP_TAPCELL_ROW_11_90 VDD VSS gf180mcu_fd_sc_mcu7t5v0__filltie
X0__125_ _139_/A1 _135_/A2 _133_/A3 _208_/A4 _125_/ZN VDD VDD VSS VSS gf180mcu_fd_sc_mcu7t5v0__nor4_1
X0__056_ _089_/A1 _086_/A2 _089_/A3 _090_/A4 _056_/ZN VDD VDD VSS VSS gf180mcu_fd_sc_mcu7t5v0__nor4_1
X0_FILLER_12_149 VDD VDD VSS VSS gf180mcu_fd_sc_mcu7t5v0__fillcap_4
X0__108_ _159_/A2 _084_/Z _177_/A3 VDD VDD VSS VSS gf180mcu_fd_sc_mcu7t5v0__nand2_1
X0_FILLER_14_2 VDD VDD VSS VSS gf180mcu_fd_sc_mcu7t5v0__fillcap_16
X0_TAP_TAPCELL_ROW_13_100 VDD VSS gf180mcu_fd_sc_mcu7t5v0__filltie
X0_FILLER_7_175 VDD VDD VSS VSS gf180mcu_fd_sc_mcu7t5v0__fill_2
X0_TAP_TAPCELL_ROW_0_39 VDD VSS gf180mcu_fd_sc_mcu7t5v0__filltie
X0_input5 dec_in[4] input5/Z VDD VDD VSS VSS gf180mcu_fd_sc_mcu7t5v0__dlyb_1
X0_FILLER_10_37 VDD VDD VSS VSS gf180mcu_fd_sc_mcu7t5v0__fill_2
X0__072_ _042_/I _080_/A2 _102_/A1 _045_/I _073_/A4 VDD VDD VSS VSS gf180mcu_fd_sc_mcu7t5v0__nand4_1
X0__141_ _041_/I _143_/A3 _206_/A3 _141_/ZN VDD VDD VSS VSS gf180mcu_fd_sc_mcu7t5v0__nor3_1
X0__124_ _134_/A1 _124_/A2 _129_/A3 _207_/A4 _124_/ZN VDD VDD VSS VSS gf180mcu_fd_sc_mcu7t5v0__nor4_1
X0_TAP_TAPCELL_ROW_11_91 VDD VSS gf180mcu_fd_sc_mcu7t5v0__filltie
X0__055_ _082_/A1 _043_/I _102_/A1 _093_/A2 _090_/A4 VDD VDD VSS VSS gf180mcu_fd_sc_mcu7t5v0__nand4_1
X0_PHY_EDGE_ROW_6_Left_23 VDD VSS gf180mcu_fd_sc_mcu7t5v0__endcap
X0_TAP_TAPCELL_ROW_7_70 VDD VSS gf180mcu_fd_sc_mcu7t5v0__filltie
X0_FILLER_16_36 VDD VDD VSS VSS gf180mcu_fd_sc_mcu7t5v0__fillcap_16
X0_FILLER_16_14 VDD VDD VSS VSS gf180mcu_fd_sc_mcu7t5v0__fill_2
X0_FILLER_4_327 VDD VDD VSS VSS gf180mcu_fd_sc_mcu7t5v0__fillcap_4
X0__107_ _139_/A1 _138_/A2 _107_/A3 _208_/A4 _107_/ZN VDD VDD VSS VSS gf180mcu_fd_sc_mcu7t5v0__nor4_1
X0_FILLER_0_330 VDD VDD VSS VSS gf180mcu_fd_sc_mcu7t5v0__fill_1
X0_TAP_TAPCELL_ROW_4_60 VDD VSS gf180mcu_fd_sc_mcu7t5v0__filltie
X0_FILLER_13_212 VDD VDD VSS VSS gf180mcu_fd_sc_mcu7t5v0__fill_1
X0_FILLER_13_26 VDD VDD VSS VSS gf180mcu_fd_sc_mcu7t5v0__fill_2
X0_input6 dec_in[5] input6/Z VDD VDD VSS VSS gf180mcu_fd_sc_mcu7t5v0__dlyb_1
X0_FILLER_15_329 VDD VDD VSS VSS gf180mcu_fd_sc_mcu7t5v0__fill_2
X0_PHY_EDGE_ROW_14_Right_14 VDD VSS gf180mcu_fd_sc_mcu7t5v0__endcap
X0__140_ _041_/I _143_/A3 _205_/A3 _140_/ZN VDD VDD VSS VSS gf180mcu_fd_sc_mcu7t5v0__nor3_1
X0__071_ _041_/I _159_/A2 _164_/A3 _154_/A4 _071_/ZN VDD VDD VSS VSS gf180mcu_fd_sc_mcu7t5v0__nor4_1
X0_FILLER_4_2 VDD VDD VSS VSS gf180mcu_fd_sc_mcu7t5v0__fill_1
X0_TAP_TAPCELL_ROW_16_110 VDD VSS gf180mcu_fd_sc_mcu7t5v0__filltie
X0__123_ _134_/A1 _129_/A3 _190_/A3 _123_/ZN VDD VDD VSS VSS gf180mcu_fd_sc_mcu7t5v0__nor3_1
X0_TAP_TAPCELL_ROW_7_71 VDD VSS gf180mcu_fd_sc_mcu7t5v0__filltie
X0__054_ _089_/A1 _086_/A2 _089_/A3 _089_/A4 _054_/ZN VDD VDD VSS VSS gf180mcu_fd_sc_mcu7t5v0__nor4_1
X0__106_ _122_/A1 _138_/A2 _107_/A3 _106_/A4 _106_/ZN VDD VDD VSS VSS gf180mcu_fd_sc_mcu7t5v0__nor4_1
X0_FILLER_7_177 VDD VDD VSS VSS gf180mcu_fd_sc_mcu7t5v0__fill_1
X0_PHY_EDGE_ROW_4_Right_4 VDD VSS gf180mcu_fd_sc_mcu7t5v0__endcap
X0_FILLER_0_172 VDD VDD VSS VSS gf180mcu_fd_sc_mcu7t5v0__fillcap_4
X0_FILLER_9_228 VDD VDD VSS VSS gf180mcu_fd_sc_mcu7t5v0__fillcap_4
X0_FILLER_6_6 VDD VDD VSS VSS gf180mcu_fd_sc_mcu7t5v0__fill_2
X0_input7 dec_in[6] input7/Z VDD VDD VSS VSS gf180mcu_fd_sc_mcu7t5v0__dlyb_1
X0_FILLER_10_39 VDD VDD VSS VSS gf180mcu_fd_sc_mcu7t5v0__fill_1
X0__070_ _136_/A1 _136_/A4 _154_/A4 VDD VDD VSS VSS gf180mcu_fd_sc_mcu7t5v0__nand2_1
X0__199_ _207_/A1 _207_/A2 _207_/A3 _199_/A4 _199_/ZN VDD VDD VSS VSS gf180mcu_fd_sc_mcu7t5v0__nor4_1
X0_output130 _177_/ZN dec_out[95] VDD VDD VSS VSS gf180mcu_fd_sc_mcu7t5v0__dlyb_1
X0_TAP_TAPCELL_ROW_16_111 VDD VSS gf180mcu_fd_sc_mcu7t5v0__filltie
X0_FILLER_15_138 VDD VDD VSS VSS gf180mcu_fd_sc_mcu7t5v0__fill_2
X0__122_ _122_/A1 _129_/A3 _189_/A3 _122_/ZN VDD VDD VSS VSS gf180mcu_fd_sc_mcu7t5v0__nor3_1
X0__053_ _042_/I _080_/A2 _102_/A1 _093_/A2 _089_/A4 VDD VDD VSS VSS gf180mcu_fd_sc_mcu7t5v0__nand4_1
X0_TAP_TAPCELL_ROW_7_72 VDD VSS gf180mcu_fd_sc_mcu7t5v0__filltie
X0_FILLER_16_16 VDD VDD VSS VSS gf180mcu_fd_sc_mcu7t5v0__fill_1
X0__105_ _122_/A1 _107_/A3 _206_/A3 _105_/ZN VDD VDD VSS VSS gf180mcu_fd_sc_mcu7t5v0__nor3_1
X0_FILLER_16_233 VDD VDD VSS VSS gf180mcu_fd_sc_mcu7t5v0__fillcap_4
X0_FILLER_12_2 VDD VDD VSS VSS gf180mcu_fd_sc_mcu7t5v0__fillcap_8
X0_FILLER_5_51 VDD VDD VSS VSS gf180mcu_fd_sc_mcu7t5v0__fill_2
X0__198_ _207_/A1 _198_/A2 _198_/A3 _198_/ZN VDD VDD VSS VSS gf180mcu_fd_sc_mcu7t5v0__nor3_1
X0_output131 _178_/ZN dec_out[96] VDD VDD VSS VSS gf180mcu_fd_sc_mcu7t5v0__dlyb_1
X0_output120 _168_/ZN dec_out[86] VDD VDD VSS VSS gf180mcu_fd_sc_mcu7t5v0__dlyb_1
X0_FILLER_11_94 VDD VDD VSS VSS gf180mcu_fd_sc_mcu7t5v0__fillcap_4
X0__052_ _089_/A1 _086_/A2 _089_/A3 _178_/A4 _052_/ZN VDD VDD VSS VSS gf180mcu_fd_sc_mcu7t5v0__nor4_1
X0__121_ _134_/A1 _124_/A2 _133_/A3 _204_/A4 _121_/ZN VDD VDD VSS VSS gf180mcu_fd_sc_mcu7t5v0__nor4_1
X0_TAP_TAPCELL_ROW_16_112 VDD VSS gf180mcu_fd_sc_mcu7t5v0__filltie
X0_TAP_TAPCELL_ROW_7_73 VDD VSS gf180mcu_fd_sc_mcu7t5v0__filltie
X0__104_ input3/Z _045_/I _104_/A3 _104_/A4 _206_/A3 VDD VDD VSS VSS gf180mcu_fd_sc_mcu7t5v0__nand4_1
X0_FILLER_3_330 VDD VDD VSS VSS gf180mcu_fd_sc_mcu7t5v0__fill_1
X0_max_cap141 _096_/A4 _200_/A4 VDD VDD VSS VSS gf180mcu_fd_sc_mcu7t5v0__buf_2
X0_FILLER_13_18 VDD VDD VSS VSS gf180mcu_fd_sc_mcu7t5v0__fillcap_8
X0_FILLER_13_237 VDD VDD VSS VSS gf180mcu_fd_sc_mcu7t5v0__fillcap_4
X0_FILLER_5_96 VDD VDD VSS VSS gf180mcu_fd_sc_mcu7t5v0__fill_2
X0_FILLER_8_285 VDD VDD VSS VSS gf180mcu_fd_sc_mcu7t5v0__fill_1
X0_FILLER_6_8 VDD VDD VSS VSS gf180mcu_fd_sc_mcu7t5v0__fill_1
X0_FILLER_14_94 VDD VDD VSS VSS gf180mcu_fd_sc_mcu7t5v0__fill_1
X0__197_ _197_/A1 _198_/A2 _197_/A3 _197_/ZN VDD VDD VSS VSS gf180mcu_fd_sc_mcu7t5v0__nor3_1
X0_PHY_EDGE_ROW_10_Right_10 VDD VSS gf180mcu_fd_sc_mcu7t5v0__endcap
X0_output110 _159_/ZN dec_out[77] VDD VDD VSS VSS gf180mcu_fd_sc_mcu7t5v0__dlyb_1
X0_output132 _179_/ZN dec_out[97] VDD VDD VSS VSS gf180mcu_fd_sc_mcu7t5v0__dlyb_1
X0_output121 _169_/Z dec_out[87] VDD VDD VSS VSS gf180mcu_fd_sc_mcu7t5v0__dlyb_1
X0__120_ _122_/A1 _124_/A2 _129_/A3 _203_/A4 _120_/ZN VDD VDD VSS VSS gf180mcu_fd_sc_mcu7t5v0__nor4_1
X0__051_ _093_/A2 _051_/A2 _178_/A4 VDD VDD VSS VSS gf180mcu_fd_sc_mcu7t5v0__nand2_1
X0_FILLER_2_2 VDD VDD VSS VSS gf180mcu_fd_sc_mcu7t5v0__fill_1
X0_TAP_TAPCELL_ROW_16_113 VDD VSS gf180mcu_fd_sc_mcu7t5v0__filltie
X0_PHY_EDGE_ROW_10_Left_27 VDD VSS gf180mcu_fd_sc_mcu7t5v0__endcap
X0__103_ _103_/A1 _107_/A3 _205_/A3 _103_/ZN VDD VDD VSS VSS gf180mcu_fd_sc_mcu7t5v0__nor3_1
X0_PHY_EDGE_ROW_8_Right_8 VDD VSS gf180mcu_fd_sc_mcu7t5v0__endcap
X0_max_cap142 _095_/A4 _199_/A4 VDD VDD VSS VSS gf180mcu_fd_sc_mcu7t5v0__buf_2
X0_PHY_EDGE_ROW_13_Left_30 VDD VSS gf180mcu_fd_sc_mcu7t5v0__endcap
X0_FILLER_5_53 VDD VDD VSS VSS gf180mcu_fd_sc_mcu7t5v0__fill_1
X0_TAP_TAPCELL_ROW_1_43 VDD VSS gf180mcu_fd_sc_mcu7t5v0__filltie
X0__196_ _197_/A1 _207_/A2 _198_/A2 _196_/A4 _196_/ZN VDD VDD VSS VSS gf180mcu_fd_sc_mcu7t5v0__nor4_1
X0__050_ _042_/I _043_/I _044_/I _136_/A1 _127_/A3 VDD VDD VSS VSS gf180mcu_fd_sc_mcu7t5v0__nor4_1
X0_output122 _170_/ZN dec_out[88] VDD VDD VSS VSS gf180mcu_fd_sc_mcu7t5v0__dlyb_1
X0_output111 _160_/ZN dec_out[78] VDD VDD VSS VSS gf180mcu_fd_sc_mcu7t5v0__dlyb_1
X0_output100 _150_/ZN dec_out[68] VDD VDD VSS VSS gf180mcu_fd_sc_mcu7t5v0__dlyb_1
X0_output133 _180_/ZN dec_out[98] VDD VDD VSS VSS gf180mcu_fd_sc_mcu7t5v0__dlyb_1
X0_TAP_TAPCELL_ROW_16_114 VDD VSS gf180mcu_fd_sc_mcu7t5v0__filltie
X0__179_ _182_/A1 _046_/I _182_/A2 _195_/A4 _179_/ZN VDD VDD VSS VSS gf180mcu_fd_sc_mcu7t5v0__nor4_1
X0_fanout190 input5/Z _201_/A2 VDD VDD VSS VSS gf180mcu_fd_sc_mcu7t5v0__dlyb_1
X0__102_ _102_/A1 _045_/I _104_/A3 _057_/Z _205_/A3 VDD VDD VSS VSS gf180mcu_fd_sc_mcu7t5v0__nand4_1
X0_FILLER_7_148 VDD VDD VSS VSS gf180mcu_fd_sc_mcu7t5v0__fill_1
X0_FILLER_16_214 VDD VDD VSS VSS gf180mcu_fd_sc_mcu7t5v0__fill_2
X0_FILLER_0_324 VDD VDD VSS VSS gf180mcu_fd_sc_mcu7t5v0__fillcap_4
X0_FILLER_4_107 VDD VDD VSS VSS gf180mcu_fd_sc_mcu7t5v0__fillcap_4
X0_max_cap143 _090_/A4 _196_/A4 VDD VDD VSS VSS gf180mcu_fd_sc_mcu7t5v0__buf_2
X0_FILLER_13_228 VDD VDD VSS VSS gf180mcu_fd_sc_mcu7t5v0__fill_1
X0_FILLER_0_176 VDD VDD VSS VSS gf180mcu_fd_sc_mcu7t5v0__fill_2
X0_FILLER_10_2 VDD VDD VSS VSS gf180mcu_fd_sc_mcu7t5v0__fill_1
X0_FILLER_14_41 VDD VDD VSS VSS gf180mcu_fd_sc_mcu7t5v0__fill_2
X0_TAP_TAPCELL_ROW_1_44 VDD VSS gf180mcu_fd_sc_mcu7t5v0__filltie
X0__195_ _197_/A1 _207_/A2 _198_/A2 _195_/A4 _195_/ZN VDD VDD VSS VSS gf180mcu_fd_sc_mcu7t5v0__nor4_1
X0_output112 _161_/ZN dec_out[79] VDD VDD VSS VSS gf180mcu_fd_sc_mcu7t5v0__dlyb_1
X0_output123 _171_/ZN dec_out[89] VDD VDD VSS VSS gf180mcu_fd_sc_mcu7t5v0__dlyb_1
X0_output101 _151_/ZN dec_out[69] VDD VDD VSS VSS gf180mcu_fd_sc_mcu7t5v0__dlyb_1
X0_output134 _181_/ZN dec_out[99] VDD VDD VSS VSS gf180mcu_fd_sc_mcu7t5v0__dlyb_1
X0_TAP_TAPCELL_ROW_16_115 VDD VSS gf180mcu_fd_sc_mcu7t5v0__filltie
X0_FILLER_14_153 VDD VDD VSS VSS gf180mcu_fd_sc_mcu7t5v0__fill_2
X0__178_ _182_/A1 _046_/I _182_/A2 _178_/A4 _178_/ZN VDD VDD VSS VSS gf180mcu_fd_sc_mcu7t5v0__nor4_1
X0__101_ _103_/A1 _101_/A2 _107_/A3 _101_/A4 _101_/ZN VDD VDD VSS VSS gf180mcu_fd_sc_mcu7t5v0__nor4_1
X0_fanout180 _162_/A2 _201_/A3 VDD VDD VSS VSS gf180mcu_fd_sc_mcu7t5v0__dlyb_1
X0_fanout191 input4/Z _045_/I VDD VDD VSS VSS gf180mcu_fd_sc_mcu7t5v0__dlyb_1
X0_FILLER_16_237 VDD VDD VSS VSS gf180mcu_fd_sc_mcu7t5v0__fill_1
X0_max_cap144 _089_/A4 _195_/A4 VDD VDD VSS VSS gf180mcu_fd_sc_mcu7t5v0__buf_2
X0_TAP_TAPCELL_ROW_1_45 VDD VSS gf180mcu_fd_sc_mcu7t5v0__filltie
X0__194_ _209_/A1 _194_/A2 _194_/ZN VDD VDD VSS VSS gf180mcu_fd_sc_mcu7t5v0__nor2_1
X0_output124 wire136/Z dec_out[8] VDD VDD VSS VSS gf180mcu_fd_sc_mcu7t5v0__dlyb_1
X0_output135 _073_/ZN dec_out[9] VDD VDD VSS VSS gf180mcu_fd_sc_mcu7t5v0__dlyb_1
X0_output113 _069_/ZN dec_out[7] VDD VDD VSS VSS gf180mcu_fd_sc_mcu7t5v0__dlyb_1
X0_output102 _065_/ZN dec_out[6] VDD VDD VSS VSS gf180mcu_fd_sc_mcu7t5v0__dlyb_1
X0_TAP_TAPCELL_ROW_16_116 VDD VSS gf180mcu_fd_sc_mcu7t5v0__filltie
X0_FILLER_11_10 VDD VDD VSS VSS gf180mcu_fd_sc_mcu7t5v0__fill_1
X0__177_ _182_/A1 _201_/A3 _177_/A3 _177_/ZN VDD VDD VSS VSS gf180mcu_fd_sc_mcu7t5v0__nor3_1
X0__100_ _103_/A1 _101_/A2 _107_/A3 _203_/A4 _100_/ZN VDD VDD VSS VSS gf180mcu_fd_sc_mcu7t5v0__nor4_1
X0_fanout192 input4/Z _136_/A1 VDD VDD VSS VSS gf180mcu_fd_sc_mcu7t5v0__dlyb_1
X0_fanout181 _135_/A3 _162_/A2 VDD VDD VSS VSS gf180mcu_fd_sc_mcu7t5v0__dlyb_1
X0_fanout170 _139_/A1 _134_/A1 VDD VDD VSS VSS gf180mcu_fd_sc_mcu7t5v0__dlyb_1
X0_FILLER_16_216 VDD VDD VSS VSS gf180mcu_fd_sc_mcu7t5v0__fill_1
X0_FILLER_3_142 VDD VDD VSS VSS gf180mcu_fd_sc_mcu7t5v0__fill_1
X0_TAP_TAPCELL_ROW_4_56 VDD VSS gf180mcu_fd_sc_mcu7t5v0__filltie
X0_FILLER_15_282 VDD VDD VSS VSS gf180mcu_fd_sc_mcu7t5v0__fill_1
X0_max_cap145 _051_/A2 _136_/A4 VDD VDD VSS VSS gf180mcu_fd_sc_mcu7t5v0__buf_1
X0_FILLER_0_178 VDD VDD VSS VSS gf180mcu_fd_sc_mcu7t5v0__fill_1
X0_FILLER_12_230 VDD VDD VSS VSS gf180mcu_fd_sc_mcu7t5v0__fillcap_4
X0_FILLER_8_201 VDD VDD VSS VSS gf180mcu_fd_sc_mcu7t5v0__fillcap_4
X0_FILLER_14_43 VDD VDD VSS VSS gf180mcu_fd_sc_mcu7t5v0__fill_1
X0_TAP_TAPCELL_ROW_1_46 VDD VSS gf180mcu_fd_sc_mcu7t5v0__filltie
X0_PHY_EDGE_ROW_2_Left_19 VDD VSS gf180mcu_fd_sc_mcu7t5v0__endcap
X0_FILLER_14_325 VDD VDD VSS VSS gf180mcu_fd_sc_mcu7t5v0__fillcap_4
X0__193_ _209_/A1 _201_/A2 _208_/A3 _193_/A4 _193_/ZN VDD VDD VSS VSS gf180mcu_fd_sc_mcu7t5v0__nor4_1
X0_output103 _152_/ZN dec_out[70] VDD VDD VSS VSS gf180mcu_fd_sc_mcu7t5v0__dlyb_1
X0_output114 _162_/ZN dec_out[80] VDD VDD VSS VSS gf180mcu_fd_sc_mcu7t5v0__dlyb_1
X0_output125 _172_/ZN dec_out[90] VDD VDD VSS VSS gf180mcu_fd_sc_mcu7t5v0__dlyb_1
X0_TAP_TAPCELL_ROW_11_88 VDD VSS gf180mcu_fd_sc_mcu7t5v0__filltie
X0_TAP_TAPCELL_ROW_16_117 VDD VSS gf180mcu_fd_sc_mcu7t5v0__filltie
X0_FILLER_14_177 VDD VDD VSS VSS gf180mcu_fd_sc_mcu7t5v0__fillcap_32
X0__176_ _182_/A1 _207_/A2 _201_/A3 _208_/A4 _176_/ZN VDD VDD VSS VSS gf180mcu_fd_sc_mcu7t5v0__nor4_1
X0_fanout193 input3/Z _044_/I VDD VDD VSS VSS gf180mcu_fd_sc_mcu7t5v0__dlyb_1
X0_fanout182 input6/Z _135_/A3 VDD VDD VSS VSS gf180mcu_fd_sc_mcu7t5v0__dlyb_1
X0_fanout160 _186_/A1 _135_/A1 VDD VDD VSS VSS gf180mcu_fd_sc_mcu7t5v0__dlyb_1
X0_FILLER_11_158 VDD VDD VSS VSS gf180mcu_fd_sc_mcu7t5v0__fill_2
X0_fanout171 _201_/A1 _139_/A1 VDD VDD VSS VSS gf180mcu_fd_sc_mcu7t5v0__dlyb_1
X0_PHY_EDGE_ROW_5_Left_22 VDD VSS gf180mcu_fd_sc_mcu7t5v0__endcap
X0_FILLER_6_173 VDD VDD VSS VSS gf180mcu_fd_sc_mcu7t5v0__fill_2
X0__159_ _159_/A1 _159_/A2 _164_/A3 _207_/A4 _159_/ZN VDD VDD VSS VSS gf180mcu_fd_sc_mcu7t5v0__nor4_1
X0_FILLER_16_206 VDD VDD VSS VSS gf180mcu_fd_sc_mcu7t5v0__fillcap_8
X0_TAP_TAPCELL_ROW_4_57 VDD VSS gf180mcu_fd_sc_mcu7t5v0__filltie
X0__192_ _209_/A1 _201_/A2 _208_/A3 _208_/A4 _192_/ZN VDD VDD VSS VSS gf180mcu_fd_sc_mcu7t5v0__nor4_1
X0_output126 _173_/ZN dec_out[91] VDD VDD VSS VSS gf180mcu_fd_sc_mcu7t5v0__dlyb_1
X0_output104 _153_/ZN dec_out[71] VDD VDD VSS VSS gf180mcu_fd_sc_mcu7t5v0__dlyb_1
X0_output115 _163_/ZN dec_out[81] VDD VDD VSS VSS gf180mcu_fd_sc_mcu7t5v0__dlyb_1
X0_TAP_TAPCELL_ROW_11_89 VDD VSS gf180mcu_fd_sc_mcu7t5v0__filltie
X0_TAP_TAPCELL_ROW_16_118 VDD VSS gf180mcu_fd_sc_mcu7t5v0__filltie
X0_FILLER_14_167 VDD VDD VSS VSS gf180mcu_fd_sc_mcu7t5v0__fillcap_8
X0__175_ _175_/A1 _207_/A2 _047_/I _207_/A4 _175_/ZN VDD VDD VSS VSS gf180mcu_fd_sc_mcu7t5v0__nor4_1
X0_fanout194 input2/Z _043_/I VDD VDD VSS VSS gf180mcu_fd_sc_mcu7t5v0__dlyb_1
X0_fanout172 _201_/A1 _041_/I VDD VDD VSS VSS gf180mcu_fd_sc_mcu7t5v0__dlyb_1
X0_fanout183 _104_/A3 _086_/A2 VDD VDD VSS VSS gf180mcu_fd_sc_mcu7t5v0__dlyb_1
X0_fanout150 _208_/A3 _207_/A3 VDD VDD VSS VSS gf180mcu_fd_sc_mcu7t5v0__dlyb_1
X0_fanout161 _182_/A1 _175_/A1 VDD VDD VSS VSS gf180mcu_fd_sc_mcu7t5v0__dlyb_1
X0__158_ _159_/A1 _158_/A2 _190_/A3 _158_/ZN VDD VDD VSS VSS gf180mcu_fd_sc_mcu7t5v0__nor3_1
X0__089_ _089_/A1 _101_/A2 _089_/A3 _089_/A4 _089_/ZN VDD VDD VSS VSS gf180mcu_fd_sc_mcu7t5v0__nor4_1
X0_FILLER_0_328 VDD VDD VSS VSS gf180mcu_fd_sc_mcu7t5v0__fill_2
X0_TAP_TAPCELL_ROW_4_58 VDD VSS gf180mcu_fd_sc_mcu7t5v0__filltie
X0_PHY_EDGE_ROW_3_Right_3 VDD VSS gf180mcu_fd_sc_mcu7t5v0__endcap
X0_FILLER_5_228 VDD VDD VSS VSS gf180mcu_fd_sc_mcu7t5v0__fillcap_4
X0_FILLER_2_37 VDD VDD VSS VSS gf180mcu_fd_sc_mcu7t5v0__fillcap_4
X0__191_ _197_/A1 _046_/I _198_/A2 _207_/A4 _191_/ZN VDD VDD VSS VSS gf180mcu_fd_sc_mcu7t5v0__nor4_1
X0_output116 _164_/ZN dec_out[82] VDD VDD VSS VSS gf180mcu_fd_sc_mcu7t5v0__dlyb_1
X0_output105 _154_/ZN dec_out[72] VDD VDD VSS VSS gf180mcu_fd_sc_mcu7t5v0__dlyb_1
X0_output127 _174_/ZN dec_out[92] VDD VDD VSS VSS gf180mcu_fd_sc_mcu7t5v0__dlyb_1
X0__174_ _175_/A1 _047_/I _206_/A3 _174_/ZN VDD VDD VSS VSS gf180mcu_fd_sc_mcu7t5v0__nor3_1
X0_fanout184 _104_/A3 _124_/A2 VDD VDD VSS VSS gf180mcu_fd_sc_mcu7t5v0__dlyb_1
X0_fanout151 _182_/A2 _208_/A3 VDD VDD VSS VSS gf180mcu_fd_sc_mcu7t5v0__dlyb_1
X0_FILLER_3_326 VDD VDD VSS VSS gf180mcu_fd_sc_mcu7t5v0__fillcap_4
X0_fanout162 _186_/A1 _182_/A1 VDD VDD VSS VSS gf180mcu_fd_sc_mcu7t5v0__dlyb_1
X0_fanout195 input1/Z _042_/I VDD VDD VSS VSS gf180mcu_fd_sc_mcu7t5v0__dlyb_1
X0_fanout173 input7/Z _201_/A1 VDD VDD VSS VSS gf180mcu_fd_sc_mcu7t5v0__dlyb_1
X0__088_ _103_/A1 _107_/A3 _162_/A3 _088_/ZN VDD VDD VSS VSS gf180mcu_fd_sc_mcu7t5v0__nor3_1
X0__157_ _159_/A1 _158_/A2 _189_/A3 _157_/ZN VDD VDD VSS VSS gf180mcu_fd_sc_mcu7t5v0__nor3_1
X0_FILLER_6_197 VDD VDD VSS VSS gf180mcu_fd_sc_mcu7t5v0__fill_2
X0_TAP_TAPCELL_ROW_4_59 VDD VSS gf180mcu_fd_sc_mcu7t5v0__filltie
X0__209_ _209_/A1 _209_/A2 _209_/ZN VDD VDD VSS VSS gf180mcu_fd_sc_mcu7t5v0__nor2_1
X0_PHY_EDGE_ROW_13_Right_13 VDD VSS gf180mcu_fd_sc_mcu7t5v0__endcap
X0_FILLER_14_317 VDD VDD VSS VSS gf180mcu_fd_sc_mcu7t5v0__fillcap_8
X0_FILLER_1_276 VDD VDD VSS VSS gf180mcu_fd_sc_mcu7t5v0__fillcap_4
X0_FILLER_9_2 VDD VDD VSS VSS gf180mcu_fd_sc_mcu7t5v0__fill_2
X0__190_ _197_/A1 _198_/A2 _190_/A3 _190_/ZN VDD VDD VSS VSS gf180mcu_fd_sc_mcu7t5v0__nor3_1
X0_output128 _175_/ZN dec_out[93] VDD VDD VSS VSS gf180mcu_fd_sc_mcu7t5v0__dlyb_1
X0_output117 _165_/ZN dec_out[83] VDD VDD VSS VSS gf180mcu_fd_sc_mcu7t5v0__dlyb_1
X0_output106 _155_/ZN dec_out[73] VDD VDD VSS VSS gf180mcu_fd_sc_mcu7t5v0__dlyb_1
X0__173_ _175_/A1 _047_/I _205_/A3 _173_/ZN VDD VDD VSS VSS gf180mcu_fd_sc_mcu7t5v0__nor3_1
X0_FILLER_9_184 VDD VDD VSS VSS gf180mcu_fd_sc_mcu7t5v0__fillcap_4
X0_fanout185 _104_/A3 _135_/A2 VDD VDD VSS VSS gf180mcu_fd_sc_mcu7t5v0__dlyb_1
X0_fanout163 _209_/A1 _197_/A1 VDD VDD VSS VSS gf180mcu_fd_sc_mcu7t5v0__dlyb_1
X0_fanout174 _096_/A3 _089_/A3 VDD VDD VSS VSS gf180mcu_fd_sc_mcu7t5v0__dlyb_1
X0_FILLER_6_132 VDD VDD VSS VSS gf180mcu_fd_sc_mcu7t5v0__fill_2
X0__156_ _162_/A1 _159_/A2 _158_/A2 _204_/A4 _156_/ZN VDD VDD VSS VSS gf180mcu_fd_sc_mcu7t5v0__nor4_1
X0__087_ _124_/A2 _127_/A3 _162_/A3 VDD VDD VSS VSS gf180mcu_fd_sc_mcu7t5v0__nand2_1
X0_fanout152 _047_/ZN _182_/A2 VDD VDD VSS VSS gf180mcu_fd_sc_mcu7t5v0__dlyb_1
X0_PHY_EDGE_ROW_9_Left_26 VDD VSS gf180mcu_fd_sc_mcu7t5v0__endcap
X0_max_cap138 _106_/A4 _207_/A4 VDD VDD VSS VSS gf180mcu_fd_sc_mcu7t5v0__buf_2
X0__139_ _139_/A1 _143_/A2 _143_/A3 _204_/A4 _139_/ZN VDD VDD VSS VSS gf180mcu_fd_sc_mcu7t5v0__nor4_1
X0__208_ _209_/A1 _208_/A2 _208_/A3 _208_/A4 _208_/ZN VDD VDD VSS VSS gf180mcu_fd_sc_mcu7t5v0__nor4_1
X0_FILLER_12_234 VDD VDD VSS VSS gf180mcu_fd_sc_mcu7t5v0__fill_1
X0_FILLER_8_205 VDD VDD VSS VSS gf180mcu_fd_sc_mcu7t5v0__fill_2
X0_FILLER_7_282 VDD VDD VSS VSS gf180mcu_fd_sc_mcu7t5v0__fill_1
X0_FILLER_14_329 VDD VDD VSS VSS gf180mcu_fd_sc_mcu7t5v0__fill_2
X0_output118 _166_/ZN dec_out[84] VDD VDD VSS VSS gf180mcu_fd_sc_mcu7t5v0__dlyb_1
X0_output107 _156_/ZN dec_out[74] VDD VDD VSS VSS gf180mcu_fd_sc_mcu7t5v0__dlyb_1
X0_output129 _176_/ZN dec_out[94] VDD VDD VSS VSS gf180mcu_fd_sc_mcu7t5v0__dlyb_1
X0__172_ _182_/A1 _208_/A2 _201_/A3 _204_/A4 _172_/ZN VDD VDD VSS VSS gf180mcu_fd_sc_mcu7t5v0__nor4_1
X0_fanout186 input5/Z _104_/A3 VDD VDD VSS VSS gf180mcu_fd_sc_mcu7t5v0__dlyb_1
X0__086_ _103_/A1 _086_/A2 _107_/A3 _193_/A4 _086_/ZN VDD VDD VSS VSS gf180mcu_fd_sc_mcu7t5v0__nor4_1
X0_FILLER_10_173 VDD VDD VSS VSS gf180mcu_fd_sc_mcu7t5v0__fill_2
X0_fanout175 _107_/A3 _096_/A3 VDD VDD VSS VSS gf180mcu_fd_sc_mcu7t5v0__dlyb_1
X0_fanout164 _209_/A1 _207_/A1 VDD VDD VSS VSS gf180mcu_fd_sc_mcu7t5v0__dlyb_1
X0__155_ _159_/A1 _159_/A2 _158_/A2 _203_/A4 _155_/ZN VDD VDD VSS VSS gf180mcu_fd_sc_mcu7t5v0__nor4_1
X0_fanout153 _138_/A2 _101_/A2 VDD VDD VSS VSS gf180mcu_fd_sc_mcu7t5v0__dlyb_1
X0_max_cap139 _101_/A4 _204_/A4 VDD VDD VSS VSS gf180mcu_fd_sc_mcu7t5v0__buf_2
X0__069_ _103_/A1 _068_/Z _069_/ZN VDD VDD VSS VSS gf180mcu_fd_sc_mcu7t5v0__nor2_1
X0_FILLER_15_276 VDD VDD VSS VSS gf180mcu_fd_sc_mcu7t5v0__fillcap_4
X0__207_ _207_/A1 _207_/A2 _207_/A3 _207_/A4 _207_/ZN VDD VDD VSS VSS gf180mcu_fd_sc_mcu7t5v0__nor4_1
X0__138_ _139_/A1 _138_/A2 _143_/A3 _203_/A4 _138_/ZN VDD VDD VSS VSS gf180mcu_fd_sc_mcu7t5v0__nor4_1
X0_FILLER_14_37 VDD VDD VSS VSS gf180mcu_fd_sc_mcu7t5v0__fillcap_4
X0_FILLER_14_26 VDD VDD VSS VSS gf180mcu_fd_sc_mcu7t5v0__fill_1
X0_FILLER_7_261 VDD VDD VSS VSS gf180mcu_fd_sc_mcu7t5v0__fill_2
X0_PHY_EDGE_ROW_7_Right_7 VDD VSS gf180mcu_fd_sc_mcu7t5v0__endcap
X0_FILLER_9_4 VDD VDD VSS VSS gf180mcu_fd_sc_mcu7t5v0__fill_1
X0_FILLER_13_330 VDD VDD VSS VSS gf180mcu_fd_sc_mcu7t5v0__fill_1
X0_TAP_TAPCELL_ROW_2_50 VDD VSS gf180mcu_fd_sc_mcu7t5v0__filltie
X0_output108 _157_/ZN dec_out[75] VDD VDD VSS VSS gf180mcu_fd_sc_mcu7t5v0__dlyb_1
X0_output90 _140_/ZN dec_out[59] VDD VDD VSS VSS gf180mcu_fd_sc_mcu7t5v0__dlyb_1
X0_output119 _167_/ZN dec_out[85] VDD VDD VSS VSS gf180mcu_fd_sc_mcu7t5v0__dlyb_1
X0_FILLER_11_38 VDD VDD VSS VSS gf180mcu_fd_sc_mcu7t5v0__fillcap_4
X0_FILLER_14_149 VDD VDD VSS VSS gf180mcu_fd_sc_mcu7t5v0__fillcap_4
X0__171_ _175_/A1 _208_/A2 _047_/I _203_/A4 _171_/ZN VDD VDD VSS VSS gf180mcu_fd_sc_mcu7t5v0__nor4_1
X0_FILLER_3_72 VDD VDD VSS VSS gf180mcu_fd_sc_mcu7t5v0__fillcap_4
X0_FILLER_9_153 VDD VDD VSS VSS gf180mcu_fd_sc_mcu7t5v0__fill_2
X0_fanout187 _201_/A2 _159_/A2 VDD VDD VSS VSS gf180mcu_fd_sc_mcu7t5v0__dlyb_1
X0_fanout176 _135_/A3 _107_/A3 VDD VDD VSS VSS gf180mcu_fd_sc_mcu7t5v0__dlyb_1
X0_TAP_TAPCELL_ROW_12_92 VDD VSS gf180mcu_fd_sc_mcu7t5v0__filltie
X0_fanout154 _143_/A2 _138_/A2 VDD VDD VSS VSS gf180mcu_fd_sc_mcu7t5v0__dlyb_1
X0_fanout165 _186_/A1 _209_/A1 VDD VDD VSS VSS gf180mcu_fd_sc_mcu7t5v0__dlyb_1
X0__154_ _162_/A1 _169_/A2 _164_/A3 _154_/A4 _154_/ZN VDD VDD VSS VSS gf180mcu_fd_sc_mcu7t5v0__nor4_1
X0__085_ _044_/I _045_/I _057_/Z _193_/A4 VDD VDD VSS VSS gf180mcu_fd_sc_mcu7t5v0__nand3_1
X0_FILLER_6_134 VDD VDD VSS VSS gf180mcu_fd_sc_mcu7t5v0__fill_1
X0__068_ _136_/A1 _124_/A2 _107_/A3 _068_/A4 _068_/Z VDD VDD VSS VSS gf180mcu_fd_sc_mcu7t5v0__or4_1
X0__206_ _207_/A1 _207_/A3 _206_/A3 _206_/ZN VDD VDD VSS VSS gf180mcu_fd_sc_mcu7t5v0__nor3_1
X0__137_ _041_/I _202_/A2 _137_/ZN VDD VDD VSS VSS gf180mcu_fd_sc_mcu7t5v0__nor2_1
X0_FILLER_8_207 VDD VDD VSS VSS gf180mcu_fd_sc_mcu7t5v0__fill_1
X0_FILLER_8_218 VDD VDD VSS VSS gf180mcu_fd_sc_mcu7t5v0__fill_1
X0_TAP_TAPCELL_ROW_5_61 VDD VSS gf180mcu_fd_sc_mcu7t5v0__filltie
X0_TAP_TAPCELL_ROW_2_51 VDD VSS gf180mcu_fd_sc_mcu7t5v0__filltie
X0_output109 _158_/ZN dec_out[76] VDD VDD VSS VSS gf180mcu_fd_sc_mcu7t5v0__dlyb_1
X0_output91 _063_/ZN dec_out[5] VDD VDD VSS VSS gf180mcu_fd_sc_mcu7t5v0__dlyb_1
X0_output80 _061_/ZN dec_out[4] VDD VDD VSS VSS gf180mcu_fd_sc_mcu7t5v0__dlyb_1
X0__170_ _182_/A1 _201_/A3 _170_/A3 _170_/ZN VDD VDD VSS VSS gf180mcu_fd_sc_mcu7t5v0__nor3_1
X0_FILLER_6_327 VDD VDD VSS VSS gf180mcu_fd_sc_mcu7t5v0__fillcap_4
X0_FILLER_7_2 VDD VDD VSS VSS gf180mcu_fd_sc_mcu7t5v0__fillcap_4
X0_TAP_TAPCELL_ROW_12_93 VDD VSS gf180mcu_fd_sc_mcu7t5v0__filltie
X0_fanout166 _096_/A1 _089_/A1 VDD VDD VSS VSS gf180mcu_fd_sc_mcu7t5v0__dlyb_1
X0_fanout155 _208_/A2 _207_/A2 VDD VDD VSS VSS gf180mcu_fd_sc_mcu7t5v0__dlyb_1
X0_fanout177 _164_/A3 _158_/A2 VDD VDD VSS VSS gf180mcu_fd_sc_mcu7t5v0__dlyb_1
X0_fanout188 _201_/A2 _169_/A2 VDD VDD VSS VSS gf180mcu_fd_sc_mcu7t5v0__dlyb_1
X0__153_ _162_/A1 _068_/Z _153_/ZN VDD VDD VSS VSS gf180mcu_fd_sc_mcu7t5v0__nor2_1
X0_FILLER_12_82 VDD VDD VSS VSS gf180mcu_fd_sc_mcu7t5v0__fill_2
X0_FILLER_10_120 VDD VDD VSS VSS gf180mcu_fd_sc_mcu7t5v0__fill_1
X0__084_ input1/Z input2/Z input3/Z _136_/A1 _084_/Z VDD VDD VSS VSS gf180mcu_fd_sc_mcu7t5v0__and4_1
X0_FILLER_15_212 VDD VDD VSS VSS gf180mcu_fd_sc_mcu7t5v0__fillcap_64
X0__136_ _136_/A1 _169_/A2 _164_/A3 _136_/A4 _202_/A2 VDD VDD VSS VSS gf180mcu_fd_sc_mcu7t5v0__nand4_1
X0__205_ _207_/A1 _207_/A3 _205_/A3 _205_/ZN VDD VDD VSS VSS gf180mcu_fd_sc_mcu7t5v0__nor3_1
X0__067_ _136_/A1 _068_/A4 _201_/A4 VDD VDD VSS VSS gf180mcu_fd_sc_mcu7t5v0__nor2_1
X0_FILLER_9_72 VDD VDD VSS VSS gf180mcu_fd_sc_mcu7t5v0__fill_2
X0__119_ _139_/A1 _186_/A2 _119_/ZN VDD VDD VSS VSS gf180mcu_fd_sc_mcu7t5v0__nor2_1
X0_TAP_TAPCELL_ROW_5_62 VDD VSS gf180mcu_fd_sc_mcu7t5v0__filltie
X0_FILLER_7_263 VDD VDD VSS VSS gf180mcu_fd_sc_mcu7t5v0__fill_1
X0_output92 _141_/ZN dec_out[60] VDD VDD VSS VSS gf180mcu_fd_sc_mcu7t5v0__dlyb_1
X0_output70 _119_/ZN dec_out[40] VDD VDD VSS VSS gf180mcu_fd_sc_mcu7t5v0__dlyb_1
X0_output81 _130_/ZN dec_out[50] VDD VDD VSS VSS gf180mcu_fd_sc_mcu7t5v0__dlyb_1
X0_FILLER_10_313 VDD VDD VSS VSS gf180mcu_fd_sc_mcu7t5v0__fill_2
X0_FILLER_9_155 VDD VDD VSS VSS gf180mcu_fd_sc_mcu7t5v0__fill_1
X0_FILLER_9_188 VDD VDD VSS VSS gf180mcu_fd_sc_mcu7t5v0__fill_1
X0_TAP_TAPCELL_ROW_12_94 VDD VSS gf180mcu_fd_sc_mcu7t5v0__filltie
X0_fanout178 _162_/A2 _164_/A3 VDD VDD VSS VSS gf180mcu_fd_sc_mcu7t5v0__dlyb_1
X0_fanout189 _201_/A2 _046_/I VDD VDD VSS VSS gf180mcu_fd_sc_mcu7t5v0__dlyb_1
X0_fanout167 _103_/A1 _096_/A1 VDD VDD VSS VSS gf180mcu_fd_sc_mcu7t5v0__dlyb_1
X0_fanout156 _143_/A2 _208_/A2 VDD VDD VSS VSS gf180mcu_fd_sc_mcu7t5v0__dlyb_1
X0_FILLER_10_187 VDD VDD VSS VSS gf180mcu_fd_sc_mcu7t5v0__fill_2
X0__083_ _096_/A1 _086_/A2 _096_/A3 _083_/A4 _083_/ZN VDD VDD VSS VSS gf180mcu_fd_sc_mcu7t5v0__nor4_1
X0__152_ _162_/A1 _159_/A2 _158_/A2 _200_/A4 _152_/ZN VDD VDD VSS VSS gf180mcu_fd_sc_mcu7t5v0__nor4_1
X0_FILLER_6_169 VDD VDD VSS VSS gf180mcu_fd_sc_mcu7t5v0__fillcap_4
X0__204_ _207_/A1 _207_/A2 _207_/A3 _204_/A4 _204_/ZN VDD VDD VSS VSS gf180mcu_fd_sc_mcu7t5v0__nor4_1
X0__066_ _042_/I _043_/I _044_/I _068_/A4 VDD VDD VSS VSS gf180mcu_fd_sc_mcu7t5v0__nand3_1
X0__135_ _135_/A1 _135_/A2 _135_/A3 _201_/A4 _135_/Z VDD VDD VSS VSS gf180mcu_fd_sc_mcu7t5v0__and4_1
X0__049_ _042_/I _043_/I _044_/I _051_/A2 VDD VDD VSS VSS gf180mcu_fd_sc_mcu7t5v0__nor3_1
X0_wire140 _073_/A4 _203_/A4 VDD VDD VSS VSS gf180mcu_fd_sc_mcu7t5v0__buf_2
X0__118_ _136_/A1 _138_/A2 _164_/A3 _136_/A4 _186_/A2 VDD VDD VSS VSS gf180mcu_fd_sc_mcu7t5v0__nand4_1
X0_TAP_TAPCELL_ROW_5_63 VDD VSS gf180mcu_fd_sc_mcu7t5v0__filltie
X0_FILLER_15_2 VDD VDD VSS VSS gf180mcu_fd_sc_mcu7t5v0__fillcap_32
X0_FILLER_14_18 VDD VDD VSS VSS gf180mcu_fd_sc_mcu7t5v0__fillcap_8
X0_PHY_EDGE_ROW_16_Left_33 VDD VSS gf180mcu_fd_sc_mcu7t5v0__endcap
X0_FILLER_15_72 VDD VDD VSS VSS gf180mcu_fd_sc_mcu7t5v0__fill_1
X0_output82 _131_/ZN dec_out[51] VDD VDD VSS VSS gf180mcu_fd_sc_mcu7t5v0__dlyb_1
X0_output60 _109_/ZN dec_out[31] VDD VDD VSS VSS gf180mcu_fd_sc_mcu7t5v0__dlyb_1
X0_output93 _142_/ZN dec_out[61] VDD VDD VSS VSS gf180mcu_fd_sc_mcu7t5v0__dlyb_1
X0_output71 _120_/ZN dec_out[41] VDD VDD VSS VSS gf180mcu_fd_sc_mcu7t5v0__dlyb_1
X0_FILLER_10_325 VDD VDD VSS VSS gf180mcu_fd_sc_mcu7t5v0__fillcap_4
X0_PHY_EDGE_ROW_1_Left_18 VDD VSS gf180mcu_fd_sc_mcu7t5v0__endcap
X0_TAP_TAPCELL_ROW_12_95 VDD VSS gf180mcu_fd_sc_mcu7t5v0__filltie
X0_FILLER_12_84 VDD VDD VSS VSS gf180mcu_fd_sc_mcu7t5v0__fill_1
X0_fanout168 _201_/A1 _103_/A1 VDD VDD VSS VSS gf180mcu_fd_sc_mcu7t5v0__dlyb_1
X0__082_ _082_/A1 _043_/I _044_/I _045_/I _083_/A4 VDD VDD VSS VSS gf180mcu_fd_sc_mcu7t5v0__nand4_1
X0__151_ _159_/A1 _159_/A2 _158_/A2 _199_/A4 _151_/ZN VDD VDD VSS VSS gf180mcu_fd_sc_mcu7t5v0__nor4_1
X0_fanout146 _133_/A3 _129_/A3 VDD VDD VSS VSS gf180mcu_fd_sc_mcu7t5v0__dlyb_1
X0_fanout157 _046_/ZN _143_/A2 VDD VDD VSS VSS gf180mcu_fd_sc_mcu7t5v0__dlyb_1
X0_fanout179 _162_/A2 _047_/I VDD VDD VSS VSS gf180mcu_fd_sc_mcu7t5v0__dlyb_1
X0_TAP_TAPCELL_ROW_8_74 VDD VSS gf180mcu_fd_sc_mcu7t5v0__filltie
X0_PHY_EDGE_ROW_4_Left_21 VDD VSS gf180mcu_fd_sc_mcu7t5v0__endcap
X0__203_ _207_/A1 _207_/A2 _207_/A3 _203_/A4 _203_/ZN VDD VDD VSS VSS gf180mcu_fd_sc_mcu7t5v0__nor4_1
X0__065_ _096_/A1 _086_/A2 _089_/A3 _096_/A4 _065_/ZN VDD VDD VSS VSS gf180mcu_fd_sc_mcu7t5v0__nor4_1
X0__134_ _134_/A1 _138_/A2 _143_/A3 _200_/A4 _134_/ZN VDD VDD VSS VSS gf180mcu_fd_sc_mcu7t5v0__nor4_1
X0_TAP_TAPCELL_ROW_5_64 VDD VSS gf180mcu_fd_sc_mcu7t5v0__filltie
X0__117_ _135_/A1 _138_/A2 _135_/A3 _201_/A4 _117_/Z VDD VDD VSS VSS gf180mcu_fd_sc_mcu7t5v0__and4_1
X0__048_ _042_/I _043_/I _104_/A4 VDD VDD VSS VSS gf180mcu_fd_sc_mcu7t5v0__nor2_1
X0_FILLER_4_279 VDD VDD VSS VSS gf180mcu_fd_sc_mcu7t5v0__fillcap_4
X0_output72 _121_/ZN dec_out[42] VDD VDD VSS VSS gf180mcu_fd_sc_mcu7t5v0__dlyb_1
X0_output94 _143_/ZN dec_out[62] VDD VDD VSS VSS gf180mcu_fd_sc_mcu7t5v0__dlyb_1
X0_output83 _132_/ZN dec_out[52] VDD VDD VSS VSS gf180mcu_fd_sc_mcu7t5v0__dlyb_1
X0_output61 _110_/ZN dec_out[32] VDD VDD VSS VSS gf180mcu_fd_sc_mcu7t5v0__dlyb_1
X0_output50 _096_/ZN dec_out[22] VDD VDD VSS VSS gf180mcu_fd_sc_mcu7t5v0__dlyb_1
X0_FILLER_5_330 VDD VDD VSS VSS gf180mcu_fd_sc_mcu7t5v0__fill_1
X0_TAP_TAPCELL_ROW_12_96 VDD VSS gf180mcu_fd_sc_mcu7t5v0__filltie
X0_FILLER_10_189 VDD VDD VSS VSS gf180mcu_fd_sc_mcu7t5v0__fill_1
X0_fanout147 _143_/A3 _133_/A3 VDD VDD VSS VSS gf180mcu_fd_sc_mcu7t5v0__dlyb_1
X0_FILLER_2_311 VDD VDD VSS VSS gf180mcu_fd_sc_mcu7t5v0__fillcap_4
X0__150_ _159_/A1 _158_/A2 _182_/A3 _150_/ZN VDD VDD VSS VSS gf180mcu_fd_sc_mcu7t5v0__nor3_1
X0_fanout169 _134_/A1 _122_/A1 VDD VDD VSS VSS gf180mcu_fd_sc_mcu7t5v0__dlyb_1
X0_fanout158 _135_/A1 _159_/A1 VDD VDD VSS VSS gf180mcu_fd_sc_mcu7t5v0__dlyb_1
X0__081_ _089_/A1 _086_/A2 _089_/A3 _106_/A4 _081_/ZN VDD VDD VSS VSS gf180mcu_fd_sc_mcu7t5v0__nor4_1
X0_PHY_EDGE_ROW_16_Right_16 VDD VSS gf180mcu_fd_sc_mcu7t5v0__endcap
X0_FILLER_5_2 VDD VDD VSS VSS gf180mcu_fd_sc_mcu7t5v0__fillcap_4
X0_TAP_TAPCELL_ROW_8_75 VDD VSS gf180mcu_fd_sc_mcu7t5v0__filltie
X0__133_ _134_/A1 _138_/A2 _133_/A3 _199_/A4 _133_/ZN VDD VDD VSS VSS gf180mcu_fd_sc_mcu7t5v0__nor4_1
X0__202_ _209_/A1 _202_/A2 _202_/ZN VDD VDD VSS VSS gf180mcu_fd_sc_mcu7t5v0__nor2_1
X0__064_ _082_/A1 _043_/I _044_/I _093_/A2 _096_/A4 VDD VDD VSS VSS gf180mcu_fd_sc_mcu7t5v0__nand4_1
X0_FILLER_14_281 VDD VDD VSS VSS gf180mcu_fd_sc_mcu7t5v0__fill_2
X0_FILLER_11_251 VDD VDD VSS VSS gf180mcu_fd_sc_mcu7t5v0__fill_1
X0_FILLER_11_262 VDD VDD VSS VSS gf180mcu_fd_sc_mcu7t5v0__fill_1
X0__116_ _122_/A1 _124_/A2 _133_/A3 _200_/A4 _116_/ZN VDD VDD VSS VSS gf180mcu_fd_sc_mcu7t5v0__nor4_1
X0_FILLER_7_244 VDD VDD VSS VSS gf180mcu_fd_sc_mcu7t5v0__fill_1
X0__047_ _047_/I _047_/ZN VDD VDD VSS VSS gf180mcu_fd_sc_mcu7t5v0__clkinv_1
X0_PHY_EDGE_ROW_2_Right_2 VDD VSS gf180mcu_fd_sc_mcu7t5v0__endcap
X0_output95 _145_/ZN dec_out[63] VDD VDD VSS VSS gf180mcu_fd_sc_mcu7t5v0__dlyb_1
X0_output84 _133_/ZN dec_out[53] VDD VDD VSS VSS gf180mcu_fd_sc_mcu7t5v0__dlyb_1
X0_output51 _097_/Z dec_out[23] VDD VDD VSS VSS gf180mcu_fd_sc_mcu7t5v0__dlyb_1
X0_output40 _081_/ZN dec_out[13] VDD VDD VSS VSS gf180mcu_fd_sc_mcu7t5v0__dlyb_1
X0_output73 _122_/ZN dec_out[43] VDD VDD VSS VSS gf180mcu_fd_sc_mcu7t5v0__dlyb_1
X0_output62 _111_/ZN dec_out[33] VDD VDD VSS VSS gf180mcu_fd_sc_mcu7t5v0__dlyb_1
X0_FILLER_7_6 VDD VDD VSS VSS gf180mcu_fd_sc_mcu7t5v0__fill_2
X0_FILLER_13_165 VDD VDD VSS VSS gf180mcu_fd_sc_mcu7t5v0__fillcap_4
X0_fanout159 _135_/A1 _162_/A1 VDD VDD VSS VSS gf180mcu_fd_sc_mcu7t5v0__dlyb_1
X0__080_ _042_/I _080_/A2 _044_/I _045_/I _106_/A4 VDD VDD VSS VSS gf180mcu_fd_sc_mcu7t5v0__nand4_1
X0_fanout148 _047_/ZN _143_/A3 VDD VDD VSS VSS gf180mcu_fd_sc_mcu7t5v0__dlyb_1
X0_TAP_TAPCELL_ROW_8_76 VDD VSS gf180mcu_fd_sc_mcu7t5v0__filltie
X0_FILLER_5_183 VDD VDD VSS VSS gf180mcu_fd_sc_mcu7t5v0__fill_1
X0__132_ _134_/A1 _133_/A3 _198_/A3 _132_/ZN VDD VDD VSS VSS gf180mcu_fd_sc_mcu7t5v0__nor3_1
X0__201_ _201_/A1 _201_/A2 _201_/A3 _201_/A4 _201_/Z VDD VDD VSS VSS gf180mcu_fd_sc_mcu7t5v0__and4_1
X0__063_ _089_/A1 _086_/A2 _089_/A3 _095_/A4 _063_/ZN VDD VDD VSS VSS gf180mcu_fd_sc_mcu7t5v0__nor4_1
X0__115_ _122_/A1 _124_/A2 _129_/A3 _199_/A4 _115_/ZN VDD VDD VSS VSS gf180mcu_fd_sc_mcu7t5v0__nor4_1
X0__046_ _046_/I _046_/ZN VDD VDD VSS VSS gf180mcu_fd_sc_mcu7t5v0__clkinv_1
X0_FILLER_7_212 VDD VDD VSS VSS gf180mcu_fd_sc_mcu7t5v0__fillcap_4
X0_FILLER_13_2 VDD VDD VSS VSS gf180mcu_fd_sc_mcu7t5v0__fillcap_16
X0_FILLER_6_55 VDD VDD VSS VSS gf180mcu_fd_sc_mcu7t5v0__fill_2
X0_output41 _083_/ZN dec_out[14] VDD VDD VSS VSS gf180mcu_fd_sc_mcu7t5v0__dlyb_1
X0_output30 _077_/ZN dec_out[11] VDD VDD VSS VSS gf180mcu_fd_sc_mcu7t5v0__dlyb_1
X0_output52 _099_/ZN dec_out[24] VDD VDD VSS VSS gf180mcu_fd_sc_mcu7t5v0__dlyb_1
X0_output85 _134_/ZN dec_out[54] VDD VDD VSS VSS gf180mcu_fd_sc_mcu7t5v0__dlyb_1
X0_output63 _112_/ZN dec_out[34] VDD VDD VSS VSS gf180mcu_fd_sc_mcu7t5v0__dlyb_1
X0_output96 _146_/ZN dec_out[64] VDD VDD VSS VSS gf180mcu_fd_sc_mcu7t5v0__dlyb_1
X0_output74 _123_/ZN dec_out[44] VDD VDD VSS VSS gf180mcu_fd_sc_mcu7t5v0__dlyb_1
.ends

.subckt inv_dut_000 A Q VDD VSS
.ends

* inv_dut_001: pfet_05v0 W=3.60u L=0.60u / nfet_05v0 W=3.60u L=0.60u
.subckt inv_dut_001 A Q VDD VSS
MMP Q A VDD VDD pfet_05v0 W=3.60u L=0.60u
MMN Q A VSS VSS nfet_05v0 W=3.60u L=0.60u
.ends

* inv_dut_002: pfet_05v0 W=5.40u L=0.60u / nfet_05v0 W=5.40u L=0.60u
.subckt inv_dut_002 A Q VDD VSS
MMP Q A VDD VDD pfet_05v0 W=5.40u L=0.60u
MMN Q A VSS VSS nfet_05v0 W=5.40u L=0.60u
.ends

* inv_dut_003: pfet_05v0 W=3.60u L=0.60u / nfet_05v0 W=1.80u L=0.60u
.subckt inv_dut_003 A Q VDD VSS
MMP Q A VDD VDD pfet_05v0 W=3.60u L=0.60u
MMN Q A VSS VSS nfet_05v0 W=1.80u L=0.60u
.ends

* inv_dut_004: pfet_05v0 W=7.20u L=0.60u / nfet_05v0 W=3.60u L=0.60u
.subckt inv_dut_004 A Q VDD VSS
MMP Q A VDD VDD pfet_05v0 W=7.20u L=0.60u
MMN Q A VSS VSS nfet_05v0 W=3.60u L=0.60u
.ends

.subckt inv_dut_005 A Q VDD VSS
.ends

* inv_dut_006: pfet_05v0 W=5.40u L=0.60u / nfet_05v0 W=1.80u L=0.60u
.subckt inv_dut_006 A Q VDD VSS
MMP Q A VDD VDD pfet_05v0 W=5.40u L=0.60u
MMN Q A VSS VSS nfet_05v0 W=1.80u L=0.60u
.ends

* inv_dut_007: pfet_05v0 W=10.80u L=0.60u / nfet_05v0 W=3.60u L=0.60u
.subckt inv_dut_007 A Q VDD VSS
MMP Q A VDD VDD pfet_05v0 W=10.80u L=0.60u
MMN Q A VSS VSS nfet_05v0 W=3.60u L=0.60u
.ends

* inv_dut_008: pfet_05v0 W=16.20u L=0.60u / nfet_05v0 W=5.40u L=0.60u
.subckt inv_dut_008 A Q VDD VSS
MMP Q A VDD VDD pfet_05v0 W=16.20u L=0.60u
MMN Q A VSS VSS nfet_05v0 W=5.40u L=0.60u
.ends

* inv_dut_009: pfet_05v0 W=3.60u L=1.20u / nfet_05v0 W=1.80u L=1.20u
.subckt inv_dut_009 A Q VDD VSS
MMP Q A VDD VDD pfet_05v0 W=3.60u L=1.20u
MMN Q A VSS VSS nfet_05v0 W=1.80u L=1.20u
.ends

* inv_dut_010: pfet_05v0 W=7.20u L=1.20u / nfet_05v0 W=3.60u L=1.20u
.subckt inv_dut_010 A Q VDD VSS
MMP Q A VDD VDD pfet_05v0 W=7.20u L=1.20u
MMN Q A VSS VSS nfet_05v0 W=3.60u L=1.20u
.ends

* inv_dut_011: pfet_05v0 W=10.80u L=1.20u / nfet_05v0 W=5.40u L=1.20u
.subckt inv_dut_011 A Q VDD VSS
MMP Q A VDD VDD pfet_05v0 W=10.80u L=1.20u
MMN Q A VSS VSS nfet_05v0 W=5.40u L=1.20u
.ends

* inv_dut_012: pfet_05v0 W=5.40u L=1.20u / nfet_05v0 W=1.80u L=1.20u
.subckt inv_dut_012 A Q VDD VSS
MMP Q A VDD VDD pfet_05v0 W=5.40u L=1.20u
MMN Q A VSS VSS nfet_05v0 W=1.80u L=1.20u
.ends

* inv_dut_013: pfet_05v0 W=10.80u L=1.20u / nfet_05v0 W=3.60u L=1.20u
.subckt inv_dut_013 A Q VDD VSS
MMP Q A VDD VDD pfet_05v0 W=10.80u L=1.20u
MMN Q A VSS VSS nfet_05v0 W=3.60u L=1.20u
.ends

.subckt inv_dut_014 A Q VDD VSS
.ends

* inv_dut_015: pfet_05v0 W=16.20u L=1.80u / nfet_05v0 W=5.40u L=1.80u
.subckt inv_dut_015 A Q VDD VSS
MMP Q A VDD VDD pfet_05v0 W=16.20u L=1.80u
MMN Q A VSS VSS nfet_05v0 W=5.40u L=1.80u
.ends

* inv_dut_016: pfet_03v3 W=0.90u L=0.30u / nfet_03v3 W=0.90u L=0.30u
.subckt inv_dut_016 A Q VDD VSS
MMP Q A VDD VDD pfet_03v3 W=0.90u L=0.30u
MMN Q A VSS VSS nfet_03v3 W=0.90u L=0.30u
.ends

* inv_dut_017: pfet_03v3 W=1.80u L=0.30u / nfet_03v3 W=1.80u L=0.30u
.subckt inv_dut_017 A Q VDD VSS
MMP Q A VDD VDD pfet_03v3 W=1.80u L=0.30u
MMN Q A VSS VSS nfet_03v3 W=1.80u L=0.30u
.ends

* inv_dut_018: pfet_03v3 W=3.60u L=0.30u / nfet_03v3 W=3.60u L=0.30u
.subckt inv_dut_018 A Q VDD VSS
MMP Q A VDD VDD pfet_03v3 W=3.60u L=0.30u
MMN Q A VSS VSS nfet_03v3 W=3.60u L=0.30u
.ends

* inv_dut_019: pfet_03v3 W=1.80u L=0.30u / nfet_03v3 W=0.90u L=0.30u
.subckt inv_dut_019 A Q VDD VSS
MMP Q A VDD VDD pfet_03v3 W=1.80u L=0.30u
MMN Q A VSS VSS nfet_03v3 W=0.90u L=0.30u
.ends

* inv_dut_020: pfet_03v3 W=3.60u L=0.30u / nfet_03v3 W=1.80u L=0.30u
.subckt inv_dut_020 A Q VDD VSS
MMP Q A VDD VDD pfet_03v3 W=3.60u L=0.30u
MMN Q A VSS VSS nfet_03v3 W=1.80u L=0.30u
.ends

.subckt inv_dut_021 A Q VDD VSS
.ends

* inv_dut_022: pfet_03v3 W=2.70u L=0.30u / nfet_03v3 W=0.90u L=0.30u
.subckt inv_dut_022 A Q VDD VSS
MMP Q A VDD VDD pfet_03v3 W=2.70u L=0.30u
MMN Q A VSS VSS nfet_03v3 W=0.90u L=0.30u
.ends

.subckt inv_dut_023 A Q VDD VSS
.ends

* inv_dut_024: pfet_03v3 W=8.10u L=0.30u / nfet_03v3 W=2.70u L=0.30u
.subckt inv_dut_024 A Q VDD VSS
MMP Q A VDD VDD pfet_03v3 W=8.10u L=0.30u
MMN Q A VSS VSS nfet_03v3 W=2.70u L=0.30u
.ends

* inv_dut_025: pfet_03v3 W=1.80u L=0.60u / nfet_03v3 W=0.90u L=0.60u
.subckt inv_dut_025 A Q VDD VSS
MMP Q A VDD VDD pfet_03v3 W=1.80u L=0.60u
MMN Q A VSS VSS nfet_03v3 W=0.90u L=0.60u
.ends

* inv_dut_026: pfet_03v3 W=3.60u L=0.60u / nfet_03v3 W=1.80u L=0.60u
.subckt inv_dut_026 A Q VDD VSS
MMP Q A VDD VDD pfet_03v3 W=3.60u L=0.60u
MMN Q A VSS VSS nfet_03v3 W=1.80u L=0.60u
.ends

* inv_dut_027: pfet_03v3 W=5.40u L=0.60u / nfet_03v3 W=2.70u L=0.60u
.subckt inv_dut_027 A Q VDD VSS
MMP Q A VDD VDD pfet_03v3 W=5.40u L=0.60u
MMN Q A VSS VSS nfet_03v3 W=2.70u L=0.60u
.ends

* inv_dut_028: pfet_03v3 W=2.70u L=0.60u / nfet_03v3 W=0.90u L=0.60u
.subckt inv_dut_028 A Q VDD VSS
MMP Q A VDD VDD pfet_03v3 W=2.70u L=0.60u
MMN Q A VSS VSS nfet_03v3 W=0.90u L=0.60u
.ends

.subckt inv_dut_029 A Q VDD VSS
.ends

* inv_dut_030: pfet_03v3 W=8.10u L=0.60u / nfet_03v3 W=2.70u L=0.60u
.subckt inv_dut_030 A Q VDD VSS
MMP Q A VDD VDD pfet_03v3 W=8.10u L=0.60u
MMN Q A VSS VSS nfet_03v3 W=2.70u L=0.60u
.ends

.subckt inv_dut_031 A Q VDD VSS
.ends

* inv_dut_032: pfet_05v0 W=1.80u L=0.60u / nfet_05v0 W=1.80u L=0.60u
.subckt inv_dut_032 A Q VDD VSS
MMP Q A VDD VDD pfet_05v0 W=1.80u L=0.60u
MMN Q A VSS VSS nfet_05v0 W=1.80u L=0.60u
.ends

* inv_dut_033: pfet_05v0 W=3.60u L=0.60u / nfet_05v0 W=3.60u L=0.60u
.subckt inv_dut_033 A Q VDD VSS
MMP Q A VDD VDD pfet_05v0 W=3.60u L=0.60u
MMN Q A VSS VSS nfet_05v0 W=3.60u L=0.60u
.ends

* inv_dut_034: pfet_05v0 W=5.40u L=0.60u / nfet_05v0 W=5.40u L=0.60u
.subckt inv_dut_034 A Q VDD VSS
MMP Q A VDD VDD pfet_05v0 W=5.40u L=0.60u
MMN Q A VSS VSS nfet_05v0 W=5.40u L=0.60u
.ends

* inv_dut_035: pfet_05v0 W=3.60u L=0.60u / nfet_05v0 W=1.80u L=0.60u
.subckt inv_dut_035 A Q VDD VSS
MMP Q A VDD VDD pfet_05v0 W=3.60u L=0.60u
MMN Q A VSS VSS nfet_05v0 W=1.80u L=0.60u
.ends

.subckt inv_dut_036 A Q VDD VSS
.ends

* inv_dut_037: pfet_05v0 W=10.80u L=0.60u / nfet_05v0 W=5.40u L=0.60u
.subckt inv_dut_037 A Q VDD VSS
MMP Q A VDD VDD pfet_05v0 W=10.80u L=0.60u
MMN Q A VSS VSS nfet_05v0 W=5.40u L=0.60u
.ends

* inv_dut_038: pfet_05v0 W=5.40u L=0.60u / nfet_05v0 W=1.80u L=0.60u
.subckt inv_dut_038 A Q VDD VSS
MMP Q A VDD VDD pfet_05v0 W=5.40u L=0.60u
MMN Q A VSS VSS nfet_05v0 W=1.80u L=0.60u
.ends

* inv_dut_039: pfet_05v0 W=10.80u L=0.60u / nfet_05v0 W=3.60u L=0.60u
.subckt inv_dut_039 A Q VDD VSS
MMP Q A VDD VDD pfet_05v0 W=10.80u L=0.60u
MMN Q A VSS VSS nfet_05v0 W=3.60u L=0.60u
.ends

* inv_dut_040: pfet_05v0 W=16.20u L=0.60u / nfet_05v0 W=5.40u L=0.60u
.subckt inv_dut_040 A Q VDD VSS
MMP Q A VDD VDD pfet_05v0 W=16.20u L=0.60u
MMN Q A VSS VSS nfet_05v0 W=5.40u L=0.60u
.ends

.subckt inv_dut_041 A Q VDD VSS
.ends

* inv_dut_042: pfet_05v0 W=7.20u L=1.20u / nfet_05v0 W=3.60u L=1.20u
.subckt inv_dut_042 A Q VDD VSS
MMP Q A VDD VDD pfet_05v0 W=7.20u L=1.20u
MMN Q A VSS VSS nfet_05v0 W=3.60u L=1.20u
.ends

* inv_dut_043: pfet_05v0 W=10.80u L=1.20u / nfet_05v0 W=5.40u L=1.20u
.subckt inv_dut_043 A Q VDD VSS
MMP Q A VDD VDD pfet_05v0 W=10.80u L=1.20u
MMN Q A VSS VSS nfet_05v0 W=5.40u L=1.20u
.ends

.subckt inv_dut_044 A Q VDD VSS
.ends

.subckt inv_dut_045 A Q VDD VSS
.ends

.subckt inv_dut_046 A Q VDD VSS
.ends

* inv_dut_047: pfet_05v0 W=16.20u L=1.80u / nfet_05v0 W=5.40u L=1.80u
.subckt inv_dut_047 A Q VDD VSS
MMP Q A VDD VDD pfet_05v0 W=16.20u L=1.80u
MMN Q A VSS VSS nfet_05v0 W=5.40u L=1.80u
.ends

.subckt inv_dut_048 A Q VDD VSS
.ends

* inv_dut_049: pfet_03v3 W=1.80u L=0.30u / nfet_03v3 W=1.80u L=0.30u
.subckt inv_dut_049 A Q VDD VSS
MMP Q A VDD VDD pfet_03v3 W=1.80u L=0.30u
MMN Q A VSS VSS nfet_03v3 W=1.80u L=0.30u
.ends

* inv_dut_050: pfet_03v3 W=3.60u L=0.30u / nfet_03v3 W=3.60u L=0.30u
.subckt inv_dut_050 A Q VDD VSS
MMP Q A VDD VDD pfet_03v3 W=3.60u L=0.30u
MMN Q A VSS VSS nfet_03v3 W=3.60u L=0.30u
.ends

* inv_dut_051: pfet_03v3 W=1.80u L=0.30u / nfet_03v3 W=0.90u L=0.30u
.subckt inv_dut_051 A Q VDD VSS
MMP Q A VDD VDD pfet_03v3 W=1.80u L=0.30u
MMN Q A VSS VSS nfet_03v3 W=0.90u L=0.30u
.ends

.subckt inv_dut_052 A Q VDD VSS
.ends

* inv_dut_053: pfet_03v3 W=5.40u L=0.30u / nfet_03v3 W=2.70u L=0.30u
.subckt inv_dut_053 A Q VDD VSS
MMP Q A VDD VDD pfet_03v3 W=5.40u L=0.30u
MMN Q A VSS VSS nfet_03v3 W=2.70u L=0.30u
.ends

.subckt inv_dut_054 A Q VDD VSS
.ends

.subckt inv_dut_055 A Q VDD VSS
.ends

.subckt inv_dut_056 A Q VDD VSS
.ends

.subckt inv_dut_057 A Q VDD VSS
.ends

* inv_dut_058: pfet_03v3 W=3.60u L=0.60u / nfet_03v3 W=1.80u L=0.60u
.subckt inv_dut_058 A Q VDD VSS
MMP Q A VDD VDD pfet_03v3 W=3.60u L=0.60u
MMN Q A VSS VSS nfet_03v3 W=1.80u L=0.60u
.ends

.subckt inv_dut_059 A Q VDD VSS
.ends

* inv_dut_060: pfet_03v3 W=2.70u L=0.60u / nfet_03v3 W=0.90u L=0.60u
.subckt inv_dut_060 A Q VDD VSS
MMP Q A VDD VDD pfet_03v3 W=2.70u L=0.60u
MMN Q A VSS VSS nfet_03v3 W=0.90u L=0.60u
.ends

* inv_dut_061: pfet_03v3 W=5.40u L=0.60u / nfet_03v3 W=1.80u L=0.60u
.subckt inv_dut_061 A Q VDD VSS
MMP Q A VDD VDD pfet_03v3 W=5.40u L=0.60u
MMN Q A VSS VSS nfet_03v3 W=1.80u L=0.60u
.ends

* inv_dut_062: pfet_03v3 W=8.10u L=0.60u / nfet_03v3 W=2.70u L=0.60u
.subckt inv_dut_062 A Q VDD VSS
MMP Q A VDD VDD pfet_03v3 W=8.10u L=0.60u
MMN Q A VSS VSS nfet_03v3 W=2.70u L=0.60u
.ends

.subckt inv_dut_063 A Q VDD VSS
.ends

* inv_dut_064: pfet_05v0 W=1.80u L=0.60u / nfet_05v0 W=1.80u L=0.60u
.subckt inv_dut_064 A Q VDD VSS
MMP Q A VDD VDD pfet_05v0 W=1.80u L=0.60u
MMN Q A VSS VSS nfet_05v0 W=1.80u L=0.60u
.ends

* inv_dut_065: pfet_05v0 W=3.60u L=0.60u / nfet_05v0 W=3.60u L=0.60u
.subckt inv_dut_065 A Q VDD VSS
MMP Q A VDD VDD pfet_05v0 W=3.60u L=0.60u
MMN Q A VSS VSS nfet_05v0 W=3.60u L=0.60u
.ends

* inv_dut_066: pfet_05v0 W=5.40u L=0.60u / nfet_05v0 W=5.40u L=0.60u
.subckt inv_dut_066 A Q VDD VSS
MMP Q A VDD VDD pfet_05v0 W=5.40u L=0.60u
MMN Q A VSS VSS nfet_05v0 W=5.40u L=0.60u
.ends

* inv_dut_067: pfet_05v0 W=3.60u L=0.60u / nfet_05v0 W=1.80u L=0.60u
.subckt inv_dut_067 A Q VDD VSS
MMP Q A VDD VDD pfet_05v0 W=3.60u L=0.60u
MMN Q A VSS VSS nfet_05v0 W=1.80u L=0.60u
.ends

* inv_dut_068: pfet_05v0 W=7.20u L=0.60u / nfet_05v0 W=3.60u L=0.60u
.subckt inv_dut_068 A Q VDD VSS
MMP Q A VDD VDD pfet_05v0 W=7.20u L=0.60u
MMN Q A VSS VSS nfet_05v0 W=3.60u L=0.60u
.ends

* inv_dut_069: pfet_05v0 W=10.80u L=0.60u / nfet_05v0 W=5.40u L=0.60u
.subckt inv_dut_069 A Q VDD VSS
MMP Q A VDD VDD pfet_05v0 W=10.80u L=0.60u
MMN Q A VSS VSS nfet_05v0 W=5.40u L=0.60u
.ends

* inv_dut_070: pfet_05v0 W=5.40u L=0.60u / nfet_05v0 W=1.80u L=0.60u
.subckt inv_dut_070 A Q VDD VSS
MMP Q A VDD VDD pfet_05v0 W=5.40u L=0.60u
MMN Q A VSS VSS nfet_05v0 W=1.80u L=0.60u
.ends

* inv_dut_071: pfet_05v0 W=10.80u L=0.60u / nfet_05v0 W=3.60u L=0.60u
.subckt inv_dut_071 A Q VDD VSS
MMP Q A VDD VDD pfet_05v0 W=10.80u L=0.60u
MMN Q A VSS VSS nfet_05v0 W=3.60u L=0.60u
.ends

* inv_dut_072: pfet_05v0 W=16.20u L=0.60u / nfet_05v0 W=5.40u L=0.60u
.subckt inv_dut_072 A Q VDD VSS
MMP Q A VDD VDD pfet_05v0 W=16.20u L=0.60u
MMN Q A VSS VSS nfet_05v0 W=5.40u L=0.60u
.ends

* inv_dut_073: pfet_05v0 W=3.60u L=1.20u / nfet_05v0 W=1.80u L=1.20u
.subckt inv_dut_073 A Q VDD VSS
MMP Q A VDD VDD pfet_05v0 W=3.60u L=1.20u
MMN Q A VSS VSS nfet_05v0 W=1.80u L=1.20u
.ends

* inv_dut_074: pfet_05v0 W=7.20u L=1.20u / nfet_05v0 W=3.60u L=1.20u
.subckt inv_dut_074 A Q VDD VSS
MMP Q A VDD VDD pfet_05v0 W=7.20u L=1.20u
MMN Q A VSS VSS nfet_05v0 W=3.60u L=1.20u
.ends

* inv_dut_075: pfet_05v0 W=10.80u L=1.20u / nfet_05v0 W=5.40u L=1.20u
.subckt inv_dut_075 A Q VDD VSS
MMP Q A VDD VDD pfet_05v0 W=10.80u L=1.20u
MMN Q A VSS VSS nfet_05v0 W=5.40u L=1.20u
.ends

* inv_dut_076: pfet_05v0 W=5.40u L=1.20u / nfet_05v0 W=1.80u L=1.20u
.subckt inv_dut_076 A Q VDD VSS
MMP Q A VDD VDD pfet_05v0 W=5.40u L=1.20u
MMN Q A VSS VSS nfet_05v0 W=1.80u L=1.20u
.ends

* inv_dut_077: pfet_05v0 W=10.80u L=1.20u / nfet_05v0 W=3.60u L=1.20u
.subckt inv_dut_077 A Q VDD VSS
MMP Q A VDD VDD pfet_05v0 W=10.80u L=1.20u
MMN Q A VSS VSS nfet_05v0 W=3.60u L=1.20u
.ends

* inv_dut_078: pfet_05v0 W=16.20u L=1.20u / nfet_05v0 W=5.40u L=1.20u
.subckt inv_dut_078 A Q VDD VSS
MMP Q A VDD VDD pfet_05v0 W=16.20u L=1.20u
MMN Q A VSS VSS nfet_05v0 W=5.40u L=1.20u
.ends

* inv_dut_079: pfet_05v0 W=16.20u L=1.80u / nfet_05v0 W=5.40u L=1.80u
.subckt inv_dut_079 A Q VDD VSS
MMP Q A VDD VDD pfet_05v0 W=16.20u L=1.80u
MMN Q A VSS VSS nfet_05v0 W=5.40u L=1.80u
.ends

* inv_dut_080: pfet_03v3 W=0.90u L=0.30u / nfet_03v3 W=0.90u L=0.30u
.subckt inv_dut_080 A Q VDD VSS
MMP Q A VDD VDD pfet_03v3 W=0.90u L=0.30u
MMN Q A VSS VSS nfet_03v3 W=0.90u L=0.30u
.ends

* inv_dut_081: pfet_03v3 W=1.80u L=0.30u / nfet_03v3 W=1.80u L=0.30u
.subckt inv_dut_081 A Q VDD VSS
MMP Q A VDD VDD pfet_03v3 W=1.80u L=0.30u
MMN Q A VSS VSS nfet_03v3 W=1.80u L=0.30u
.ends

.subckt inv_dut_082 A Q VDD VSS
.ends

* inv_dut_083: pfet_03v3 W=1.80u L=0.30u / nfet_03v3 W=0.90u L=0.30u
.subckt inv_dut_083 A Q VDD VSS
MMP Q A VDD VDD pfet_03v3 W=1.80u L=0.30u
MMN Q A VSS VSS nfet_03v3 W=0.90u L=0.30u
.ends

* inv_dut_084: pfet_03v3 W=3.60u L=0.30u / nfet_03v3 W=1.80u L=0.30u
.subckt inv_dut_084 A Q VDD VSS
MMP Q A VDD VDD pfet_03v3 W=3.60u L=0.30u
MMN Q A VSS VSS nfet_03v3 W=1.80u L=0.30u
.ends

.subckt inv_dut_085 A Q VDD VSS
.ends

* inv_dut_086: pfet_03v3 W=2.70u L=0.30u / nfet_03v3 W=0.90u L=0.30u
.subckt inv_dut_086 A Q VDD VSS
MMP Q A VDD VDD pfet_03v3 W=2.70u L=0.30u
MMN Q A VSS VSS nfet_03v3 W=0.90u L=0.30u
.ends

* inv_dut_087: pfet_03v3 W=5.40u L=0.30u / nfet_03v3 W=1.80u L=0.30u
.subckt inv_dut_087 A Q VDD VSS
MMP Q A VDD VDD pfet_03v3 W=5.40u L=0.30u
MMN Q A VSS VSS nfet_03v3 W=1.80u L=0.30u
.ends

.subckt inv_dut_088 A Q VDD VSS
.ends

* inv_dut_089: pfet_03v3 W=1.80u L=0.60u / nfet_03v3 W=0.90u L=0.60u
.subckt inv_dut_089 A Q VDD VSS
MMP Q A VDD VDD pfet_03v3 W=1.80u L=0.60u
MMN Q A VSS VSS nfet_03v3 W=0.90u L=0.60u
.ends

* inv_dut_090: pfet_03v3 W=3.60u L=0.60u / nfet_03v3 W=1.80u L=0.60u
.subckt inv_dut_090 A Q VDD VSS
MMP Q A VDD VDD pfet_03v3 W=3.60u L=0.60u
MMN Q A VSS VSS nfet_03v3 W=1.80u L=0.60u
.ends

* inv_dut_091: pfet_03v3 W=5.40u L=0.60u / nfet_03v3 W=2.70u L=0.60u
.subckt inv_dut_091 A Q VDD VSS
MMP Q A VDD VDD pfet_03v3 W=5.40u L=0.60u
MMN Q A VSS VSS nfet_03v3 W=2.70u L=0.60u
.ends

* inv_dut_092: pfet_03v3 W=2.70u L=0.60u / nfet_03v3 W=0.90u L=0.60u
.subckt inv_dut_092 A Q VDD VSS
MMP Q A VDD VDD pfet_03v3 W=2.70u L=0.60u
MMN Q A VSS VSS nfet_03v3 W=0.90u L=0.60u
.ends

* inv_dut_093: pfet_03v3 W=5.40u L=0.60u / nfet_03v3 W=1.80u L=0.60u
.subckt inv_dut_093 A Q VDD VSS
MMP Q A VDD VDD pfet_03v3 W=5.40u L=0.60u
MMN Q A VSS VSS nfet_03v3 W=1.80u L=0.60u
.ends

* inv_dut_094: pfet_03v3 W=8.10u L=0.60u / nfet_03v3 W=2.70u L=0.60u
.subckt inv_dut_094 A Q VDD VSS
MMP Q A VDD VDD pfet_03v3 W=8.10u L=0.60u
MMN Q A VSS VSS nfet_03v3 W=2.70u L=0.60u
.ends

* inv_dut_095: pfet_03v3 W=8.10u L=0.90u / nfet_03v3 W=2.70u L=0.90u
.subckt inv_dut_095 A Q VDD VSS
MMP Q A VDD VDD pfet_03v3 W=8.10u L=0.90u
MMN Q A VSS VSS nfet_03v3 W=2.70u L=0.90u
.ends

* inv_dut_096: pfet_05v0 W=1.80u L=0.60u / nfet_05v0 W=1.80u L=0.60u
.subckt inv_dut_096 A Q VDD VSS
MMP Q A VDD VDD pfet_05v0 W=1.80u L=0.60u
MMN Q A VSS VSS nfet_05v0 W=1.80u L=0.60u
.ends

* inv_dut_097: pfet_05v0 W=3.60u L=0.60u / nfet_05v0 W=3.60u L=0.60u
.subckt inv_dut_097 A Q VDD VSS
MMP Q A VDD VDD pfet_05v0 W=3.60u L=0.60u
MMN Q A VSS VSS nfet_05v0 W=3.60u L=0.60u
.ends

.subckt inv_dut_098 A Q VDD VSS
.ends

* inv_dut_099: pfet_05v0 W=3.60u L=0.60u / nfet_05v0 W=1.80u L=0.60u
.subckt inv_dut_099 A Q VDD VSS
MMP Q A VDD VDD pfet_05v0 W=3.60u L=0.60u
MMN Q A VSS VSS nfet_05v0 W=1.80u L=0.60u
.ends

.subckt inv_dut_100 A Q VDD VSS
.ends

* inv_dut_101: pfet_05v0 W=10.80u L=0.60u / nfet_05v0 W=5.40u L=0.60u
.subckt inv_dut_101 A Q VDD VSS
MMP Q A VDD VDD pfet_05v0 W=10.80u L=0.60u
MMN Q A VSS VSS nfet_05v0 W=5.40u L=0.60u
.ends

* inv_dut_102: pfet_05v0 W=5.40u L=0.60u / nfet_05v0 W=1.80u L=0.60u
.subckt inv_dut_102 A Q VDD VSS
MMP Q A VDD VDD pfet_05v0 W=5.40u L=0.60u
MMN Q A VSS VSS nfet_05v0 W=1.80u L=0.60u
.ends

* inv_dut_103: pfet_05v0 W=10.80u L=0.60u / nfet_05v0 W=3.60u L=0.60u
.subckt inv_dut_103 A Q VDD VSS
MMP Q A VDD VDD pfet_05v0 W=10.80u L=0.60u
MMN Q A VSS VSS nfet_05v0 W=3.60u L=0.60u
.ends

* inv_dut_104: pfet_05v0 W=16.20u L=0.60u / nfet_05v0 W=5.40u L=0.60u
.subckt inv_dut_104 A Q VDD VSS
MMP Q A VDD VDD pfet_05v0 W=16.20u L=0.60u
MMN Q A VSS VSS nfet_05v0 W=5.40u L=0.60u
.ends

* inv_dut_105: pfet_05v0 W=3.60u L=1.20u / nfet_05v0 W=1.80u L=1.20u
.subckt inv_dut_105 A Q VDD VSS
MMP Q A VDD VDD pfet_05v0 W=3.60u L=1.20u
MMN Q A VSS VSS nfet_05v0 W=1.80u L=1.20u
.ends

* inv_dut_106: pfet_05v0 W=7.20u L=1.20u / nfet_05v0 W=3.60u L=1.20u
.subckt inv_dut_106 A Q VDD VSS
MMP Q A VDD VDD pfet_05v0 W=7.20u L=1.20u
MMN Q A VSS VSS nfet_05v0 W=3.60u L=1.20u
.ends

.subckt inv_dut_107 A Q VDD VSS
.ends

* inv_dut_108: pfet_05v0 W=5.40u L=1.20u / nfet_05v0 W=1.80u L=1.20u
.subckt inv_dut_108 A Q VDD VSS
MMP Q A VDD VDD pfet_05v0 W=5.40u L=1.20u
MMN Q A VSS VSS nfet_05v0 W=1.80u L=1.20u
.ends

* inv_dut_109: pfet_05v0 W=10.80u L=1.20u / nfet_05v0 W=3.60u L=1.20u
.subckt inv_dut_109 A Q VDD VSS
MMP Q A VDD VDD pfet_05v0 W=10.80u L=1.20u
MMN Q A VSS VSS nfet_05v0 W=3.60u L=1.20u
.ends

.subckt inv_dut_110 A Q VDD VSS
.ends

.subckt inv_dut_111 A Q VDD VSS
.ends

* inv_dut_112: pfet_03v3 W=0.90u L=0.30u / nfet_03v3 W=0.90u L=0.30u
.subckt inv_dut_112 A Q VDD VSS
MMP Q A VDD VDD pfet_03v3 W=0.90u L=0.30u
MMN Q A VSS VSS nfet_03v3 W=0.90u L=0.30u
.ends

* inv_dut_113: pfet_03v3 W=1.80u L=0.30u / nfet_03v3 W=1.80u L=0.30u
.subckt inv_dut_113 A Q VDD VSS
MMP Q A VDD VDD pfet_03v3 W=1.80u L=0.30u
MMN Q A VSS VSS nfet_03v3 W=1.80u L=0.30u
.ends

* inv_dut_114: pfet_03v3 W=3.60u L=0.30u / nfet_03v3 W=3.60u L=0.30u
.subckt inv_dut_114 A Q VDD VSS
MMP Q A VDD VDD pfet_03v3 W=3.60u L=0.30u
MMN Q A VSS VSS nfet_03v3 W=3.60u L=0.30u
.ends

.subckt inv_dut_115 A Q VDD VSS
.ends

* inv_dut_116: pfet_03v3 W=3.60u L=0.30u / nfet_03v3 W=1.80u L=0.30u
.subckt inv_dut_116 A Q VDD VSS
MMP Q A VDD VDD pfet_03v3 W=3.60u L=0.30u
MMN Q A VSS VSS nfet_03v3 W=1.80u L=0.30u
.ends

* inv_dut_117: pfet_03v3 W=5.40u L=0.30u / nfet_03v3 W=2.70u L=0.30u
.subckt inv_dut_117 A Q VDD VSS
MMP Q A VDD VDD pfet_03v3 W=5.40u L=0.30u
MMN Q A VSS VSS nfet_03v3 W=2.70u L=0.30u
.ends

.subckt inv_dut_118 A Q VDD VSS
.ends

* inv_dut_119: pfet_03v3 W=5.40u L=0.30u / nfet_03v3 W=1.80u L=0.30u
.subckt inv_dut_119 A Q VDD VSS
MMP Q A VDD VDD pfet_03v3 W=5.40u L=0.30u
MMN Q A VSS VSS nfet_03v3 W=1.80u L=0.30u
.ends

.subckt inv_dut_120 A Q VDD VSS
.ends

.subckt inv_dut_121 A Q VDD VSS
.ends

* inv_dut_122: pfet_03v3 W=3.60u L=0.60u / nfet_03v3 W=1.80u L=0.60u
.subckt inv_dut_122 A Q VDD VSS
MMP Q A VDD VDD pfet_03v3 W=3.60u L=0.60u
MMN Q A VSS VSS nfet_03v3 W=1.80u L=0.60u
.ends

* inv_dut_123: pfet_03v3 W=5.40u L=0.60u / nfet_03v3 W=2.70u L=0.60u
.subckt inv_dut_123 A Q VDD VSS
MMP Q A VDD VDD pfet_03v3 W=5.40u L=0.60u
MMN Q A VSS VSS nfet_03v3 W=2.70u L=0.60u
.ends

* inv_dut_124: pfet_03v3 W=2.70u L=0.60u / nfet_03v3 W=0.90u L=0.60u
.subckt inv_dut_124 A Q VDD VSS
MMP Q A VDD VDD pfet_03v3 W=2.70u L=0.60u
MMN Q A VSS VSS nfet_03v3 W=0.90u L=0.60u
.ends

* inv_dut_125: pfet_03v3 W=5.40u L=0.60u / nfet_03v3 W=1.80u L=0.60u
.subckt inv_dut_125 A Q VDD VSS
MMP Q A VDD VDD pfet_03v3 W=5.40u L=0.60u
MMN Q A VSS VSS nfet_03v3 W=1.80u L=0.60u
.ends

* inv_dut_126: pfet_03v3 W=8.10u L=0.60u / nfet_03v3 W=2.70u L=0.60u
.subckt inv_dut_126 A Q VDD VSS
MMP Q A VDD VDD pfet_03v3 W=8.10u L=0.60u
MMN Q A VSS VSS nfet_03v3 W=2.70u L=0.60u
.ends

.subckt inv_dut_127 A Q VDD VSS
.ends

.SUBCKT gf180mcu_fd_sc_mcu7t5v0__and2_1 A1 A2 Z VDD VNW VPW VSS
M_i_2 net_0 A1 Z_neg VPW nfet_05v0 W=3.65e-07 L=6e-07
M_i_3 VSS A2 net_0 VPW nfet_05v0 W=3.65e-07 L=6e-07
M_i_0 Z Z_neg VSS VPW nfet_05v0 W=8.15e-07 L=6e-07
M_i_4 Z_neg A1 VDD VNW pfet_05v0 W=6e-07 L=5e-07
M_i_5 VDD A2 Z_neg VNW pfet_05v0 W=6e-07 L=5e-07
M_i_1 Z Z_neg VDD VNW pfet_05v0 W=1.215e-06 L=5e-07
.ENDS

.SUBCKT gf180mcu_fd_sc_mcu7t5v0__and4_1 A1 A2 A3 A4 Z VDD VNW VPW VSS
M_i_2 net_0 A1 Z_neg VPW nfet_05v0 W=4.2e-07 L=6e-07
M_i_3 net_1 A2 net_0 VPW nfet_05v0 W=4.2e-07 L=6e-07
M_i_4 net_2 A3 net_1 VPW nfet_05v0 W=4.2e-07 L=6e-07
M_i_5 VSS A4 net_2 VPW nfet_05v0 W=4.2e-07 L=6e-07
M_i_0 Z Z_neg VSS VPW nfet_05v0 W=8.15e-07 L=6e-07
M_i_6 Z_neg A1 VDD VNW pfet_05v0 W=6e-07 L=5e-07
M_i_7 VDD A2 Z_neg VNW pfet_05v0 W=6e-07 L=5e-07
M_i_8 Z_neg A3 VDD VNW pfet_05v0 W=6e-07 L=5e-07
M_i_9 VDD A4 Z_neg VNW pfet_05v0 W=6e-07 L=5e-07
M_i_1 Z Z_neg VDD VNW pfet_05v0 W=1.22e-06 L=5e-07
.ENDS

.SUBCKT gf180mcu_fd_sc_mcu7t5v0__buf_1 I Z VDD VNW VPW VSS
M_i_2 VSS I Z_neg VPW nfet_05v0 W=3.6e-07 L=6e-07
M_i_0 Z Z_neg VSS VPW nfet_05v0 W=8.2e-07 L=6e-07
M_i_3 VDD I Z_neg VNW pfet_05v0 W=5.65e-07 L=5e-07
M_i_1 Z Z_neg VDD VNW pfet_05v0 W=1.22e-06 L=5e-07
.ENDS

.SUBCKT gf180mcu_fd_sc_mcu7t5v0__buf_2 I Z VDD VNW VPW VSS
M_i_2 VSS I Z_neg VPW nfet_05v0 W=8.2e-07 L=6e-07
M_i_0_0 Z Z_neg VSS VPW nfet_05v0 W=8.2e-07 L=6e-07
M_i_0_1 VSS Z_neg Z VPW nfet_05v0 W=8.2e-07 L=6e-07
M_i_3 VDD I Z_neg VNW pfet_05v0 W=1.22e-06 L=5e-07
M_i_1_0 Z Z_neg VDD VNW pfet_05v0 W=1.22e-06 L=5e-07
M_i_1_1 VDD Z_neg Z VNW pfet_05v0 W=1.22e-06 L=5e-07
.ENDS

.SUBCKT gf180mcu_fd_sc_mcu7t5v0__clkbuf_1 I Z VDD VNW VPW VSS
M_i_2 VSS I Z_neg VPW nfet_05v0 W=3.6e-07 L=6e-07
M_i_0 Z Z_neg VSS VPW nfet_05v0 W=4.95e-07 L=6e-07
* The device in the netlist is split in half, suggesting a two-fingered
* FET, which this is not.  Modified by Tim E. Nov. 3, 2025 to properly
* match the layout.
* M_i_3 VDD I Z_neg VNW pfet_05v0 W=5.25e-07 L=5e-07
* M_i_3_0 VDD I Z_neg VNW pfet_05v0 W=5.25e-07 L=5e-07
M_i_3 VDD I Z_neg VNW pfet_05v0 W=1.05e-06 L=5e-07
M_i_1 Z Z_neg VDD VNW pfet_05v0 W=1.22e-06 L=5e-07
.ENDS

.SUBCKT gf180mcu_fd_sc_mcu7t5v0__clkinv_1 I ZN VDD VNW VPW VSS
M_i_0 ZN I VSS VPW nfet_05v0 W=4.8e-07 L=6e-07
M_i_1 ZN I VDD VNW pfet_05v0 W=1.22e-06 L=5e-07
.ENDS

.SUBCKT gf180mcu_fd_sc_mcu7t5v0__dlyb_1 I Z VDD VNW VPW VSS
M_i_2_0 Z_neg I VSS VPW nfet_05v0 W=3.6e-07 L=6e-07
M_i_2 net_2 Z_neg net_1 VPW nfet_05v0 W=3.6e-07 L=6e-07
M_i_3 net_1 Z_neg VSS VPW nfet_05v0 W=3.6e-07 L=6e-07
M_i_2_21 net_3 net_2 net_6 VPW nfet_05v0 W=3.65e-07 L=0.600000U
M_i_3_6 net_6 net_2 VSS VPW nfet_05v0 W=3.65e-07 L=6e-07
M_i_2_0_18 Z net_3 VSS VPW nfet_05v0 W=8.2e-07 L=6e-07
M_i_3_0 Z_neg I VDD VNW pfet_05v0 W=3.6e-07 L=5e-07
M_i_0 net_0 Z_neg VDD VNW pfet_05v0 W=3.6e-07 L=5e-07
M_i_1 net_2 Z_neg net_0 VNW pfet_05v0 W=3.6e-07 L=5e-07
M_i_0_29 net_5 net_2 VDD VNW pfet_05v0 W=3.6e-07 L=5e-07
M_i_1_39 net_3 net_2 net_5 VNW pfet_05v0 W=3.6e-07 L=5e-07
M_i_3_0_0 Z net_3 VDD VNW pfet_05v0 W=1.22e-06 L=5e-07
.ENDS

.subckt gf180mcu_fd_sc_mcu7t5v0__endcap VDD VSS
.ends

.subckt gf180mcu_fd_sc_mcu7t5v0__fill_1 VDD VNW VPW VSS
.ends

.subckt gf180mcu_fd_sc_mcu7t5v0__fill_2 VDD VNW VPW VSS
.ends

.SUBCKT gf180mcu_fd_sc_mcu7t5v0__fillcap_16 VDD VNW VPW VSS
M_i_17 net_3 net_2 VSS VPW nfet_05v0 W=8.2e-07 L=1e-06
M_i_17_23 net_4 net_5 VSS VPW nfet_05v0 W=8.2e-07 L=1e-06
M_i_17_24 net_7 net_9 VSS VPW nfet_05v0 W=8.2e-07 L=1e-06
M_i_17_23_55 net_6 net_8 VSS VPW nfet_05v0 W=8.2e-07 L=1e-06
M_i_19 VDD net_3 net_2 VNW pfet_05v0 W=1.22e-06 L=1e-06
M_i_19_7 VDD net_4 net_5 VNW pfet_05v0 W=1.22e-06 L=1e-06
M_i_19_33 VDD net_7 net_9 VNW pfet_05v0 W=1.22e-06 L=1e-06
M_i_19_7_23 VDD net_6 net_8 VNW pfet_05v0 W=1.22e-06 L=1e-06
.ENDS

.SUBCKT gf180mcu_fd_sc_mcu7t5v0__fillcap_32 VDD VNW VPW VSS
M_i_17 net_3 net_2 VSS VPW nfet_05v0 W=8.2e-07 L=1e-06
M_i_17_23 net_4 net_5 VSS VPW nfet_05v0 W=8.2e-07 L=1e-06
M_i_17_24 net_7 net_9 VSS VPW nfet_05v0 W=8.2e-07 L=1e-06
M_i_17_23_55 net_6 net_8 VSS VPW nfet_05v0 W=8.2e-07 L=1e-06
M_i_17_27 net_17 net_14 VSS VPW nfet_05v0 W=8.2e-07 L=1e-06
M_i_17_23_63 net_16 net_15 VSS VPW nfet_05v0 W=8.2e-07 L=1e-06
M_i_17_24_22 net_13 net_11 VSS VPW nfet_05v0 W=8.2e-07 L=1e-06
M_i_17_23_55_93 net_12 net_10 VSS VPW nfet_05v0 W=8.2e-07 L=1e-06
M_i_19 VDD net_3 net_2 VNW pfet_05v0 W=1.22e-06 L=1e-06
M_i_19_7 VDD net_4 net_5 VNW pfet_05v0 W=1.22e-06 L=1e-06
M_i_19_33 VDD net_7 net_9 VNW pfet_05v0 W=1.22e-06 L=1e-06
M_i_19_7_23 VDD net_6 net_8 VNW pfet_05v0 W=1.22e-06 L=1e-06
M_i_19_94 VDD net_17 net_14 VNW pfet_05v0 W=1.22e-06 L=1e-06
M_i_19_7_87 VDD net_16 net_15 VNW pfet_05v0 W=1.22e-06 L=1e-06
M_i_19_33_95 VDD net_13 net_11 VNW pfet_05v0 W=1.22e-06 L=1e-06
M_i_19_7_23_23 VDD net_12 net_10 VNW pfet_05v0 W=1.22e-06 L=1e-06
.ENDS

.SUBCKT gf180mcu_fd_sc_mcu7t5v0__fillcap_4 VDD VNW VPW VSS
M_i_17 net_1 net_0 VSS VPW nfet_05v0 W=8.2e-07 L=1e-06
M_i_19 VDD net_1 net_0 VNW pfet_05v0 W=1.22e-06 L=1e-06
.ENDS

.SUBCKT gf180mcu_fd_sc_mcu7t5v0__fillcap_64 VDD VNW VPW VSS
M_i_17 net_3 net_2 VSS VPW nfet_05v0 W=8.2e-07 L=1e-06
M_i_17_23 net_4 net_5 VSS VPW nfet_05v0 W=8.2e-07 L=1e-06
M_i_17_24 net_7 net_9 VSS VPW nfet_05v0 W=8.2e-07 L=1e-06
M_i_17_23_55 net_6 net_8 VSS VPW nfet_05v0 W=8.2e-07 L=1e-06
M_i_17_27 net_17 net_14 VSS VPW nfet_05v0 W=8.2e-07 L=1e-06
M_i_17_23_63 net_16 net_15 VSS VPW nfet_05v0 W=8.2e-07 L=1e-06
M_i_17_24_22 net_13 net_11 VSS VPW nfet_05v0 W=8.2e-07 L=1e-06
M_i_17_23_55_93 net_12 net_10 VSS VPW nfet_05v0 W=8.2e-07 L=1e-06
M_i_17_20 net_30 net_26 VSS VPW nfet_05v0 W=8.2e-07 L=1e-06
M_i_17_23_59 net_25 net_20 VSS VPW nfet_05v0 W=8.2e-07 L=1e-06
M_i_17_24_135 net_23 net_28 VSS VPW nfet_05v0 W=8.2e-07 L=1e-06
M_i_17_23_55_90 net_33 net_18 VSS VPW nfet_05v0 W=8.2e-07 L=1e-06
M_i_17_27_139 net_31 net_29 VSS VPW nfet_05v0 W=8.2e-07 L=1e-06
M_i_17_23_63_82 net_32 net_24 VSS VPW nfet_05v0 W=8.2e-07 L=1e-06
M_i_17_24_22_30 net_22 net_27 VSS VPW nfet_05v0 W=8.2e-07 L=1e-06
M_i_17_23_55_93_110 net_19 net_21 VSS VPW nfet_05v0 W=8.2e-07 L=1e-06
M_i_19 VDD net_3 net_2 VNW pfet_05v0 W=1.22e-06 L=1e-06
M_i_19_7 VDD net_4 net_5 VNW pfet_05v0 W=1.22e-06 L=1e-06
M_i_19_33 VDD net_7 net_9 VNW pfet_05v0 W=1.22e-06 L=1e-06
M_i_19_7_23 VDD net_6 net_8 VNW pfet_05v0 W=1.22e-06 L=1e-06
M_i_19_94 VDD net_17 net_14 VNW pfet_05v0 W=1.22e-06 L=1e-06
M_i_19_7_87 VDD net_16 net_15 VNW pfet_05v0 W=1.22e-06 L=1e-06
M_i_19_33_95 VDD net_13 net_11 VNW pfet_05v0 W=1.22e-06 L=1e-06
M_i_19_7_23_23 VDD net_12 net_10 VNW pfet_05v0 W=1.22e-06 L=1e-06
M_i_19_95 VDD net_30 net_26 VNW pfet_05v0 W=1.22e-06 L=1e-06
M_i_19_7_188 VDD net_25 net_20 VNW pfet_05v0 W=1.22e-06 L=1e-06
M_i_19_33_98 VDD net_23 net_28 VNW pfet_05v0 W=1.22e-06 L=1e-06
M_i_19_7_23_16 VDD net_33 net_18 VNW pfet_05v0 W=1.22e-06 L=1e-06
M_i_19_94_91 VDD net_31 net_29 VNW pfet_05v0 W=1.22e-06 L=1e-06
M_i_19_7_87_65 VDD net_32 net_24 VNW pfet_05v0 W=1.22e-06 L=1e-06
M_i_19_33_95_109 VDD net_22 net_27 VNW pfet_05v0 W=1.22e-06 L=1e-06
M_i_19_7_23_23_99 VDD net_19 net_21 VNW pfet_05v0 W=1.22e-06 L=1e-06
.ENDS

.SUBCKT gf180mcu_fd_sc_mcu7t5v0__fillcap_8 VDD VNW VPW VSS
M_i_17 net_3 net_2 VSS VPW nfet_05v0 W=8.2e-07 L=1e-06
M_i_17_23 net_4 net_5 VSS VPW nfet_05v0 W=8.2e-07 L=1e-06
M_i_19 VDD net_3 net_2 VNW pfet_05v0 W=1.22e-06 L=1e-06
M_i_19_7 VDD net_4 net_5 VNW pfet_05v0 W=1.22e-06 L=1e-06
.ENDS

.subckt gf180mcu_fd_sc_mcu7t5v0__filltie VDD VSS
.ends

.SUBCKT gf180mcu_fd_sc_mcu7t5v0__nand2_1 A1 A2 ZN VDD VNW VPW VSS
M_i_1 net_0 A2 VSS VPW nfet_05v0 W=8.2e-07 L=6e-07
M_i_0 ZN A1 net_0 VPW nfet_05v0 W=8.2e-07 L=6e-07
M_i_3 ZN A2 VDD VNW pfet_05v0 W=1.13e-06 L=5e-07
M_i_2 VDD A1 ZN VNW pfet_05v0 W=1.13e-06 L=5e-07
.ENDS

.SUBCKT gf180mcu_fd_sc_mcu7t5v0__nand3_1 A1 A2 A3 ZN VDD VNW VPW VSS
M_i_2 net_1 A3 VSS VPW nfet_05v0 W=8.2e-07 L=6e-07
M_i_1 net_0 A2 net_1 VPW nfet_05v0 W=8.2e-07 L=6e-07
M_i_0 ZN A1 net_0 VPW nfet_05v0 W=8.2e-07 L=6e-07
M_i_5 ZN A3 VDD VNW pfet_05v0 W=9.85e-07 L=5e-07
M_i_4 VDD A2 ZN VNW pfet_05v0 W=9.85e-07 L=5e-07
M_i_3 ZN A1 VDD VNW pfet_05v0 W=9.85e-07 L=5e-07
.ENDS

.SUBCKT gf180mcu_fd_sc_mcu7t5v0__nand4_1 A1 A2 A3 A4 ZN VDD VNW VPW VSS
M_i_3 net_2 A4 VSS VPW nfet_05v0 W=8.2e-07 L=6e-07
M_i_2 net_1 A3 net_2 VPW nfet_05v0 W=8.2e-07 L=6e-07
M_i_1 net_0 A2 net_1 VPW nfet_05v0 W=8.2e-07 L=6e-07
M_i_0 ZN A1 net_0 VPW nfet_05v0 W=8.2e-07 L=6e-07
M_i_7 ZN A4 VDD VNW pfet_05v0 W=8.45e-07 L=5e-07
M_i_6 VDD A3 ZN VNW pfet_05v0 W=8.45e-07 L=5e-07
M_i_5 ZN A2 VDD VNW pfet_05v0 W=8.45e-07 L=5e-07
M_i_4 VDD A1 ZN VNW pfet_05v0 W=8.45e-07 L=5e-07
.ENDS

.SUBCKT gf180mcu_fd_sc_mcu7t5v0__nor2_1 A1 A2 ZN VDD VNW VPW VSS
M_i_1 ZN A2 VSS VPW nfet_05v0 W=5.65e-07 L=6e-07
M_i_0 VSS A1 ZN VPW nfet_05v0 W=5.65e-07 L=6e-07
M_i_3 net_0 A2 VDD VNW pfet_05v0 W=1.22e-06 L=5e-07
M_i_2 ZN A1 net_0 VNW pfet_05v0 W=1.22e-06 L=5e-07
.ENDS

.SUBCKT gf180mcu_fd_sc_mcu7t5v0__nor3_1 A1 A2 A3 ZN VDD VNW VPW VSS
M_i_2 ZN A3 VSS VPW nfet_05v0 W=4.65e-07 L=6e-07
M_i_1 VSS A2 ZN VPW nfet_05v0 W=4.65e-07 L=6e-07
M_i_0 ZN A1 VSS VPW nfet_05v0 W=4.65e-07 L=6e-07
M_i_5 net_1 A3 VDD VNW pfet_05v0 W=1.22e-06 L=5e-07
M_i_4 net_0 A2 net_1 VNW pfet_05v0 W=1.22e-06 L=5e-07
M_i_3 ZN A1 net_0 VNW pfet_05v0 W=1.22e-06 L=5e-07
.ENDS

.SUBCKT gf180mcu_fd_sc_mcu7t5v0__nor4_1 A1 A2 A3 A4 ZN VDD VNW VPW VSS
M_i_3 ZN A4 VSS VPW nfet_05v0 W=3.6e-07 L=6e-07
M_i_2 VSS A3 ZN VPW nfet_05v0 W=3.6e-07 L=6e-07
M_i_1 ZN A2 VSS VPW nfet_05v0 W=3.6e-07 L=6e-07
M_i_0 VSS A1 ZN VPW nfet_05v0 W=3.6e-07 L=6e-07
M_i_7 net_2 A4 VDD VNW pfet_05v0 W=1.22e-06 L=5e-07
M_i_6 net_1 A3 net_2 VNW pfet_05v0 W=1.22e-06 L=5e-07
M_i_5 net_0 A2 net_1 VNW pfet_05v0 W=1.22e-06 L=5e-07
M_i_4 ZN A1 net_0 VNW pfet_05v0 W=1.22e-06 L=5e-07
.ENDS

.SUBCKT gf180mcu_fd_sc_mcu7t5v0__or4_1 A1 A2 A3 A4 Z VDD VNW VPW VSS
M_i_2 Z_neg A1 VSS VPW nfet_05v0 W=3.6e-07 L=6e-07
M_i_3 VSS A2 Z_neg VPW nfet_05v0 W=3.6e-07 L=6e-07
M_i_4 Z_neg A3 VSS VPW nfet_05v0 W=3.6e-07 L=6e-07
M_i_5 VSS A4 Z_neg VPW nfet_05v0 W=3.6e-07 L=6e-07
M_i_0 Z Z_neg VSS VPW nfet_05v0 W=8.2e-07 L=6e-07
M_i_6 net_0 A1 Z_neg VNW pfet_05v0 W=5.6e-07 L=5e-07
M_i_7 net_1 A2 net_0 VNW pfet_05v0 W=5.6e-07 L=5e-07
M_i_8 net_2 A3 net_1 VNW pfet_05v0 W=5.6e-07 L=5e-07
M_i_9 VDD A4 net_2 VNW pfet_05v0 W=5.6e-07 L=5e-07
M_i_1 Z Z_neg VDD VNW pfet_05v0 W=1.22e-06 L=5e-07
.ENDS

.subckt workshop_inverter VCTRL VCO_EN D[0] D[1] D[2] D[3] D[4] D[5] D[6] IN OUT FOUT VDD_INV VDD_DEC VSS
X0_VCO VCTRL VCO_EN IN OUT FOUT MIN VDD_DEC VSS MOUT VDD_INV vco_only
X0_DEC VDD_DEC VSS D[0] D[1] D[2] D[3] D[4] D[5] D[6] SEL[0] SEL[100] SEL[101] SEL[102] SEL[103] SEL[104] SEL[105] SEL[106] SEL[107] SEL[108] SEL[109] SEL[10] SEL[110] SEL[111] SEL[112] SEL[113] SEL[114] SEL[115] SEL[116] SEL[117] SEL[118] SEL[119] SEL[11] SEL[120] SEL[121] SEL[122] SEL[123] SEL[124] SEL[125] SEL[126] SEL[127] SEL[12] SEL[13] SEL[14] SEL[15] SEL[16] SEL[17] SEL[18] SEL[19] SEL[1] SEL[20] SEL[21] SEL[22] SEL[23] SEL[24] SEL[25] SEL[26] SEL[27] SEL[28] SEL[29] SEL[2] SEL[30] SEL[31] SEL[32] SEL[33] SEL[34] SEL[35] SEL[36] SEL[37] SEL[38] SEL[39] SEL[3] SEL[40] SEL[41] SEL[42] SEL[43] SEL[44] SEL[45] SEL[46] SEL[47] SEL[48] SEL[49] SEL[4] SEL[50] SEL[51] SEL[52] SEL[53] SEL[54] SEL[55] SEL[56] SEL[57] SEL[58] SEL[59] SEL[5] SEL[60] SEL[61] SEL[62] SEL[63] SEL[64] SEL[65] SEL[66] SEL[67] SEL[68] SEL[69] SEL[6] SEL[70] SEL[71] SEL[72] SEL[73] SEL[74] SEL[75] SEL[76] SEL[77] SEL[78] SEL[79] SEL[7] SEL[80] SEL[81] SEL[82] SEL[83] SEL[84] SEL[85] SEL[86] SEL[87] SEL[88] SEL[89] SEL[8] SEL[90] SEL[91] SEL[92] SEL[93] SEL[94] SEL[95] SEL[96] SEL[97] SEL[98] SEL[99] SEL[9] decoder_7to128
DANT0 VSS D[0] diode_nw2ps_06v0 A='1.4u * 1.2u ' P='2*1.4u + 2*1.2u '
DANT1 VSS D[1] diode_nw2ps_06v0 A='1.4u * 1.2u ' P='2*1.4u + 2*1.2u '
DANT2 VSS D[2] diode_nw2ps_06v0 A='1.4u * 1.2u ' P='2*1.4u + 2*1.2u '
DANT3 VSS D[3] diode_nw2ps_06v0 A='1.4u * 1.2u ' P='2*1.4u + 2*1.2u '
DANT4 VSS D[4] diode_nw2ps_06v0 A='1.4u * 1.2u ' P='2*1.4u + 2*1.2u '
DANT5 VSS D[5] diode_nw2ps_06v0 A='1.4u * 1.2u ' P='2*1.4u + 2*1.2u '
DANT6 VSS D[6] diode_nw2ps_06v0 A='1.4u * 1.2u ' P='2*1.4u + 2*1.2u '
X0_TGI000 MIN SEL[0] VDD_DEC VSS DIN000 tgate_5v0_in
X0_TGO000 MOUT SEL[0] VDD_DEC VSS DOUT000 tgate_5v0_out
X0_DUT000 DIN000 DOUT000 VDD_INV VSS inv_dut_000
X0_TGI001 MIN SEL[1] VDD_DEC VSS DIN001 tgate_5v0_in
X0_TGO001 MOUT SEL[1] VDD_DEC VSS DOUT001 tgate_5v0_out
X0_DUT001 DIN001 DOUT001 VDD_INV VSS inv_dut_001
X0_TGI002 MIN SEL[2] VDD_DEC VSS DIN002 tgate_5v0_in
X0_TGO002 MOUT SEL[2] VDD_DEC VSS DOUT002 tgate_5v0_out
X0_DUT002 DIN002 DOUT002 VDD_INV VSS inv_dut_002
X0_TGI003 MIN SEL[3] VDD_DEC VSS DIN003 tgate_5v0_in
X0_TGO003 MOUT SEL[3] VDD_DEC VSS DOUT003 tgate_5v0_out
X0_DUT003 DIN003 DOUT003 VDD_INV VSS inv_dut_003
X0_TGI004 MIN SEL[4] VDD_DEC VSS DIN004 tgate_5v0_in
X0_TGO004 MOUT SEL[4] VDD_DEC VSS DOUT004 tgate_5v0_out
X0_DUT004 DIN004 DOUT004 VDD_INV VSS inv_dut_004
X0_TGI005 MIN SEL[5] VDD_DEC VSS DIN005 tgate_5v0_in
X0_TGO005 MOUT SEL[5] VDD_DEC VSS DOUT005 tgate_5v0_out
X0_DUT005 DIN005 DOUT005 VDD_INV VSS inv_dut_005
X0_TGI006 MIN SEL[6] VDD_DEC VSS DIN006 tgate_5v0_in
X0_TGO006 MOUT SEL[6] VDD_DEC VSS DOUT006 tgate_5v0_out
X0_DUT006 DIN006 DOUT006 VDD_INV VSS inv_dut_006
X0_TGI007 MIN SEL[7] VDD_DEC VSS DIN007 tgate_5v0_in
X0_TGO007 MOUT SEL[7] VDD_DEC VSS DOUT007 tgate_5v0_out
X0_DUT007 DIN007 DOUT007 VDD_INV VSS inv_dut_007
X0_TGI008 MIN SEL[8] VDD_DEC VSS DIN008 tgate_5v0_in
X0_TGO008 MOUT SEL[8] VDD_DEC VSS DOUT008 tgate_5v0_out
X0_DUT008 DIN008 DOUT008 VDD_INV VSS inv_dut_008
X0_TGI009 MIN SEL[9] VDD_DEC VSS DIN009 tgate_5v0_in
X0_TGO009 MOUT SEL[9] VDD_DEC VSS DOUT009 tgate_5v0_out
X0_DUT009 DIN009 DOUT009 VDD_INV VSS inv_dut_009
X0_TGI010 MIN SEL[10] VDD_DEC VSS DIN010 tgate_5v0_in
X0_TGO010 MOUT SEL[10] VDD_DEC VSS DOUT010 tgate_5v0_out
X0_DUT010 DIN010 DOUT010 VDD_INV VSS inv_dut_010
X0_TGI011 MIN SEL[11] VDD_DEC VSS DIN011 tgate_5v0_in
X0_TGO011 MOUT SEL[11] VDD_DEC VSS DOUT011 tgate_5v0_out
X0_DUT011 DIN011 DOUT011 VDD_INV VSS inv_dut_011
X0_TGI012 MIN SEL[12] VDD_DEC VSS DIN012 tgate_5v0_in
X0_TGO012 MOUT SEL[12] VDD_DEC VSS DOUT012 tgate_5v0_out
X0_DUT012 DIN012 DOUT012 VDD_INV VSS inv_dut_012
X0_TGI013 MIN SEL[13] VDD_DEC VSS DIN013 tgate_5v0_in
X0_TGO013 MOUT SEL[13] VDD_DEC VSS DOUT013 tgate_5v0_out
X0_DUT013 DIN013 DOUT013 VDD_INV VSS inv_dut_013
X0_TGI014 MIN SEL[14] VDD_DEC VSS DIN014 tgate_5v0_in
X0_TGO014 MOUT SEL[14] VDD_DEC VSS DOUT014 tgate_5v0_out
X0_DUT014 DIN014 DOUT014 VDD_INV VSS inv_dut_014
X0_TGI015 MIN SEL[15] VDD_DEC VSS DIN015 tgate_5v0_in
X0_TGO015 MOUT SEL[15] VDD_DEC VSS DOUT015 tgate_5v0_out
X0_DUT015 DIN015 DOUT015 VDD_INV VSS inv_dut_015
X0_TGI016 MIN SEL[16] VDD_DEC VSS DIN016 tgate_5v0_in
X0_TGO016 MOUT SEL[16] VDD_DEC VSS DOUT016 tgate_5v0_out
X0_DUT016 DIN016 DOUT016 VDD_INV VSS inv_dut_016
X0_TGI017 MIN SEL[17] VDD_DEC VSS DIN017 tgate_5v0_in
X0_TGO017 MOUT SEL[17] VDD_DEC VSS DOUT017 tgate_5v0_out
X0_DUT017 DIN017 DOUT017 VDD_INV VSS inv_dut_017
X0_TGI018 MIN SEL[18] VDD_DEC VSS DIN018 tgate_5v0_in
X0_TGO018 MOUT SEL[18] VDD_DEC VSS DOUT018 tgate_5v0_out
X0_DUT018 DIN018 DOUT018 VDD_INV VSS inv_dut_018
X0_TGI019 MIN SEL[19] VDD_DEC VSS DIN019 tgate_5v0_in
X0_TGO019 MOUT SEL[19] VDD_DEC VSS DOUT019 tgate_5v0_out
X0_DUT019 DIN019 DOUT019 VDD_INV VSS inv_dut_019
X0_TGI020 MIN SEL[20] VDD_DEC VSS DIN020 tgate_5v0_in
X0_TGO020 MOUT SEL[20] VDD_DEC VSS DOUT020 tgate_5v0_out
X0_DUT020 DIN020 DOUT020 VDD_INV VSS inv_dut_020
X0_TGI021 MIN SEL[21] VDD_DEC VSS DIN021 tgate_5v0_in
X0_TGO021 MOUT SEL[21] VDD_DEC VSS DOUT021 tgate_5v0_out
X0_DUT021 DIN021 DOUT021 VDD_INV VSS inv_dut_021
X0_TGI022 MIN SEL[22] VDD_DEC VSS DIN022 tgate_5v0_in
X0_TGO022 MOUT SEL[22] VDD_DEC VSS DOUT022 tgate_5v0_out
X0_DUT022 DIN022 DOUT022 VDD_INV VSS inv_dut_022
X0_TGI023 MIN SEL[23] VDD_DEC VSS DIN023 tgate_5v0_in
X0_TGO023 MOUT SEL[23] VDD_DEC VSS DOUT023 tgate_5v0_out
X0_DUT023 DIN023 DOUT023 VDD_INV VSS inv_dut_023
X0_TGI024 MIN SEL[24] VDD_DEC VSS DIN024 tgate_5v0_in
X0_TGO024 MOUT SEL[24] VDD_DEC VSS DOUT024 tgate_5v0_out
X0_DUT024 DIN024 DOUT024 VDD_INV VSS inv_dut_024
X0_TGI025 MIN SEL[25] VDD_DEC VSS DIN025 tgate_5v0_in
X0_TGO025 MOUT SEL[25] VDD_DEC VSS DOUT025 tgate_5v0_out
X0_DUT025 DIN025 DOUT025 VDD_INV VSS inv_dut_025
X0_TGI026 MIN SEL[26] VDD_DEC VSS DIN026 tgate_5v0_in
X0_TGO026 MOUT SEL[26] VDD_DEC VSS DOUT026 tgate_5v0_out
X0_DUT026 DIN026 DOUT026 VDD_INV VSS inv_dut_026
X0_TGI027 MIN SEL[27] VDD_DEC VSS DIN027 tgate_5v0_in
X0_TGO027 MOUT SEL[27] VDD_DEC VSS DOUT027 tgate_5v0_out
X0_DUT027 DIN027 DOUT027 VDD_INV VSS inv_dut_027
X0_TGI028 MIN SEL[28] VDD_DEC VSS DIN028 tgate_5v0_in
X0_TGO028 MOUT SEL[28] VDD_DEC VSS DOUT028 tgate_5v0_out
X0_DUT028 DIN028 DOUT028 VDD_INV VSS inv_dut_028
X0_TGI029 MIN SEL[29] VDD_DEC VSS DIN029 tgate_5v0_in
X0_TGO029 MOUT SEL[29] VDD_DEC VSS DOUT029 tgate_5v0_out
X0_DUT029 DIN029 DOUT029 VDD_INV VSS inv_dut_029
X0_TGI030 MIN SEL[30] VDD_DEC VSS DIN030 tgate_5v0_in
X0_TGO030 MOUT SEL[30] VDD_DEC VSS DOUT030 tgate_5v0_out
X0_DUT030 DIN030 DOUT030 VDD_INV VSS inv_dut_030
X0_TGI031 MIN SEL[31] VDD_DEC VSS DIN031 tgate_5v0_in
X0_TGO031 MOUT SEL[31] VDD_DEC VSS DOUT031 tgate_5v0_out
X0_DUT031 DIN031 DOUT031 VDD_INV VSS inv_dut_031
X0_TGI032 MIN SEL[32] VDD_DEC VSS DIN032 tgate_5v0_in
X0_TGO032 MOUT SEL[32] VDD_DEC VSS DOUT032 tgate_5v0_out
X0_DUT032 DIN032 DOUT032 VDD_INV VSS inv_dut_032
X0_TGI033 MIN SEL[33] VDD_DEC VSS DIN033 tgate_5v0_in
X0_TGO033 MOUT SEL[33] VDD_DEC VSS DOUT033 tgate_5v0_out
X0_DUT033 DIN033 DOUT033 VDD_INV VSS inv_dut_033
X0_TGI034 MIN SEL[34] VDD_DEC VSS DIN034 tgate_5v0_in
X0_TGO034 MOUT SEL[34] VDD_DEC VSS DOUT034 tgate_5v0_out
X0_DUT034 DIN034 DOUT034 VDD_INV VSS inv_dut_034
X0_TGI035 MIN SEL[35] VDD_DEC VSS DIN035 tgate_5v0_in
X0_TGO035 MOUT SEL[35] VDD_DEC VSS DOUT035 tgate_5v0_out
X0_DUT035 DIN035 DOUT035 VDD_INV VSS inv_dut_035
X0_TGI036 MIN SEL[36] VDD_DEC VSS DIN036 tgate_5v0_in
X0_TGO036 MOUT SEL[36] VDD_DEC VSS DOUT036 tgate_5v0_out
X0_DUT036 DIN036 DOUT036 VDD_INV VSS inv_dut_036
X0_TGI037 MIN SEL[37] VDD_DEC VSS DIN037 tgate_5v0_in
X0_TGO037 MOUT SEL[37] VDD_DEC VSS DOUT037 tgate_5v0_out
X0_DUT037 DIN037 DOUT037 VDD_INV VSS inv_dut_037
X0_TGI038 MIN SEL[38] VDD_DEC VSS DIN038 tgate_5v0_in
X0_TGO038 MOUT SEL[38] VDD_DEC VSS DOUT038 tgate_5v0_out
X0_DUT038 DIN038 DOUT038 VDD_INV VSS inv_dut_038
X0_TGI039 MIN SEL[39] VDD_DEC VSS DIN039 tgate_5v0_in
X0_TGO039 MOUT SEL[39] VDD_DEC VSS DOUT039 tgate_5v0_out
X0_DUT039 DIN039 DOUT039 VDD_INV VSS inv_dut_039
X0_TGI040 MIN SEL[40] VDD_DEC VSS DIN040 tgate_5v0_in
X0_TGO040 MOUT SEL[40] VDD_DEC VSS DOUT040 tgate_5v0_out
X0_DUT040 DIN040 DOUT040 VDD_INV VSS inv_dut_040
X0_TGI041 MIN SEL[41] VDD_DEC VSS DIN041 tgate_5v0_in
X0_TGO041 MOUT SEL[41] VDD_DEC VSS DOUT041 tgate_5v0_out
X0_DUT041 DIN041 DOUT041 VDD_INV VSS inv_dut_041
X0_TGI042 MIN SEL[42] VDD_DEC VSS DIN042 tgate_5v0_in
X0_TGO042 MOUT SEL[42] VDD_DEC VSS DOUT042 tgate_5v0_out
X0_DUT042 DIN042 DOUT042 VDD_INV VSS inv_dut_042
X0_TGI043 MIN SEL[43] VDD_DEC VSS DIN043 tgate_5v0_in
X0_TGO043 MOUT SEL[43] VDD_DEC VSS DOUT043 tgate_5v0_out
X0_DUT043 DIN043 DOUT043 VDD_INV VSS inv_dut_043
X0_TGI044 MIN SEL[44] VDD_DEC VSS DIN044 tgate_5v0_in
X0_TGO044 MOUT SEL[44] VDD_DEC VSS DOUT044 tgate_5v0_out
X0_DUT044 DIN044 DOUT044 VDD_INV VSS inv_dut_044
X0_TGI045 MIN SEL[45] VDD_DEC VSS DIN045 tgate_5v0_in
X0_TGO045 MOUT SEL[45] VDD_DEC VSS DOUT045 tgate_5v0_out
X0_DUT045 DIN045 DOUT045 VDD_INV VSS inv_dut_045
X0_TGI046 MIN SEL[46] VDD_DEC VSS DIN046 tgate_5v0_in
X0_TGO046 MOUT SEL[46] VDD_DEC VSS DOUT046 tgate_5v0_out
X0_DUT046 DIN046 DOUT046 VDD_INV VSS inv_dut_046
X0_TGI047 MIN SEL[47] VDD_DEC VSS DIN047 tgate_5v0_in
X0_TGO047 MOUT SEL[47] VDD_DEC VSS DOUT047 tgate_5v0_out
X0_DUT047 DIN047 DOUT047 VDD_INV VSS inv_dut_047
X0_TGI048 MIN SEL[48] VDD_DEC VSS DIN048 tgate_5v0_in
X0_TGO048 MOUT SEL[48] VDD_DEC VSS DOUT048 tgate_5v0_out
X0_DUT048 DIN048 DOUT048 VDD_INV VSS inv_dut_048
X0_TGI049 MIN SEL[49] VDD_DEC VSS DIN049 tgate_5v0_in
X0_TGO049 MOUT SEL[49] VDD_DEC VSS DOUT049 tgate_5v0_out
X0_DUT049 DIN049 DOUT049 VDD_INV VSS inv_dut_049
X0_TGI050 MIN SEL[50] VDD_DEC VSS DIN050 tgate_5v0_in
X0_TGO050 MOUT SEL[50] VDD_DEC VSS DOUT050 tgate_5v0_out
X0_DUT050 DIN050 DOUT050 VDD_INV VSS inv_dut_050
X0_TGI051 MIN SEL[51] VDD_DEC VSS DIN051 tgate_5v0_in
X0_TGO051 MOUT SEL[51] VDD_DEC VSS DOUT051 tgate_5v0_out
X0_DUT051 DIN051 DOUT051 VDD_INV VSS inv_dut_051
X0_TGI052 MIN SEL[52] VDD_DEC VSS DIN052 tgate_5v0_in
X0_TGO052 MOUT SEL[52] VDD_DEC VSS DOUT052 tgate_5v0_out
X0_DUT052 DIN052 DOUT052 VDD_INV VSS inv_dut_052
X0_TGI053 MIN SEL[53] VDD_DEC VSS DIN053 tgate_5v0_in
X0_TGO053 MOUT SEL[53] VDD_DEC VSS DOUT053 tgate_5v0_out
X0_DUT053 DIN053 DOUT053 VDD_INV VSS inv_dut_053
X0_TGI054 MIN SEL[54] VDD_DEC VSS DIN054 tgate_5v0_in
X0_TGO054 MOUT SEL[54] VDD_DEC VSS DOUT054 tgate_5v0_out
X0_DUT054 DIN054 DOUT054 VDD_INV VSS inv_dut_054
X0_TGI055 MIN SEL[55] VDD_DEC VSS DIN055 tgate_5v0_in
X0_TGO055 MOUT SEL[55] VDD_DEC VSS DOUT055 tgate_5v0_out
X0_DUT055 DIN055 DOUT055 VDD_INV VSS inv_dut_055
X0_TGI056 MIN SEL[56] VDD_DEC VSS DIN056 tgate_5v0_in
X0_TGO056 MOUT SEL[56] VDD_DEC VSS DOUT056 tgate_5v0_out
X0_DUT056 DIN056 DOUT056 VDD_INV VSS inv_dut_056
X0_TGI057 MIN SEL[57] VDD_DEC VSS DIN057 tgate_5v0_in
X0_TGO057 MOUT SEL[57] VDD_DEC VSS DOUT057 tgate_5v0_out
X0_DUT057 DIN057 DOUT057 VDD_INV VSS inv_dut_057
X0_TGI058 MIN SEL[58] VDD_DEC VSS DIN058 tgate_5v0_in
X0_TGO058 MOUT SEL[58] VDD_DEC VSS DOUT058 tgate_5v0_out
X0_DUT058 DIN058 DOUT058 VDD_INV VSS inv_dut_058
X0_TGI059 MIN SEL[59] VDD_DEC VSS DIN059 tgate_5v0_in
X0_TGO059 MOUT SEL[59] VDD_DEC VSS DOUT059 tgate_5v0_out
X0_DUT059 DIN059 DOUT059 VDD_INV VSS inv_dut_059
X0_TGI060 MIN SEL[60] VDD_DEC VSS DIN060 tgate_5v0_in
X0_TGO060 MOUT SEL[60] VDD_DEC VSS DOUT060 tgate_5v0_out
X0_DUT060 DIN060 DOUT060 VDD_INV VSS inv_dut_060
X0_TGI061 MIN SEL[61] VDD_DEC VSS DIN061 tgate_5v0_in
X0_TGO061 MOUT SEL[61] VDD_DEC VSS DOUT061 tgate_5v0_out
X0_DUT061 DIN061 DOUT061 VDD_INV VSS inv_dut_061
X0_TGI062 MIN SEL[62] VDD_DEC VSS DIN062 tgate_5v0_in
X0_TGO062 MOUT SEL[62] VDD_DEC VSS DOUT062 tgate_5v0_out
X0_DUT062 DIN062 DOUT062 VDD_INV VSS inv_dut_062
X0_TGI063 MIN SEL[63] VDD_DEC VSS DIN063 tgate_5v0_in
X0_TGO063 MOUT SEL[63] VDD_DEC VSS DOUT063 tgate_5v0_out
X0_DUT063 DIN063 DOUT063 VDD_INV VSS inv_dut_063
X0_TGI064 MIN SEL[64] VDD_DEC VSS DIN064 tgate_5v0_in
X0_TGO064 MOUT SEL[64] VDD_DEC VSS DOUT064 tgate_5v0_out
X0_DUT064 DIN064 DOUT064 VDD_INV VSS inv_dut_064
X0_TGI065 MIN SEL[65] VDD_DEC VSS DIN065 tgate_5v0_in
X0_TGO065 MOUT SEL[65] VDD_DEC VSS DOUT065 tgate_5v0_out
X0_DUT065 DIN065 DOUT065 VDD_INV VSS inv_dut_065
X0_TGI066 MIN SEL[66] VDD_DEC VSS DIN066 tgate_5v0_in
X0_TGO066 MOUT SEL[66] VDD_DEC VSS DOUT066 tgate_5v0_out
X0_DUT066 DIN066 DOUT066 VDD_INV VSS inv_dut_066
X0_TGI067 MIN SEL[67] VDD_DEC VSS DIN067 tgate_5v0_in
X0_TGO067 MOUT SEL[67] VDD_DEC VSS DOUT067 tgate_5v0_out
X0_DUT067 DIN067 DOUT067 VDD_INV VSS inv_dut_067
X0_TGI068 MIN SEL[68] VDD_DEC VSS DIN068 tgate_5v0_in
X0_TGO068 MOUT SEL[68] VDD_DEC VSS DOUT068 tgate_5v0_out
X0_DUT068 DIN068 DOUT068 VDD_INV VSS inv_dut_068
X0_TGI069 MIN SEL[69] VDD_DEC VSS DIN069 tgate_5v0_in
X0_TGO069 MOUT SEL[69] VDD_DEC VSS DOUT069 tgate_5v0_out
X0_DUT069 DIN069 DOUT069 VDD_INV VSS inv_dut_069
X0_TGI070 MIN SEL[70] VDD_DEC VSS DIN070 tgate_5v0_in
X0_TGO070 MOUT SEL[70] VDD_DEC VSS DOUT070 tgate_5v0_out
X0_DUT070 DIN070 DOUT070 VDD_INV VSS inv_dut_070
X0_TGI071 MIN SEL[71] VDD_DEC VSS DIN071 tgate_5v0_in
X0_TGO071 MOUT SEL[71] VDD_DEC VSS DOUT071 tgate_5v0_out
X0_DUT071 DIN071 DOUT071 VDD_INV VSS inv_dut_071
X0_TGI072 MIN SEL[72] VDD_DEC VSS DIN072 tgate_5v0_in
X0_TGO072 MOUT SEL[72] VDD_DEC VSS DOUT072 tgate_5v0_out
X0_DUT072 DIN072 DOUT072 VDD_INV VSS inv_dut_072
X0_TGI073 MIN SEL[73] VDD_DEC VSS DIN073 tgate_5v0_in
X0_TGO073 MOUT SEL[73] VDD_DEC VSS DOUT073 tgate_5v0_out
X0_DUT073 DIN073 DOUT073 VDD_INV VSS inv_dut_073
X0_TGI074 MIN SEL[74] VDD_DEC VSS DIN074 tgate_5v0_in
X0_TGO074 MOUT SEL[74] VDD_DEC VSS DOUT074 tgate_5v0_out
X0_DUT074 DIN074 DOUT074 VDD_INV VSS inv_dut_074
X0_TGI075 MIN SEL[75] VDD_DEC VSS DIN075 tgate_5v0_in
X0_TGO075 MOUT SEL[75] VDD_DEC VSS DOUT075 tgate_5v0_out
X0_DUT075 DIN075 DOUT075 VDD_INV VSS inv_dut_075
X0_TGI076 MIN SEL[76] VDD_DEC VSS DIN076 tgate_5v0_in
X0_TGO076 MOUT SEL[76] VDD_DEC VSS DOUT076 tgate_5v0_out
X0_DUT076 DIN076 DOUT076 VDD_INV VSS inv_dut_076
X0_TGI077 MIN SEL[77] VDD_DEC VSS DIN077 tgate_5v0_in
X0_TGO077 MOUT SEL[77] VDD_DEC VSS DOUT077 tgate_5v0_out
X0_DUT077 DIN077 DOUT077 VDD_INV VSS inv_dut_077
X0_TGI078 MIN SEL[78] VDD_DEC VSS DIN078 tgate_5v0_in
X0_TGO078 MOUT SEL[78] VDD_DEC VSS DOUT078 tgate_5v0_out
X0_DUT078 DIN078 DOUT078 VDD_INV VSS inv_dut_078
X0_TGI079 MIN SEL[79] VDD_DEC VSS DIN079 tgate_5v0_in
X0_TGO079 MOUT SEL[79] VDD_DEC VSS DOUT079 tgate_5v0_out
X0_DUT079 DIN079 DOUT079 VDD_INV VSS inv_dut_079
X0_TGI080 MIN SEL[80] VDD_DEC VSS DIN080 tgate_5v0_in
X0_TGO080 MOUT SEL[80] VDD_DEC VSS DOUT080 tgate_5v0_out
X0_DUT080 DIN080 DOUT080 VDD_INV VSS inv_dut_080
X0_TGI081 MIN SEL[81] VDD_DEC VSS DIN081 tgate_5v0_in
X0_TGO081 MOUT SEL[81] VDD_DEC VSS DOUT081 tgate_5v0_out
X0_DUT081 DIN081 DOUT081 VDD_INV VSS inv_dut_081
X0_TGI082 MIN SEL[82] VDD_DEC VSS DIN082 tgate_5v0_in
X0_TGO082 MOUT SEL[82] VDD_DEC VSS DOUT082 tgate_5v0_out
X0_DUT082 DIN082 DOUT082 VDD_INV VSS inv_dut_082
X0_TGI083 MIN SEL[83] VDD_DEC VSS DIN083 tgate_5v0_in
X0_TGO083 MOUT SEL[83] VDD_DEC VSS DOUT083 tgate_5v0_out
X0_DUT083 DIN083 DOUT083 VDD_INV VSS inv_dut_083
X0_TGI084 MIN SEL[84] VDD_DEC VSS DIN084 tgate_5v0_in
X0_TGO084 MOUT SEL[84] VDD_DEC VSS DOUT084 tgate_5v0_out
X0_DUT084 DIN084 DOUT084 VDD_INV VSS inv_dut_084
X0_TGI085 MIN SEL[85] VDD_DEC VSS DIN085 tgate_5v0_in
X0_TGO085 MOUT SEL[85] VDD_DEC VSS DOUT085 tgate_5v0_out
X0_DUT085 DIN085 DOUT085 VDD_INV VSS inv_dut_085
X0_TGI086 MIN SEL[86] VDD_DEC VSS DIN086 tgate_5v0_in
X0_TGO086 MOUT SEL[86] VDD_DEC VSS DOUT086 tgate_5v0_out
X0_DUT086 DIN086 DOUT086 VDD_INV VSS inv_dut_086
X0_TGI087 MIN SEL[87] VDD_DEC VSS DIN087 tgate_5v0_in
X0_TGO087 MOUT SEL[87] VDD_DEC VSS DOUT087 tgate_5v0_out
X0_DUT087 DIN087 DOUT087 VDD_INV VSS inv_dut_087
X0_TGI088 MIN SEL[88] VDD_DEC VSS DIN088 tgate_5v0_in
X0_TGO088 MOUT SEL[88] VDD_DEC VSS DOUT088 tgate_5v0_out
X0_DUT088 DIN088 DOUT088 VDD_INV VSS inv_dut_088
X0_TGI089 MIN SEL[89] VDD_DEC VSS DIN089 tgate_5v0_in
X0_TGO089 MOUT SEL[89] VDD_DEC VSS DOUT089 tgate_5v0_out
X0_DUT089 DIN089 DOUT089 VDD_INV VSS inv_dut_089
X0_TGI090 MIN SEL[90] VDD_DEC VSS DIN090 tgate_5v0_in
X0_TGO090 MOUT SEL[90] VDD_DEC VSS DOUT090 tgate_5v0_out
X0_DUT090 DIN090 DOUT090 VDD_INV VSS inv_dut_090
X0_TGI091 MIN SEL[91] VDD_DEC VSS DIN091 tgate_5v0_in
X0_TGO091 MOUT SEL[91] VDD_DEC VSS DOUT091 tgate_5v0_out
X0_DUT091 DIN091 DOUT091 VDD_INV VSS inv_dut_091
X0_TGI092 MIN SEL[92] VDD_DEC VSS DIN092 tgate_5v0_in
X0_TGO092 MOUT SEL[92] VDD_DEC VSS DOUT092 tgate_5v0_out
X0_DUT092 DIN092 DOUT092 VDD_INV VSS inv_dut_092
X0_TGI093 MIN SEL[93] VDD_DEC VSS DIN093 tgate_5v0_in
X0_TGO093 MOUT SEL[93] VDD_DEC VSS DOUT093 tgate_5v0_out
X0_DUT093 DIN093 DOUT093 VDD_INV VSS inv_dut_093
X0_TGI094 MIN SEL[94] VDD_DEC VSS DIN094 tgate_5v0_in
X0_TGO094 MOUT SEL[94] VDD_DEC VSS DOUT094 tgate_5v0_out
X0_DUT094 DIN094 DOUT094 VDD_INV VSS inv_dut_094
X0_TGI095 MIN SEL[95] VDD_DEC VSS DIN095 tgate_5v0_in
X0_TGO095 MOUT SEL[95] VDD_DEC VSS DOUT095 tgate_5v0_out
X0_DUT095 DIN095 DOUT095 VDD_INV VSS inv_dut_095
X0_TGI096 MIN SEL[96] VDD_DEC VSS DIN096 tgate_5v0_in
X0_TGO096 MOUT SEL[96] VDD_DEC VSS DOUT096 tgate_5v0_out
X0_DUT096 DIN096 DOUT096 VDD_INV VSS inv_dut_096
X0_TGI097 MIN SEL[97] VDD_DEC VSS DIN097 tgate_5v0_in
X0_TGO097 MOUT SEL[97] VDD_DEC VSS DOUT097 tgate_5v0_out
X0_DUT097 DIN097 DOUT097 VDD_INV VSS inv_dut_097
X0_TGI098 MIN SEL[98] VDD_DEC VSS DIN098 tgate_5v0_in
X0_TGO098 MOUT SEL[98] VDD_DEC VSS DOUT098 tgate_5v0_out
X0_DUT098 DIN098 DOUT098 VDD_INV VSS inv_dut_098
X0_TGI099 MIN SEL[99] VDD_DEC VSS DIN099 tgate_5v0_in
X0_TGO099 MOUT SEL[99] VDD_DEC VSS DOUT099 tgate_5v0_out
X0_DUT099 DIN099 DOUT099 VDD_INV VSS inv_dut_099
X0_TGI100 MIN SEL[100] VDD_DEC VSS DIN100 tgate_5v0_in
X0_TGO100 MOUT SEL[100] VDD_DEC VSS DOUT100 tgate_5v0_out
X0_DUT100 DIN100 DOUT100 VDD_INV VSS inv_dut_100
X0_TGI101 MIN SEL[101] VDD_DEC VSS DIN101 tgate_5v0_in
X0_TGO101 MOUT SEL[101] VDD_DEC VSS DOUT101 tgate_5v0_out
X0_DUT101 DIN101 DOUT101 VDD_INV VSS inv_dut_101
X0_TGI102 MIN SEL[102] VDD_DEC VSS DIN102 tgate_5v0_in
X0_TGO102 MOUT SEL[102] VDD_DEC VSS DOUT102 tgate_5v0_out
X0_DUT102 DIN102 DOUT102 VDD_INV VSS inv_dut_102
X0_TGI103 MIN SEL[103] VDD_DEC VSS DIN103 tgate_5v0_in
X0_TGO103 MOUT SEL[103] VDD_DEC VSS DOUT103 tgate_5v0_out
X0_DUT103 DIN103 DOUT103 VDD_INV VSS inv_dut_103
X0_TGI104 MIN SEL[104] VDD_DEC VSS DIN104 tgate_5v0_in
X0_TGO104 MOUT SEL[104] VDD_DEC VSS DOUT104 tgate_5v0_out
X0_DUT104 DIN104 DOUT104 VDD_INV VSS inv_dut_104
X0_TGI105 MIN SEL[105] VDD_DEC VSS DIN105 tgate_5v0_in
X0_TGO105 MOUT SEL[105] VDD_DEC VSS DOUT105 tgate_5v0_out
X0_DUT105 DIN105 DOUT105 VDD_INV VSS inv_dut_105
X0_TGI106 MIN SEL[106] VDD_DEC VSS DIN106 tgate_5v0_in
X0_TGO106 MOUT SEL[106] VDD_DEC VSS DOUT106 tgate_5v0_out
X0_DUT106 DIN106 DOUT106 VDD_INV VSS inv_dut_106
X0_TGI107 MIN SEL[107] VDD_DEC VSS DIN107 tgate_5v0_in
X0_TGO107 MOUT SEL[107] VDD_DEC VSS DOUT107 tgate_5v0_out
X0_DUT107 DIN107 DOUT107 VDD_INV VSS inv_dut_107
X0_TGI108 MIN SEL[108] VDD_DEC VSS DIN108 tgate_5v0_in
X0_TGO108 MOUT SEL[108] VDD_DEC VSS DOUT108 tgate_5v0_out
X0_DUT108 DIN108 DOUT108 VDD_INV VSS inv_dut_108
X0_TGI109 MIN SEL[109] VDD_DEC VSS DIN109 tgate_5v0_in
X0_TGO109 MOUT SEL[109] VDD_DEC VSS DOUT109 tgate_5v0_out
X0_DUT109 DIN109 DOUT109 VDD_INV VSS inv_dut_109
X0_TGI110 MIN SEL[110] VDD_DEC VSS DIN110 tgate_5v0_in
X0_TGO110 MOUT SEL[110] VDD_DEC VSS DOUT110 tgate_5v0_out
X0_DUT110 DIN110 DOUT110 VDD_INV VSS inv_dut_110
X0_TGI111 MIN SEL[111] VDD_DEC VSS DIN111 tgate_5v0_in
X0_TGO111 MOUT SEL[111] VDD_DEC VSS DOUT111 tgate_5v0_out
X0_DUT111 DIN111 DOUT111 VDD_INV VSS inv_dut_111
X0_TGI112 MIN SEL[112] VDD_DEC VSS DIN112 tgate_5v0_in
X0_TGO112 MOUT SEL[112] VDD_DEC VSS DOUT112 tgate_5v0_out
X0_DUT112 DIN112 DOUT112 VDD_INV VSS inv_dut_112
X0_TGI113 MIN SEL[113] VDD_DEC VSS DIN113 tgate_5v0_in
X0_TGO113 MOUT SEL[113] VDD_DEC VSS DOUT113 tgate_5v0_out
X0_DUT113 DIN113 DOUT113 VDD_INV VSS inv_dut_113
X0_TGI114 MIN SEL[114] VDD_DEC VSS DIN114 tgate_5v0_in
X0_TGO114 MOUT SEL[114] VDD_DEC VSS DOUT114 tgate_5v0_out
X0_DUT114 DIN114 DOUT114 VDD_INV VSS inv_dut_114
X0_TGI115 MIN SEL[115] VDD_DEC VSS DIN115 tgate_5v0_in
X0_TGO115 MOUT SEL[115] VDD_DEC VSS DOUT115 tgate_5v0_out
X0_DUT115 DIN115 DOUT115 VDD_INV VSS inv_dut_115
X0_TGI116 MIN SEL[116] VDD_DEC VSS DIN116 tgate_5v0_in
X0_TGO116 MOUT SEL[116] VDD_DEC VSS DOUT116 tgate_5v0_out
X0_DUT116 DIN116 DOUT116 VDD_INV VSS inv_dut_116
X0_TGI117 MIN SEL[117] VDD_DEC VSS DIN117 tgate_5v0_in
X0_TGO117 MOUT SEL[117] VDD_DEC VSS DOUT117 tgate_5v0_out
X0_DUT117 DIN117 DOUT117 VDD_INV VSS inv_dut_117
X0_TGI118 MIN SEL[118] VDD_DEC VSS DIN118 tgate_5v0_in
X0_TGO118 MOUT SEL[118] VDD_DEC VSS DOUT118 tgate_5v0_out
X0_DUT118 DIN118 DOUT118 VDD_INV VSS inv_dut_118
X0_TGI119 MIN SEL[119] VDD_DEC VSS DIN119 tgate_5v0_in
X0_TGO119 MOUT SEL[119] VDD_DEC VSS DOUT119 tgate_5v0_out
X0_DUT119 DIN119 DOUT119 VDD_INV VSS inv_dut_119
X0_TGI120 MIN SEL[120] VDD_DEC VSS DIN120 tgate_5v0_in
X0_TGO120 MOUT SEL[120] VDD_DEC VSS DOUT120 tgate_5v0_out
X0_DUT120 DIN120 DOUT120 VDD_INV VSS inv_dut_120
X0_TGI121 MIN SEL[121] VDD_DEC VSS DIN121 tgate_5v0_in
X0_TGO121 MOUT SEL[121] VDD_DEC VSS DOUT121 tgate_5v0_out
X0_DUT121 DIN121 DOUT121 VDD_INV VSS inv_dut_121
X0_TGI122 MIN SEL[122] VDD_DEC VSS DIN122 tgate_5v0_in
X0_TGO122 MOUT SEL[122] VDD_DEC VSS DOUT122 tgate_5v0_out
X0_DUT122 DIN122 DOUT122 VDD_INV VSS inv_dut_122
X0_TGI123 MIN SEL[123] VDD_DEC VSS DIN123 tgate_5v0_in
X0_TGO123 MOUT SEL[123] VDD_DEC VSS DOUT123 tgate_5v0_out
X0_DUT123 DIN123 DOUT123 VDD_INV VSS inv_dut_123
X0_TGI124 MIN SEL[124] VDD_DEC VSS DIN124 tgate_5v0_in
X0_TGO124 MOUT SEL[124] VDD_DEC VSS DOUT124 tgate_5v0_out
X0_DUT124 DIN124 DOUT124 VDD_INV VSS inv_dut_124
X0_TGI125 MIN SEL[125] VDD_DEC VSS DIN125 tgate_5v0_in
X0_TGO125 MOUT SEL[125] VDD_DEC VSS DOUT125 tgate_5v0_out
X0_DUT125 DIN125 DOUT125 VDD_INV VSS inv_dut_125
X0_TGI126 MIN SEL[126] VDD_DEC VSS DIN126 tgate_5v0_in
X0_TGO126 MOUT SEL[126] VDD_DEC VSS DOUT126 tgate_5v0_out
X0_DUT126 DIN126 DOUT126 VDD_INV VSS inv_dut_126
X0_TGI127 MIN SEL[127] VDD_DEC VSS DIN127 tgate_5v0_in
X0_TGO127 MOUT SEL[127] VDD_DEC VSS DOUT127 tgate_5v0_out
X0_DUT127 DIN127 DOUT127 VDD_INV VSS inv_dut_127
.ends
