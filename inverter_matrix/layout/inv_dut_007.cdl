* inv_dut_007: pfet_05v0 W=10.80u L=0.60u / nfet_05v0 W=3.60u L=0.60u
.SUBCKT inv_dut_007 A Q VDD VSS
MMP Q A VDD VDD pfet_05v0 W=10.80u L=0.60u
MMN Q A VSS VSS nfet_05v0 W=3.60u L=0.60u
.ENDS
