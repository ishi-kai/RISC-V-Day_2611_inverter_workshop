* Extracted by KLayout with GF180MCU LVS runset on : 19/10/2026 04:59

.SUBCKT inv_dut_110 A Q VDD VSS
M$1 Q A VDD VDD pfet_05v0 L=1.2U W=16.2U AS=12.474P AD=12.474P PS=33.94U
+ PD=33.94U
M$2 Q A VSS VSS nfet_05v0 L=1.2U W=5.4U AS=3.942P AD=3.942P PS=12.26U PD=12.26U
.ENDS inv_dut_110
