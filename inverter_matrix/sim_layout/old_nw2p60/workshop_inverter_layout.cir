* Extracted by KLayout with GF180MCU LVS runset on : 19/10/2026 06:07

* cell workshop_inverter
* pin D[0]
* pin D[1]
* pin D[2]
* pin D[3]
* pin D[4]
* pin D[5]
* pin D[6]
* pin FOUT
* pin IN
* pin OUT
* pin VCO_EN
* pin VCTRL
* pin VDD_DEC
* pin VDD_INV
* pin VSS
.SUBCKT workshop_inverter D[0] D[1] D[2] D[3] D[4] D[5] D[6] FOUT IN OUT VCO_EN
+ VCTRL VDD_DEC VDD_INV VSS
* cell instance _150 r0 *1 64,72
X_150 n_I257 n_I385 VDD_INV VSS inv_dut_112
* cell instance _151 r0 *1 264,618
X_151 n_I256 n_I384 VDD_INV VSS inv_dut_005
* cell instance _152 r0 *1 544,72
X_152 n_I255 n_I383 VDD_INV VSS inv_dut_124
* cell instance _153 r0 *1 184,150
X_153 n_I254 n_I382 VDD_INV VSS inv_dut_099
* cell instance _154 r0 *1 224,462
X_154 n_I253 n_I381 VDD_INV VSS inv_dut_036
* cell instance _155 r0 *1 184,72
X_155 n_I252 n_I380 VDD_INV VSS inv_dut_115
* cell instance _156 r0 *1 304,618
X_156 n_I251 n_I379 VDD_INV VSS inv_dut_006
* cell instance _157 r0 *1 104,618
X_157 n_I250 n_I378 VDD_INV VSS inv_dut_001
* cell instance _158 r0 *1 264,384
X_158 n_I249 n_I377 VDD_INV VSS inv_dut_053
* cell instance _159 r0 *1 624,72
X_159 n_I248 n_I376 VDD_INV VSS inv_dut_126
* cell instance _160 r0 *1 184,462
X_160 n_I247 n_I375 VDD_INV VSS inv_dut_035
* cell instance _161 r0 *1 464,150
X_161 n_I246 n_I374 VDD_INV VSS inv_dut_106
* cell instance _162 r0 *1 504,150
X_162 n_I245 n_I373 VDD_INV VSS inv_dut_107
* cell instance _163 r0 *1 624,228
X_163 n_I244 n_I372 VDD_INV VSS inv_dut_094
* cell instance _164 r0 *1 664,228
X_164 n_I243 n_I371 VDD_INV VSS inv_dut_095
* cell instance _165 r0 *1 544,228
X_165 n_I242 n_I370 VDD_INV VSS inv_dut_092
* cell instance _166 r0 *1 584,228
X_166 n_I241 n_I369 VDD_INV VSS inv_dut_093
* cell instance _167 r0 *1 544,150
X_167 n_I240 n_I368 VDD_INV VSS inv_dut_108
* cell instance _168 r0 *1 584,150
X_168 n_I239 n_I367 VDD_INV VSS inv_dut_109
* cell instance _169 r0 *1 104,384
X_169 n_I238 n_I366 VDD_INV VSS inv_dut_049
* cell instance _170 r0 *1 584,72
X_170 n_I237 n_I365 VDD_INV VSS inv_dut_125
* cell instance _171 r0 *1 424,150
X_171 n_I236 n_I364 VDD_INV VSS inv_dut_105
* cell instance _172 r0 *1 664,150
X_172 n_I235 n_I363 VDD_INV VSS inv_dut_111
* cell instance _173 r0 *1 664,72
X_173 n_I234 n_I362 VDD_INV VSS inv_dut_127
* cell instance _174 r0 *1 64,462
X_174 n_I233 n_I361 VDD_INV VSS inv_dut_032
* cell instance _175 r0 *1 384,150
X_175 n_I232 n_I360 VDD_INV VSS inv_dut_104
* cell instance _176 r0 *1 224,384
X_176 n_I231 n_I359 VDD_INV VSS inv_dut_052
* cell instance _177 r0 *1 304,462
X_177 n_I230 n_I358 VDD_INV VSS inv_dut_038
* cell instance _178 r0 *1 344,618
X_178 n_I229 n_I357 VDD_INV VSS inv_dut_007
* cell instance _179 r0 *1 264,462
X_179 n_I228 n_I356 VDD_INV VSS inv_dut_037
* cell instance _180 r0 *1 304,384
X_180 n_I227 n_I355 VDD_INV VSS inv_dut_054
* cell instance _181 r0 *1 624,150
X_181 n_I226 n_I354 VDD_INV VSS inv_dut_110
* cell instance _182 r0 *1 344,462
X_182 n_I225 n_I353 VDD_INV VSS inv_dut_039
* cell instance _183 r0 *1 184,384
X_183 n_I224 n_I352 VDD_INV VSS inv_dut_051
* cell instance _184 r0 *1 344,384
X_184 n_I223 n_I351 VDD_INV VSS inv_dut_055
* cell instance _185 r0 *1 344,306
X_185 n_I222 n_I350 VDD_INV VSS inv_dut_071
* cell instance _186 r0 *1 344,228
X_186 n_I221 n_I349 VDD_INV VSS inv_dut_087
* cell instance _187 r0 *1 344,150
X_187 n_I220 n_I348 VDD_INV VSS inv_dut_103
* cell instance _188 r0 *1 344,72
X_188 n_I219 n_I347 VDD_INV VSS inv_dut_119
* cell instance _189 r0 *1 184,306
X_189 n_I218 n_I346 VDD_INV VSS inv_dut_067
* cell instance _190 r0 *1 184,228
X_190 n_I217 n_I345 VDD_INV VSS inv_dut_083
* cell instance _191 r0 *1 224,618
X_191 n_I216 n_I344 VDD_INV VSS inv_dut_004
* cell instance _192 r0 *1 384,540
X_192 n_I215 n_I343 VDD_INV VSS inv_dut_024
* cell instance _193 r0 *1 424,540
X_193 n_I214 n_I342 VDD_INV VSS inv_dut_025
* cell instance _194 r0 *1 464,540
X_194 n_I213 n_I341 VDD_INV VSS inv_dut_026
* cell instance _195 r0 *1 504,540
X_195 n_I212 n_I340 VDD_INV VSS inv_dut_027
* cell instance _196 r0 *1 664,540
X_196 n_I211 n_I339 VDD_INV VSS inv_dut_031
* cell instance _197 r0 *1 64,384
X_197 n_I210 n_I338 VDD_INV VSS inv_dut_048
* cell instance _198 r0 *1 584,540
X_198 n_I209 n_I337 VDD_INV VSS inv_dut_029
* cell instance _199 r0 *1 624,540
X_199 n_I208 n_I336 VDD_INV VSS inv_dut_030
* cell instance _200 r0 *1 184,540
X_200 n_I207 n_I335 VDD_INV VSS inv_dut_019
* cell instance _201 r0 *1 224,306
X_201 n_I206 n_I334 VDD_INV VSS inv_dut_068
* cell instance _202 r0 *1 104,540
X_202 n_I205 n_I333 VDD_INV VSS inv_dut_017
* cell instance _203 r0 *1 144,540
X_203 n_I204 n_I332 VDD_INV VSS inv_dut_018
* cell instance _204 r0 *1 64,540
X_204 n_I203 n_I331 VDD_INV VSS inv_dut_016
* cell instance _205 r0 *1 224,540
X_205 n_I202 n_I330 VDD_INV VSS inv_dut_020
* cell instance _206 r0 *1 264,540
X_206 n_I201 n_I329 VDD_INV VSS inv_dut_021
* cell instance _207 r0 *1 304,540
X_207 n_I200 n_I328 VDD_INV VSS inv_dut_022
* cell instance _208 r0 *1 264,306
X_208 n_I199 n_I327 VDD_INV VSS inv_dut_069
* cell instance _209 r0 *1 304,306
X_209 n_I198 n_I326 VDD_INV VSS inv_dut_070
* cell instance _210 r0 *1 104,306
X_210 n_I197 n_I325 VDD_INV VSS inv_dut_065
* cell instance _211 r0 *1 144,306
X_211 n_I196 n_I324 VDD_INV VSS inv_dut_066
* cell instance _212 r0 *1 64,306
X_212 n_I195 n_I323 VDD_INV VSS inv_dut_064
* cell instance _213 r0 *1 544,540
X_213 n_I194 n_I322 VDD_INV VSS inv_dut_028
* cell instance _214 r0 *1 504,384
X_214 n_I193 n_I321 VDD_INV VSS inv_dut_059
* cell instance _215 r0 *1 224,72
X_215 n_I192 n_I320 VDD_INV VSS inv_dut_116
* cell instance _216 r0 *1 464,384
X_216 n_I191 n_I319 VDD_INV VSS inv_dut_058
* cell instance _217 r0 *1 384,618
X_217 n_I190 n_I318 VDD_INV VSS inv_dut_008
* cell instance _218 r0 *1 424,384
X_218 n_I189 n_I317 VDD_INV VSS inv_dut_057
* cell instance _219 r0 *1 504,462
X_219 n_I188 n_I316 VDD_INV VSS inv_dut_043
* cell instance _220 r0 *1 384,384
X_220 n_I187 n_I315 VDD_INV VSS inv_dut_056
* cell instance _221 r0 *1 384,462
X_221 n_I186 n_I314 VDD_INV VSS inv_dut_040
* cell instance _222 r0 *1 464,462
X_222 n_I185 n_I313 VDD_INV VSS inv_dut_042
* cell instance _223 r0 *1 264,72
X_223 n_I184 n_I312 VDD_INV VSS inv_dut_117
* cell instance _224 r0 *1 424,462
X_224 n_I183 n_I311 VDD_INV VSS inv_dut_041
* cell instance _225 r0 *1 624,462
X_225 n_I182 n_I310 VDD_INV VSS inv_dut_046
* cell instance _226 r0 *1 584,462
X_226 n_I181 n_I309 VDD_INV VSS inv_dut_045
* cell instance _227 r0 *1 624,384
X_227 n_I180 n_I308 VDD_INV VSS inv_dut_062
* cell instance _228 r0 *1 624,618
X_228 n_I179 n_I307 VDD_INV VSS inv_dut_014
* cell instance _229 r0 *1 344,540
X_229 n_I178 n_I306 VDD_INV VSS inv_dut_023
* cell instance _230 r0 *1 544,384
X_230 n_I177 n_I305 VDD_INV VSS inv_dut_060
* cell instance _231 r0 *1 584,618
X_231 n_I176 n_I304 VDD_INV VSS inv_dut_013
* cell instance _232 r0 *1 664,618
X_232 n_I175 n_I303 VDD_INV VSS inv_dut_015
* cell instance _233 r0 *1 584,306
X_233 n_I174 n_I302 VDD_INV VSS inv_dut_077
* cell instance _234 r0 *1 624,306
X_234 n_I173 n_I301 VDD_INV VSS inv_dut_078
* cell instance _235 r0 *1 664,306
X_235 n_I172 n_I300 VDD_INV VSS inv_dut_079
* cell instance _236 r0 *1 584,384
X_236 n_I171 n_I299 VDD_INV VSS inv_dut_061
* cell instance _237 r0 *1 544,462
X_237 n_I170 n_I298 VDD_INV VSS inv_dut_044
* cell instance _238 r0 *1 544,306
X_238 n_I169 n_I297 VDD_INV VSS inv_dut_076
* cell instance _239 r0 *1 504,306
X_239 n_I168 n_I296 VDD_INV VSS inv_dut_075
* cell instance _240 r0 *1 464,306
X_240 n_I167 n_I295 VDD_INV VSS inv_dut_074
* cell instance _241 r0 *1 384,306
X_241 n_I166 n_I294 VDD_INV VSS inv_dut_072
* cell instance _242 r0 *1 424,306
X_242 n_I165 n_I293 VDD_INV VSS inv_dut_073
* cell instance _243 r0 *1 664,462
X_243 n_I164 n_I292 VDD_INV VSS inv_dut_047
* cell instance _244 r0 *1 664,384
X_244 n_I163 n_I291 VDD_INV VSS inv_dut_063
* cell instance _245 r0 *1 544,618
X_245 n_I162 n_I290 VDD_INV VSS inv_dut_012
* cell instance _246 r0 *1 104,462
X_246 n_I161 n_I289 VDD_INV VSS inv_dut_033
* cell instance _247 r0 *1 384,72
X_247 n_I160 n_I288 VDD_INV VSS inv_dut_120
* cell instance _248 r0 *1 144,618
X_248 n_I159 n_I287 VDD_INV VSS inv_dut_002
* cell instance _249 r0 *1 64,618
X_249 n_I158 n_I286 VDD_INV VSS inv_dut_000
* cell instance _250 r0 *1 144,384
X_250 n_I157 n_I285 VDD_INV VSS inv_dut_050
* cell instance _251 r0 *1 144,462
X_251 n_I156 n_I284 VDD_INV VSS inv_dut_034
* cell instance _252 r0 *1 64,150
X_252 n_I155 n_I283 VDD_INV VSS inv_dut_096
* cell instance _253 r0 *1 104,150
X_253 n_I154 n_I282 VDD_INV VSS inv_dut_097
* cell instance _254 r0 *1 144,150
X_254 n_I153 n_I281 VDD_INV VSS inv_dut_098
* cell instance _255 r0 *1 104,72
X_255 n_I152 n_I280 VDD_INV VSS inv_dut_113
* cell instance _256 r0 *1 464,72
X_256 n_I151 n_I279 VDD_INV VSS inv_dut_122
* cell instance _257 r0 *1 144,72
X_257 n_I150 n_I278 VDD_INV VSS inv_dut_114
* cell instance _258 r0 *1 144,228
X_258 n_I149 n_I277 VDD_INV VSS inv_dut_082
* cell instance _259 r0 *1 64,228
X_259 n_I148 n_I276 VDD_INV VSS inv_dut_080
* cell instance _260 r0 *1 264,228
X_260 n_I147 n_I275 VDD_INV VSS inv_dut_085
* cell instance _261 r0 *1 224,150
X_261 n_I146 n_I274 VDD_INV VSS inv_dut_100
* cell instance _262 r0 *1 264,150
X_262 n_I145 n_I273 VDD_INV VSS inv_dut_101
* cell instance _263 r0 *1 184,618
X_263 n_I144 n_I272 VDD_INV VSS inv_dut_003
* cell instance _264 r0 *1 304,228
X_264 n_I143 n_I271 VDD_INV VSS inv_dut_086
* cell instance _265 r0 *1 304,150
X_265 n_I142 n_I270 VDD_INV VSS inv_dut_102
* cell instance _266 r0 *1 384,228
X_266 n_I141 n_I269 VDD_INV VSS inv_dut_088
* cell instance _267 r0 *1 424,228
X_267 n_I140 n_I268 VDD_INV VSS inv_dut_089
* cell instance _268 r0 *1 104,228
X_268 n_I139 n_I267 VDD_INV VSS inv_dut_081
* cell instance _269 r0 *1 504,228
X_269 n_I138 n_I266 VDD_INV VSS inv_dut_091
* cell instance _270 r0 *1 504,618
X_270 n_I137 n_I265 VDD_INV VSS inv_dut_011
* cell instance _271 r0 *1 464,618
X_271 n_I136 n_I264 VDD_INV VSS inv_dut_010
* cell instance _272 r0 *1 424,72
X_272 n_I135 n_I263 VDD_INV VSS inv_dut_121
* cell instance _273 r0 *1 424,618
X_273 n_I134 n_I262 VDD_INV VSS inv_dut_009
* cell instance _274 r0 *1 304,72
X_274 n_I133 n_I261 VDD_INV VSS inv_dut_118
* cell instance _275 r0 *1 224,228
X_275 n_I132 n_I260 VDD_INV VSS inv_dut_084
* cell instance _276 r0 *1 504,72
X_276 n_I131 n_I259 VDD_INV VSS inv_dut_123
* cell instance _277 r0 *1 464,228
X_277 n_I130 n_I258 VDD_INV VSS inv_dut_090
* cell instance _731 r0 *1 159.025,842.5
X_731 VDD_INV n_I2010 n_I2018 n_I2017 n_I2016 VSS cs_inv_x4_5v0
* cell instance _732 r0 *1 78.305,842.5
X_732 VDD_INV n_I2014 n_I2018 n_I2017 n_I2011 VSS cs_inv_5v0
* cell instance _733 r0 *1 60,842.5
X_733 VDD_INV n_I2018 n_I2017 VCTRL VSS vco_bias_5v0
* cell instance _735 r0 *1 145.765,842.5
X_735 VDD_INV n_I2016 n_I2018 n_I2017 n_I2012 VSS cs_inv_5v0
* cell instance _736 r0 *1 132.505,842.5
X_736 VDD_INV n_I2012 n_I2018 n_I2017 n_I2015 VSS cs_inv_5v0
* cell instance _737 r0 *1 104.825,842.5
X_737 VDD_INV n_I2015 n_I2018 n_I2017 n_I2013 VSS cs_inv_5v0
* cell instance _739 r0 *1 91.565,842.5
X_739 VDD_INV n_I2013 n_I2018 n_I2017 n_I2014 VSS cs_inv_5v0
* device instance _1 r0 *1 548.46,858 diode_nw2ps_06v0
D_1 VSS D[2] diode_nw2ps_06v0 area=0.3888P pj=2.88U
* device instance _2 r0 *1 520.46,858 diode_nw2ps_06v0
D_2 VSS D[1] diode_nw2ps_06v0 area=0.3888P pj=2.88U
* device instance _3 r0 *1 576.46,858 diode_nw2ps_06v0
D_3 VSS D[3] diode_nw2ps_06v0 area=0.3888P pj=2.88U
* device instance _4 r0 *1 492.46,858 diode_nw2ps_06v0
D_4 VSS D[0] diode_nw2ps_06v0 area=0.3888P pj=2.88U
* device instance _5 r0 *1 604.46,858 diode_nw2ps_06v0
D_5 VSS D[4] diode_nw2ps_06v0 area=0.3888P pj=2.88U
* device instance _6 r0 *1 632.46,858 diode_nw2ps_06v0
D_6 VSS D[5] diode_nw2ps_06v0 area=0.3888P pj=2.88U
* device instance _7 r0 *1 660.46,858 diode_nw2ps_06v0
D_7 VSS D[6] diode_nw2ps_06v0 area=0.3888P pj=2.88U
* device instance _8 r90 *1 62.14,843.355 diode_nw2ps_06v0
D_8 VSS VCTRL diode_nw2ps_06v0 area=0.3344P pj=2.52U
* device instance _9 r180 *1 568.63,799.985 pfet_05v0
XM_9 n_I2445 n_I2282 VDD_DEC VDD_DEC pfet_05v0 L=0.5U W=1.05U AS=0.4015P
+ AD=0.462P PS=1.92U PD=2.98U
* device instance _10 r180 *1 567.43,800.07 pfet_05v0
XM_10 n_I2101 n_I2445 VDD_DEC VDD_DEC pfet_05v0 L=0.5U W=1.22U AS=0.4015P
+ AD=0.5368P PS=1.92U PD=3.32U
* device instance _11 r180 *1 568.68,802.295 nfet_05v0
XM_11 VSS n_I2282 n_I2445 VSS nfet_05v0 L=0.6U W=0.36U AS=0.1584P AD=0.153P
+ PS=1.6U PD=1.195U
* device instance _12 r180 *1 567.38,802.228 nfet_05v0
XM_12 n_I2101 n_I2445 VSS VSS nfet_05v0 L=0.6U W=0.495U AS=0.153P AD=0.2178P
+ PS=1.195U PD=1.87U
* device instance _13 m0 *1 512.23,823.285 pfet_05v0
XM_13 n_I2446 n_I2353 VDD_DEC VDD_DEC pfet_05v0 L=0.5U W=0.6U AS=0.264P
+ AD=0.156P PS=2.08U PD=1.12U
* device instance _14 m0 *1 513.25,823.285 pfet_05v0
XM_14 n_I2446 n_I2322 VDD_DEC VDD_DEC pfet_05v0 L=0.5U W=0.6U AS=0.40575P
+ AD=0.156P PS=2.055U PD=1.12U
* device instance _15 m0 *1 514.59,823.593 pfet_05v0
XM_15 n_I2364 n_I2446 VDD_DEC VDD_DEC pfet_05v0 L=0.5U W=1.215U AS=0.40575P
+ AD=0.5346P PS=2.055U PD=3.31U
* device instance _16 m0 *1 512.28,825.583 nfet_05v0
XM_16 n_I2447 n_I2353 n_I2446 VSS nfet_05v0 L=0.6U W=0.365U AS=0.1606P
+ AD=0.0584P PS=1.61U PD=0.685U
* device instance _17 m0 *1 513.2,825.583 nfet_05v0
XM_17 n_I2447 n_I2322 VSS VSS nfet_05v0 L=0.6U W=0.365U AS=0.23405P AD=0.0584P
+ PS=1.555U PD=0.685U
* device instance _18 m0 *1 514.54,825.808 nfet_05v0
XM_18 n_I2364 n_I2446 VSS VSS nfet_05v0 L=0.6U W=0.815U AS=0.23405P AD=0.3586P
+ PS=1.555U PD=2.51U
* device instance _19 m0 *1 544.81,823.26 pfet_05v0
XM_19 n_I2451 n_I2384 n_I2448 VDD_DEC pfet_05v0 L=0.5U W=0.56U AS=0.2464P
+ AD=0.196P PS=2U PD=1.26U
* device instance _20 m0 *1 546.01,823.26 pfet_05v0
XM_20 n_I2450 n_I2333 n_I2451 VDD_DEC pfet_05v0 L=0.5U W=0.56U AS=0.196P
+ AD=0.1736P PS=1.26U PD=1.18U
* device instance _21 m0 *1 547.13,823.26 pfet_05v0
XM_21 n_I2449 n_I2332 n_I2450 VDD_DEC pfet_05v0 L=0.5U W=0.56U AS=0.1736P
+ AD=0.1736P PS=1.18U PD=1.18U
* device instance _22 m0 *1 548.25,823.26 pfet_05v0
XM_22 n_I2449 n_I2382 VDD_DEC VDD_DEC pfet_05v0 L=0.5U W=0.56U AS=0.389P
+ AD=0.1736P PS=2.02U PD=1.18U
* device instance _23 m0 *1 549.55,823.59 pfet_05v0
XM_23 n_I2419 n_I2448 VDD_DEC VDD_DEC pfet_05v0 L=0.5U W=1.22U AS=0.389P
+ AD=0.5368P PS=2.02U PD=3.32U
* device instance _24 m0 *1 544.76,825.915 nfet_05v0
XM_24 n_I2448 n_I2384 VSS VSS nfet_05v0 L=0.6U W=0.36U AS=0.1584P AD=0.126P
+ PS=1.6U PD=1.06U
* device instance _25 m0 *1 546.06,825.915 nfet_05v0
XM_25 VSS n_I2333 n_I2448 VSS nfet_05v0 L=0.6U W=0.36U AS=0.126P AD=0.0936P
+ PS=1.06U PD=0.88U
* device instance _26 m0 *1 547.18,825.915 nfet_05v0
XM_26 n_I2448 n_I2332 VSS VSS nfet_05v0 L=0.6U W=0.36U AS=0.0936P AD=0.0936P
+ PS=0.88U PD=0.88U
* device instance _27 m0 *1 548.3,825.915 nfet_05v0
XM_27 n_I2448 n_I2382 VSS VSS nfet_05v0 L=0.6U W=0.36U AS=0.218P AD=0.0936P
+ PS=1.52U PD=0.88U
* device instance _28 m0 *1 549.6,825.81 nfet_05v0
XM_28 n_I2419 n_I2448 VSS VSS nfet_05v0 L=0.6U W=0.82U AS=0.218P AD=0.3608P
+ PS=1.52U PD=2.52U
* device instance _29 m0 *1 528.47,831.43 pfet_05v0
XM_29 VDD_DEC n_I2246 n_I2452 VDD_DEC pfet_05v0 L=0.5U W=1.22U AS=0.5368P
+ AD=0.4941P PS=3.32U PD=2.03U
* device instance _30 m0 *1 529.78,831.43 pfet_05v0
XM_30 n_I2309 n_I2452 VDD_DEC VDD_DEC pfet_05v0 L=0.5U W=2.44U AS=0.8723P
+ AD=0.915P PS=3.87U PD=5.16U
* device instance _32 m0 *1 528.52,833.65 nfet_05v0
XM_32 VSS n_I2246 n_I2452 VSS nfet_05v0 L=0.6U W=0.82U AS=0.3608P AD=0.2911P
+ PS=2.52U PD=1.53U
* device instance _33 m0 *1 529.83,833.65 nfet_05v0
XM_33 n_I2309 n_I2452 VSS VSS nfet_05v0 L=0.6U W=1.64U AS=0.5043P AD=0.574P
+ PS=2.87U PD=3.86U
* device instance _35 m0 *1 538.55,831.43 pfet_05v0
XM_35 VDD_DEC n_I2380 n_I2453 VDD_DEC pfet_05v0 L=0.5U W=1.22U AS=0.5368P
+ AD=0.4941P PS=3.32U PD=2.03U
* device instance _36 m0 *1 539.86,831.43 pfet_05v0
XM_36 n_I2251 n_I2453 VDD_DEC VDD_DEC pfet_05v0 L=0.5U W=2.44U AS=0.8723P
+ AD=0.915P PS=3.87U PD=5.16U
* device instance _38 m0 *1 538.6,833.65 nfet_05v0
XM_38 VSS n_I2380 n_I2453 VSS nfet_05v0 L=0.6U W=0.82U AS=0.3608P AD=0.2911P
+ PS=2.52U PD=1.53U
* device instance _39 m0 *1 539.91,833.65 nfet_05v0
XM_39 n_I2251 n_I2453 VSS VSS nfet_05v0 L=0.6U W=1.64U AS=0.5043P AD=0.574P
+ PS=2.87U PD=3.86U
* device instance _41 m0 *1 522.31,831.43 pfet_05v0
XM_41 VDD_DEC n_I2363 n_I2454 VDD_DEC pfet_05v0 L=0.5U W=1.22U AS=0.5368P
+ AD=0.4941P PS=3.32U PD=2.03U
* device instance _42 m0 *1 523.62,831.43 pfet_05v0
XM_42 n_I2274 n_I2454 VDD_DEC VDD_DEC pfet_05v0 L=0.5U W=2.44U AS=0.8723P
+ AD=0.915P PS=3.87U PD=5.16U
* device instance _44 m0 *1 522.36,833.65 nfet_05v0
XM_44 VSS n_I2363 n_I2454 VSS nfet_05v0 L=0.6U W=0.82U AS=0.3608P AD=0.2911P
+ PS=2.52U PD=1.53U
* device instance _45 m0 *1 523.67,833.65 nfet_05v0
XM_45 n_I2274 n_I2454 VSS VSS nfet_05v0 L=0.6U W=1.64U AS=0.5043P AD=0.574P
+ PS=2.87U PD=3.86U
* device instance _47 r0 *1 512.23,829.53 pfet_05v0
XM_47 VDD_DEC n_I2330 n_I2455 VDD_DEC pfet_05v0 L=0.5U W=1.22U AS=0.5368P
+ AD=0.4941P PS=3.32U PD=2.03U
* device instance _48 r0 *1 513.54,829.53 pfet_05v0
XM_48 n_I2165 n_I2455 VDD_DEC VDD_DEC pfet_05v0 L=0.5U W=2.44U AS=0.8723P
+ AD=0.915P PS=3.87U PD=5.16U
* device instance _50 r0 *1 512.28,827.31 nfet_05v0
XM_50 VSS n_I2330 n_I2455 VSS nfet_05v0 L=0.6U W=0.82U AS=0.3608P AD=0.2911P
+ PS=2.52U PD=1.53U
* device instance _51 r0 *1 513.59,827.31 nfet_05v0
XM_51 n_I2165 n_I2455 VSS VSS nfet_05v0 L=0.6U W=1.64U AS=0.5043P AD=0.574P
+ PS=2.87U PD=3.86U
* device instance _53 r0 *1 516.71,829.53 pfet_05v0
XM_53 VDD_DEC n_I2231 n_I2456 VDD_DEC pfet_05v0 L=0.5U W=1.22U AS=0.5368P
+ AD=0.4941P PS=3.32U PD=2.03U
* device instance _54 r0 *1 518.02,829.53 pfet_05v0
XM_54 n_I2208 n_I2456 VDD_DEC VDD_DEC pfet_05v0 L=0.5U W=2.44U AS=0.8723P
+ AD=0.915P PS=3.87U PD=5.16U
* device instance _56 r0 *1 516.76,827.31 nfet_05v0
XM_56 VSS n_I2231 n_I2456 VSS nfet_05v0 L=0.6U W=0.82U AS=0.3608P AD=0.2911P
+ PS=2.52U PD=1.53U
* device instance _57 r0 *1 518.07,827.31 nfet_05v0
XM_57 n_I2208 n_I2456 VSS VSS nfet_05v0 L=0.6U W=1.64U AS=0.5043P AD=0.574P
+ PS=2.87U PD=3.86U
* device instance _59 r0 *1 540.23,837.37 pfet_05v0
XM_59 VDD_DEC n_I2323 n_I2457 VDD_DEC pfet_05v0 L=0.5U W=1.22U AS=0.5368P
+ AD=0.4941P PS=3.32U PD=2.03U
* device instance _60 r0 *1 541.54,837.37 pfet_05v0
XM_60 n_I2237 n_I2457 VDD_DEC VDD_DEC pfet_05v0 L=0.5U W=2.44U AS=0.8723P
+ AD=0.915P PS=3.87U PD=5.16U
* device instance _62 r0 *1 540.28,835.15 nfet_05v0
XM_62 VSS n_I2323 n_I2457 VSS nfet_05v0 L=0.6U W=0.82U AS=0.3608P AD=0.2911P
+ PS=2.52U PD=1.53U
* device instance _63 r0 *1 541.59,835.15 nfet_05v0
XM_63 n_I2237 n_I2457 VSS VSS nfet_05v0 L=0.6U W=1.64U AS=0.5043P AD=0.574P
+ PS=2.87U PD=3.86U
* device instance _65 r0 *1 535.75,837.37 pfet_05v0
XM_65 VDD_DEC n_I2306 n_I2458 VDD_DEC pfet_05v0 L=0.5U W=1.22U AS=0.5368P
+ AD=0.4941P PS=3.32U PD=2.03U
* device instance _66 r0 *1 537.06,837.37 pfet_05v0
XM_66 n_I2204 n_I2458 VDD_DEC VDD_DEC pfet_05v0 L=0.5U W=2.44U AS=0.8723P
+ AD=0.915P PS=3.87U PD=5.16U
* device instance _68 r0 *1 535.8,835.15 nfet_05v0
XM_68 VSS n_I2306 n_I2458 VSS nfet_05v0 L=0.6U W=0.82U AS=0.3608P AD=0.2911P
+ PS=2.52U PD=1.53U
* device instance _69 r0 *1 537.11,835.15 nfet_05v0
XM_69 n_I2204 n_I2458 VSS VSS nfet_05v0 L=0.6U W=1.64U AS=0.5043P AD=0.574P
+ PS=2.87U PD=3.86U
* device instance _71 m0 *1 503.27,823.59 pfet_05v0
XM_71 VDD_DEC n_I2362 n_I2459 VDD_DEC pfet_05v0 L=0.5U W=1.22U AS=0.5368P
+ AD=0.4941P PS=3.32U PD=2.03U
* device instance _72 m0 *1 504.58,823.59 pfet_05v0
XM_72 n_I2360 n_I2459 VDD_DEC VDD_DEC pfet_05v0 L=0.5U W=2.44U AS=0.8723P
+ AD=0.915P PS=3.87U PD=5.16U
* device instance _74 m0 *1 503.32,825.81 nfet_05v0
XM_74 VSS n_I2362 n_I2459 VSS nfet_05v0 L=0.6U W=0.82U AS=0.3608P AD=0.2911P
+ PS=2.52U PD=1.53U
* device instance _75 m0 *1 504.63,825.81 nfet_05v0
XM_75 n_I2360 n_I2459 VSS VSS nfet_05v0 L=0.6U W=1.64U AS=0.5043P AD=0.574P
+ PS=2.87U PD=3.86U
* device instance _77 r0 *1 508.97,822.017 pfet_05v0
XM_77 n_I2460 n_I2399 VDD_DEC VDD_DEC pfet_05v0 L=0.5U W=0.565U AS=0.35315P
+ AD=0.2486P PS=1.96U PD=2.01U
* device instance _78 r0 *1 510.21,821.69 pfet_05v0
XM_78 n_I2407 n_I2460 VDD_DEC VDD_DEC pfet_05v0 L=0.5U W=1.22U AS=0.35315P
+ AD=0.5368P PS=1.96U PD=3.32U
* device instance _79 r0 *1 508.92,819.7 nfet_05v0
XM_79 n_I2460 n_I2399 VSS VSS nfet_05v0 L=0.6U W=0.36U AS=0.2344P AD=0.1584P
+ PS=1.56U PD=1.6U
* device instance _80 r0 *1 510.26,819.47 nfet_05v0
XM_80 n_I2407 n_I2460 VSS VSS nfet_05v0 L=0.6U W=0.82U AS=0.2344P AD=0.3608P
+ PS=1.56U PD=2.52U
* device instance _81 m0 *1 567.17,807.6 pfet_05v0
XM_81 n_I2461 n_I2338 VDD_DEC VDD_DEC pfet_05v0 L=0.5U W=0.6U AS=0.264P
+ AD=0.156P PS=2.08U PD=1.12U
* device instance _82 m0 *1 568.19,807.6 pfet_05v0
XM_82 VDD_DEC n_I2383 n_I2461 VDD_DEC pfet_05v0 L=0.5U W=0.6U AS=0.156P
+ AD=0.156P PS=1.12U PD=1.12U
* device instance _83 m0 *1 569.21,807.6 pfet_05v0
XM_83 n_I2461 n_I2337 VDD_DEC VDD_DEC pfet_05v0 L=0.5U W=0.6U AS=0.156P
+ AD=0.156P PS=1.12U PD=1.12U
* device instance _84 m0 *1 570.23,807.6 pfet_05v0
XM_84 n_I2461 n_I2336 VDD_DEC VDD_DEC pfet_05v0 L=0.5U W=0.6U AS=0.395P
+ AD=0.156P PS=2.02U PD=1.12U
* device instance _85 m0 *1 571.53,807.91 pfet_05v0
XM_85 n_I2164 n_I2461 VDD_DEC VDD_DEC pfet_05v0 L=0.5U W=1.22U AS=0.395P
+ AD=0.5368P PS=2.02U PD=3.32U
* device instance _86 m0 *1 567.22,809.93 nfet_05v0
XM_86 n_I2464 n_I2338 n_I2461 VSS nfet_05v0 L=0.6U W=0.42U AS=0.1848P AD=0.0672P
+ PS=1.72U PD=0.74U
* device instance _87 m0 *1 568.14,809.93 nfet_05v0
XM_87 n_I2463 n_I2383 n_I2464 VSS nfet_05v0 L=0.6U W=0.42U AS=0.0672P AD=0.0882P
+ PS=0.74U PD=0.84U
* device instance _88 m0 *1 569.16,809.93 nfet_05v0
XM_88 n_I2462 n_I2337 n_I2463 VSS nfet_05v0 L=0.6U W=0.42U AS=0.0882P AD=0.0882P
+ PS=0.84U PD=0.84U
* device instance _89 m0 *1 570.18,809.93 nfet_05v0
XM_89 n_I2462 n_I2336 VSS VSS nfet_05v0 L=0.6U W=0.42U AS=0.226P AD=0.0882P
+ PS=1.515U PD=0.84U
* device instance _90 m0 *1 571.48,810.128 nfet_05v0
XM_90 n_I2164 n_I2461 VSS VSS nfet_05v0 L=0.6U W=0.815U AS=0.226P AD=0.3586P
+ PS=1.515U PD=2.51U
* device instance _91 m0 *1 617.57,807.6 pfet_05v0
XM_91 n_I2465 n_I2342 VDD_DEC VDD_DEC pfet_05v0 L=0.5U W=0.6U AS=0.264P
+ AD=0.156P PS=2.08U PD=1.12U
* device instance _92 m0 *1 618.59,807.6 pfet_05v0
XM_92 VDD_DEC n_I2178 n_I2465 VDD_DEC pfet_05v0 L=0.5U W=0.6U AS=0.156P
+ AD=0.156P PS=1.12U PD=1.12U
* device instance _93 m0 *1 619.61,807.6 pfet_05v0
XM_93 n_I2465 n_I2285 VDD_DEC VDD_DEC pfet_05v0 L=0.5U W=0.6U AS=0.156P
+ AD=0.156P PS=1.12U PD=1.12U
* device instance _94 m0 *1 620.63,807.6 pfet_05v0
XM_94 n_I2465 n_I2336 VDD_DEC VDD_DEC pfet_05v0 L=0.5U W=0.6U AS=0.395P
+ AD=0.156P PS=2.02U PD=1.12U
* device instance _95 m0 *1 621.93,807.91 pfet_05v0
XM_95 n_I2078 n_I2465 VDD_DEC VDD_DEC pfet_05v0 L=0.5U W=1.22U AS=0.395P
+ AD=0.5368P PS=2.02U PD=3.32U
* device instance _96 m0 *1 617.62,809.93 nfet_05v0
XM_96 n_I2468 n_I2342 n_I2465 VSS nfet_05v0 L=0.6U W=0.42U AS=0.1848P AD=0.0672P
+ PS=1.72U PD=0.74U
* device instance _97 m0 *1 618.54,809.93 nfet_05v0
XM_97 n_I2467 n_I2178 n_I2468 VSS nfet_05v0 L=0.6U W=0.42U AS=0.0672P AD=0.0882P
+ PS=0.74U PD=0.84U
* device instance _98 m0 *1 619.56,809.93 nfet_05v0
XM_98 n_I2466 n_I2285 n_I2467 VSS nfet_05v0 L=0.6U W=0.42U AS=0.0882P AD=0.0882P
+ PS=0.84U PD=0.84U
* device instance _99 m0 *1 620.58,809.93 nfet_05v0
XM_99 n_I2466 n_I2336 VSS VSS nfet_05v0 L=0.6U W=0.42U AS=0.226P AD=0.0882P
+ PS=1.515U PD=0.84U
* device instance _100 m0 *1 621.88,810.128 nfet_05v0
XM_100 n_I2078 n_I2465 VSS VSS nfet_05v0 L=0.6U W=0.815U AS=0.226P AD=0.3586P
+ PS=1.515U PD=2.51U
* device instance _101 m0 *1 599.09,807.6 pfet_05v0
XM_101 n_I2469 n_I2236 VDD_DEC VDD_DEC pfet_05v0 L=0.5U W=0.6U AS=0.264P
+ AD=0.156P PS=2.08U PD=1.12U
* device instance _102 m0 *1 600.11,807.6 pfet_05v0
XM_102 VDD_DEC n_I2284 n_I2469 VDD_DEC pfet_05v0 L=0.5U W=0.6U AS=0.156P
+ AD=0.156P PS=1.12U PD=1.12U
* device instance _103 m0 *1 601.13,807.6 pfet_05v0
XM_103 n_I2469 n_I2286 VDD_DEC VDD_DEC pfet_05v0 L=0.5U W=0.6U AS=0.156P
+ AD=0.156P PS=1.12U PD=1.12U
* device instance _104 m0 *1 602.15,807.6 pfet_05v0
XM_104 n_I2469 n_I2336 VDD_DEC VDD_DEC pfet_05v0 L=0.5U W=0.6U AS=0.395P
+ AD=0.156P PS=2.02U PD=1.12U
* device instance _105 m0 *1 603.45,807.91 pfet_05v0
XM_105 n_I2255 n_I2469 VDD_DEC VDD_DEC pfet_05v0 L=0.5U W=1.22U AS=0.395P
+ AD=0.5368P PS=2.02U PD=3.32U
* device instance _106 m0 *1 599.14,809.93 nfet_05v0
XM_106 n_I2472 n_I2236 n_I2469 VSS nfet_05v0 L=0.6U W=0.42U AS=0.1848P
+ AD=0.0672P PS=1.72U PD=0.74U
* device instance _107 m0 *1 600.06,809.93 nfet_05v0
XM_107 n_I2471 n_I2284 n_I2472 VSS nfet_05v0 L=0.6U W=0.42U AS=0.0672P
+ AD=0.0882P PS=0.74U PD=0.84U
* device instance _108 m0 *1 601.08,809.93 nfet_05v0
XM_108 n_I2470 n_I2286 n_I2471 VSS nfet_05v0 L=0.6U W=0.42U AS=0.0882P
+ AD=0.0882P PS=0.84U PD=0.84U
* device instance _109 m0 *1 602.1,809.93 nfet_05v0
XM_109 n_I2470 n_I2336 VSS VSS nfet_05v0 L=0.6U W=0.42U AS=0.226P AD=0.0882P
+ PS=1.515U PD=0.84U
* device instance _110 m0 *1 603.4,810.128 nfet_05v0
XM_110 n_I2255 n_I2469 VSS VSS nfet_05v0 L=0.6U W=0.815U AS=0.226P AD=0.3586P
+ PS=1.515U PD=2.51U
* device instance _111 r180 *1 554.11,807.6 pfet_05v0
XM_111 n_I2473 n_I2338 VDD_DEC VDD_DEC pfet_05v0 L=0.5U W=0.6U AS=0.264P
+ AD=0.156P PS=2.08U PD=1.12U
* device instance _112 r180 *1 553.09,807.6 pfet_05v0
XM_112 VDD_DEC n_I2169 n_I2473 VDD_DEC pfet_05v0 L=0.5U W=0.6U AS=0.156P
+ AD=0.156P PS=1.12U PD=1.12U
* device instance _113 r180 *1 552.07,807.6 pfet_05v0
XM_113 n_I2473 n_I2337 VDD_DEC VDD_DEC pfet_05v0 L=0.5U W=0.6U AS=0.156P
+ AD=0.156P PS=1.12U PD=1.12U
* device instance _114 r180 *1 551.05,807.6 pfet_05v0
XM_114 n_I2473 n_I2336 VDD_DEC VDD_DEC pfet_05v0 L=0.5U W=0.6U AS=0.395P
+ AD=0.156P PS=2.02U PD=1.12U
* device instance _115 r180 *1 549.75,807.91 pfet_05v0
XM_115 n_I2023 n_I2473 VDD_DEC VDD_DEC pfet_05v0 L=0.5U W=1.22U AS=0.395P
+ AD=0.5368P PS=2.02U PD=3.32U
* device instance _116 r180 *1 554.06,809.93 nfet_05v0
XM_116 n_I2476 n_I2338 n_I2473 VSS nfet_05v0 L=0.6U W=0.42U AS=0.1848P
+ AD=0.0672P PS=1.72U PD=0.74U
* device instance _117 r180 *1 553.14,809.93 nfet_05v0
XM_117 n_I2475 n_I2169 n_I2476 VSS nfet_05v0 L=0.6U W=0.42U AS=0.0672P
+ AD=0.0882P PS=0.74U PD=0.84U
* device instance _118 r180 *1 552.12,809.93 nfet_05v0
XM_118 n_I2474 n_I2337 n_I2475 VSS nfet_05v0 L=0.6U W=0.42U AS=0.0882P
+ AD=0.0882P PS=0.84U PD=0.84U
* device instance _119 r180 *1 551.1,809.93 nfet_05v0
XM_119 n_I2474 n_I2336 VSS VSS nfet_05v0 L=0.6U W=0.42U AS=0.226P AD=0.0882P
+ PS=1.515U PD=0.84U
* device instance _120 r180 *1 549.8,810.128 nfet_05v0
XM_120 n_I2023 n_I2473 VSS VSS nfet_05v0 L=0.6U W=0.815U AS=0.226P AD=0.3586P
+ PS=1.515U PD=2.51U
* device instance _121 r180 *1 560.27,807.6 pfet_05v0
XM_121 n_I2477 n_I2338 VDD_DEC VDD_DEC pfet_05v0 L=0.5U W=0.6U AS=0.264P
+ AD=0.156P PS=2.08U PD=1.12U
* device instance _122 r180 *1 559.25,807.6 pfet_05v0
XM_122 VDD_DEC n_I2333 n_I2477 VDD_DEC pfet_05v0 L=0.5U W=0.6U AS=0.156P
+ AD=0.156P PS=1.12U PD=1.12U
* device instance _123 r180 *1 558.23,807.6 pfet_05v0
XM_123 n_I2477 n_I2202 VDD_DEC VDD_DEC pfet_05v0 L=0.5U W=0.6U AS=0.156P
+ AD=0.156P PS=1.12U PD=1.12U
* device instance _124 r180 *1 557.21,807.6 pfet_05v0
XM_124 n_I2477 n_I2336 VDD_DEC VDD_DEC pfet_05v0 L=0.5U W=0.6U AS=0.395P
+ AD=0.156P PS=2.02U PD=1.12U
* device instance _125 r180 *1 555.91,807.91 pfet_05v0
XM_125 n_I2054 n_I2477 VDD_DEC VDD_DEC pfet_05v0 L=0.5U W=1.22U AS=0.395P
+ AD=0.5368P PS=2.02U PD=3.32U
* device instance _126 r180 *1 560.22,809.93 nfet_05v0
XM_126 n_I2480 n_I2338 n_I2477 VSS nfet_05v0 L=0.6U W=0.42U AS=0.1848P
+ AD=0.0672P PS=1.72U PD=0.74U
* device instance _127 r180 *1 559.3,809.93 nfet_05v0
XM_127 n_I2479 n_I2333 n_I2480 VSS nfet_05v0 L=0.6U W=0.42U AS=0.0672P
+ AD=0.0882P PS=0.74U PD=0.84U
* device instance _128 r180 *1 558.28,809.93 nfet_05v0
XM_128 n_I2478 n_I2202 n_I2479 VSS nfet_05v0 L=0.6U W=0.42U AS=0.0882P
+ AD=0.0882P PS=0.84U PD=0.84U
* device instance _129 r180 *1 557.26,809.93 nfet_05v0
XM_129 n_I2478 n_I2336 VSS VSS nfet_05v0 L=0.6U W=0.42U AS=0.226P AD=0.0882P
+ PS=1.515U PD=0.84U
* device instance _130 r180 *1 555.96,810.128 nfet_05v0
XM_130 n_I2054 n_I2477 VSS VSS nfet_05v0 L=0.6U W=0.815U AS=0.226P AD=0.3586P
+ PS=1.515U PD=2.51U
* device instance _131 r0 *1 547.57,814.16 pfet_05v0
XM_131 n_I2481 n_I2355 VDD_DEC VDD_DEC pfet_05v0 L=0.5U W=0.6U AS=0.264P
+ AD=0.156P PS=2.08U PD=1.12U
* device instance _132 r0 *1 548.59,814.16 pfet_05v0
XM_132 VDD_DEC n_I2365 n_I2481 VDD_DEC pfet_05v0 L=0.5U W=0.6U AS=0.156P
+ AD=0.156P PS=1.12U PD=1.12U
* device instance _133 r0 *1 549.61,814.16 pfet_05v0
XM_133 n_I2481 n_I2418 VDD_DEC VDD_DEC pfet_05v0 L=0.5U W=0.6U AS=0.156P
+ AD=0.156P PS=1.12U PD=1.12U
* device instance _134 r0 *1 550.63,814.16 pfet_05v0
XM_134 n_I2481 n_I2384 VDD_DEC VDD_DEC pfet_05v0 L=0.5U W=0.6U AS=0.395P
+ AD=0.156P PS=2.02U PD=1.12U
* device instance _135 r0 *1 551.93,813.85 pfet_05v0
XM_135 n_I2366 n_I2481 VDD_DEC VDD_DEC pfet_05v0 L=0.5U W=1.22U AS=0.395P
+ AD=0.5368P PS=2.02U PD=3.32U
* device instance _136 r0 *1 547.62,811.83 nfet_05v0
XM_136 n_I2484 n_I2355 n_I2481 VSS nfet_05v0 L=0.6U W=0.42U AS=0.1848P
+ AD=0.0672P PS=1.72U PD=0.74U
* device instance _137 r0 *1 548.54,811.83 nfet_05v0
XM_137 n_I2483 n_I2365 n_I2484 VSS nfet_05v0 L=0.6U W=0.42U AS=0.0672P
+ AD=0.0882P PS=0.74U PD=0.84U
* device instance _138 r0 *1 549.56,811.83 nfet_05v0
XM_138 n_I2482 n_I2418 n_I2483 VSS nfet_05v0 L=0.6U W=0.42U AS=0.0882P
+ AD=0.0882P PS=0.84U PD=0.84U
* device instance _139 r0 *1 550.58,811.83 nfet_05v0
XM_139 n_I2482 n_I2384 VSS VSS nfet_05v0 L=0.6U W=0.42U AS=0.226P AD=0.0882P
+ PS=1.515U PD=0.84U
* device instance _140 r0 *1 551.88,811.632 nfet_05v0
XM_140 n_I2366 n_I2481 VSS VSS nfet_05v0 L=0.6U W=0.815U AS=0.226P AD=0.3586P
+ PS=1.515U PD=2.51U
* device instance _141 r0 *1 634.93,798.48 pfet_05v0
XM_141 n_I2485 n_I2342 VDD_DEC VDD_DEC pfet_05v0 L=0.5U W=0.6U AS=0.264P
+ AD=0.156P PS=2.08U PD=1.12U
* device instance _142 r0 *1 635.95,798.48 pfet_05v0
XM_142 VDD_DEC n_I2341 n_I2485 VDD_DEC pfet_05v0 L=0.5U W=0.6U AS=0.156P
+ AD=0.156P PS=1.12U PD=1.12U
* device instance _143 r0 *1 636.97,798.48 pfet_05v0
XM_143 n_I2485 n_I2285 VDD_DEC VDD_DEC pfet_05v0 L=0.5U W=0.6U AS=0.156P
+ AD=0.156P PS=1.12U PD=1.12U
* device instance _144 r0 *1 637.99,798.48 pfet_05v0
XM_144 n_I2485 n_I2336 VDD_DEC VDD_DEC pfet_05v0 L=0.5U W=0.6U AS=0.395P
+ AD=0.156P PS=2.02U PD=1.12U
* device instance _145 r0 *1 639.29,798.17 pfet_05v0
XM_145 n_I2258 n_I2485 VDD_DEC VDD_DEC pfet_05v0 L=0.5U W=1.22U AS=0.395P
+ AD=0.5368P PS=2.02U PD=3.32U
* device instance _146 r0 *1 634.98,796.15 nfet_05v0
XM_146 n_I2488 n_I2342 n_I2485 VSS nfet_05v0 L=0.6U W=0.42U AS=0.1848P
+ AD=0.0672P PS=1.72U PD=0.74U
* device instance _147 r0 *1 635.9,796.15 nfet_05v0
XM_147 n_I2487 n_I2341 n_I2488 VSS nfet_05v0 L=0.6U W=0.42U AS=0.0672P
+ AD=0.0882P PS=0.74U PD=0.84U
* device instance _148 r0 *1 636.92,796.15 nfet_05v0
XM_148 n_I2486 n_I2285 n_I2487 VSS nfet_05v0 L=0.6U W=0.42U AS=0.0882P
+ AD=0.0882P PS=0.84U PD=0.84U
* device instance _149 r0 *1 637.94,796.15 nfet_05v0
XM_149 n_I2486 n_I2336 VSS VSS nfet_05v0 L=0.6U W=0.42U AS=0.226P AD=0.0882P
+ PS=1.515U PD=0.84U
* device instance _150 r0 *1 639.24,795.952 nfet_05v0
XM_150 n_I2258 n_I2485 VSS VSS nfet_05v0 L=0.6U W=0.815U AS=0.226P AD=0.3586P
+ PS=1.515U PD=2.51U
* device instance _151 r180 *1 517.765,823.635 pfet_05v0
XM_151 n_I2198 n_I2399 VDD_DEC VDD_DEC pfet_05v0 L=0.5U W=1.13U AS=0.4972P
+ AD=0.2938P PS=3.14U PD=1.65U
* device instance _152 r180 *1 516.745,823.635 pfet_05v0
XM_152 VDD_DEC n_I2329 n_I2198 VDD_DEC pfet_05v0 L=0.5U W=1.13U AS=0.2938P
+ AD=0.4972P PS=1.65U PD=3.14U
* device instance _153 r180 *1 517.715,825.81 nfet_05v0
XM_153 n_I2489 n_I2399 VSS VSS nfet_05v0 L=0.6U W=0.82U AS=0.3608P AD=0.1312P
+ PS=2.52U PD=1.14U
* device instance _154 r180 *1 516.795,825.81 nfet_05v0
XM_154 n_I2198 n_I2329 n_I2489 VSS nfet_05v0 L=0.6U W=0.82U AS=0.1312P
+ AD=0.3608P PS=1.14U PD=2.52U
* device instance _155 r0 *1 606.315,829.485 pfet_05v0
XM_155 n_I2368 n_I2366 VDD_DEC VDD_DEC pfet_05v0 L=0.5U W=1.13U AS=0.4972P
+ AD=0.2938P PS=3.14U PD=1.65U
* device instance _156 r0 *1 607.335,829.485 pfet_05v0
XM_156 VDD_DEC n_I2210 n_I2368 VDD_DEC pfet_05v0 L=0.5U W=1.13U AS=0.2938P
+ AD=0.4972P PS=1.65U PD=3.14U
* device instance _157 r0 *1 606.365,827.31 nfet_05v0
XM_157 n_I2490 n_I2366 VSS VSS nfet_05v0 L=0.6U W=0.82U AS=0.3608P AD=0.1312P
+ PS=2.52U PD=1.14U
* device instance _158 r0 *1 607.285,827.31 nfet_05v0
XM_158 n_I2368 n_I2210 n_I2490 VSS nfet_05v0 L=0.6U W=0.82U AS=0.1312P
+ AD=0.3608P PS=1.14U PD=2.52U
* device instance _159 r0 *1 574.395,829.485 pfet_05v0
XM_159 n_I2402 n_I2407 VDD_DEC VDD_DEC pfet_05v0 L=0.5U W=1.13U AS=0.4972P
+ AD=0.2938P PS=3.14U PD=1.65U
* device instance _160 r0 *1 575.415,829.485 pfet_05v0
XM_160 VDD_DEC n_I2384 n_I2402 VDD_DEC pfet_05v0 L=0.5U W=1.13U AS=0.2938P
+ AD=0.4972P PS=1.65U PD=3.14U
* device instance _161 r0 *1 574.445,827.31 nfet_05v0
XM_161 n_I2491 n_I2407 VSS VSS nfet_05v0 L=0.6U W=0.82U AS=0.3608P AD=0.1312P
+ PS=2.52U PD=1.14U
* device instance _162 r0 *1 575.365,827.31 nfet_05v0
XM_162 n_I2402 n_I2384 n_I2491 VSS nfet_05v0 L=0.6U W=0.82U AS=0.1312P
+ AD=0.3608P PS=1.14U PD=2.52U
* device instance _163 r180 *1 548.005,807.955 pfet_05v0
XM_163 n_I2381 n_I2335 VDD_DEC VDD_DEC pfet_05v0 L=0.5U W=1.13U AS=0.4972P
+ AD=0.2938P PS=3.14U PD=1.65U
* device instance _164 r180 *1 546.985,807.955 pfet_05v0
XM_164 VDD_DEC n_I2333 n_I2381 VDD_DEC pfet_05v0 L=0.5U W=1.13U AS=0.2938P
+ AD=0.4972P PS=1.65U PD=3.14U
* device instance _165 r180 *1 547.955,810.13 nfet_05v0
XM_165 n_I2492 n_I2335 VSS VSS nfet_05v0 L=0.6U W=0.82U AS=0.3608P AD=0.1312P
+ PS=2.52U PD=1.14U
* device instance _166 r180 *1 547.035,810.13 nfet_05v0
XM_166 n_I2381 n_I2333 n_I2492 VSS nfet_05v0 L=0.6U W=0.82U AS=0.1312P
+ AD=0.3608P PS=1.14U PD=2.52U
* device instance _167 m0 *1 495.68,823.59 pfet_05v0
XM_167 VDD_DEC n_I2500 n_I2499 VDD_DEC pfet_05v0 L=1U W=1.22U AS=0.5368P
+ AD=0.5368P PS=3.32U PD=3.32U
* device instance _168 m0 *1 493.44,823.59 pfet_05v0
XM_168 VDD_DEC n_I2498 n_I2497 VDD_DEC pfet_05v0 L=1U W=1.22U AS=0.5368P
+ AD=0.5368P PS=3.32U PD=3.32U
* device instance _169 m0 *1 491.2,823.59 pfet_05v0
XM_169 VDD_DEC n_I2496 n_I2495 VDD_DEC pfet_05v0 L=1U W=1.22U AS=0.5368P
+ AD=0.5368P PS=3.32U PD=3.32U
* device instance _170 m0 *1 488.96,823.59 pfet_05v0
XM_170 VDD_DEC n_I2494 n_I2493 VDD_DEC pfet_05v0 L=1U W=1.22U AS=0.5368P
+ AD=0.5368P PS=3.32U PD=3.32U
* device instance _171 m0 *1 495.68,825.81 nfet_05v0
XM_171 n_I2500 n_I2499 VSS VSS nfet_05v0 L=1U W=0.82U AS=0.3608P AD=0.3608P
+ PS=2.52U PD=2.52U
* device instance _172 m0 *1 493.44,825.81 nfet_05v0
XM_172 n_I2498 n_I2497 VSS VSS nfet_05v0 L=1U W=0.82U AS=0.3608P AD=0.3608P
+ PS=2.52U PD=2.52U
* device instance _173 m0 *1 491.2,825.81 nfet_05v0
XM_173 n_I2496 n_I2495 VSS VSS nfet_05v0 L=1U W=0.82U AS=0.3608P AD=0.3608P
+ PS=2.52U PD=2.52U
* device instance _174 m0 *1 488.96,825.81 nfet_05v0
XM_174 n_I2494 n_I2493 VSS VSS nfet_05v0 L=1U W=0.82U AS=0.3608P AD=0.3608P
+ PS=2.52U PD=2.52U
* device instance _175 m0 *1 665.36,831.43 pfet_05v0
XM_175 VDD_DEC n_I2508 n_I2507 VDD_DEC pfet_05v0 L=1U W=1.22U AS=0.5368P
+ AD=0.5368P PS=3.32U PD=3.32U
* device instance _176 m0 *1 663.12,831.43 pfet_05v0
XM_176 VDD_DEC n_I2506 n_I2505 VDD_DEC pfet_05v0 L=1U W=1.22U AS=0.5368P
+ AD=0.5368P PS=3.32U PD=3.32U
* device instance _177 m0 *1 660.88,831.43 pfet_05v0
XM_177 VDD_DEC n_I2504 n_I2503 VDD_DEC pfet_05v0 L=1U W=1.22U AS=0.5368P
+ AD=0.5368P PS=3.32U PD=3.32U
* device instance _178 m0 *1 658.64,831.43 pfet_05v0
XM_178 VDD_DEC n_I2502 n_I2501 VDD_DEC pfet_05v0 L=1U W=1.22U AS=0.5368P
+ AD=0.5368P PS=3.32U PD=3.32U
* device instance _179 m0 *1 665.36,833.65 nfet_05v0
XM_179 n_I2508 n_I2507 VSS VSS nfet_05v0 L=1U W=0.82U AS=0.3608P AD=0.3608P
+ PS=2.52U PD=2.52U
* device instance _180 m0 *1 663.12,833.65 nfet_05v0
XM_180 n_I2506 n_I2505 VSS VSS nfet_05v0 L=1U W=0.82U AS=0.3608P AD=0.3608P
+ PS=2.52U PD=2.52U
* device instance _181 m0 *1 660.88,833.65 nfet_05v0
XM_181 n_I2504 n_I2503 VSS VSS nfet_05v0 L=1U W=0.82U AS=0.3608P AD=0.3608P
+ PS=2.52U PD=2.52U
* device instance _182 m0 *1 658.64,833.65 nfet_05v0
XM_182 n_I2502 n_I2501 VSS VSS nfet_05v0 L=1U W=0.82U AS=0.3608P AD=0.3608P
+ PS=2.52U PD=2.52U
* device instance _183 r0 *1 656.96,837.37 pfet_05v0
XM_183 VDD_DEC n_I2516 n_I2515 VDD_DEC pfet_05v0 L=1U W=1.22U AS=0.5368P
+ AD=0.5368P PS=3.32U PD=3.32U
* device instance _184 r0 *1 654.72,837.37 pfet_05v0
XM_184 VDD_DEC n_I2514 n_I2513 VDD_DEC pfet_05v0 L=1U W=1.22U AS=0.5368P
+ AD=0.5368P PS=3.32U PD=3.32U
* device instance _185 r0 *1 652.48,837.37 pfet_05v0
XM_185 VDD_DEC n_I2512 n_I2511 VDD_DEC pfet_05v0 L=1U W=1.22U AS=0.5368P
+ AD=0.5368P PS=3.32U PD=3.32U
* device instance _186 r0 *1 650.24,837.37 pfet_05v0
XM_186 VDD_DEC n_I2510 n_I2509 VDD_DEC pfet_05v0 L=1U W=1.22U AS=0.5368P
+ AD=0.5368P PS=3.32U PD=3.32U
* device instance _187 r0 *1 656.96,835.15 nfet_05v0
XM_187 n_I2516 n_I2515 VSS VSS nfet_05v0 L=1U W=0.82U AS=0.3608P AD=0.3608P
+ PS=2.52U PD=2.52U
* device instance _188 r0 *1 654.72,835.15 nfet_05v0
XM_188 n_I2514 n_I2513 VSS VSS nfet_05v0 L=1U W=0.82U AS=0.3608P AD=0.3608P
+ PS=2.52U PD=2.52U
* device instance _189 r0 *1 652.48,835.15 nfet_05v0
XM_189 n_I2512 n_I2511 VSS VSS nfet_05v0 L=1U W=0.82U AS=0.3608P AD=0.3608P
+ PS=2.52U PD=2.52U
* device instance _190 r0 *1 650.24,835.15 nfet_05v0
XM_190 n_I2510 n_I2509 VSS VSS nfet_05v0 L=1U W=0.82U AS=0.3608P AD=0.3608P
+ PS=2.52U PD=2.52U
* device instance _191 r0 *1 599.84,837.37 pfet_05v0
XM_191 VDD_DEC n_I2524 n_I2523 VDD_DEC pfet_05v0 L=1U W=1.22U AS=0.5368P
+ AD=0.5368P PS=3.32U PD=3.32U
* device instance _192 r0 *1 597.6,837.37 pfet_05v0
XM_192 VDD_DEC n_I2522 n_I2521 VDD_DEC pfet_05v0 L=1U W=1.22U AS=0.5368P
+ AD=0.5368P PS=3.32U PD=3.32U
* device instance _193 r0 *1 595.36,837.37 pfet_05v0
XM_193 VDD_DEC n_I2520 n_I2519 VDD_DEC pfet_05v0 L=1U W=1.22U AS=0.5368P
+ AD=0.5368P PS=3.32U PD=3.32U
* device instance _194 r0 *1 593.12,837.37 pfet_05v0
XM_194 VDD_DEC n_I2518 n_I2517 VDD_DEC pfet_05v0 L=1U W=1.22U AS=0.5368P
+ AD=0.5368P PS=3.32U PD=3.32U
* device instance _195 r0 *1 599.84,835.15 nfet_05v0
XM_195 n_I2524 n_I2523 VSS VSS nfet_05v0 L=1U W=0.82U AS=0.3608P AD=0.3608P
+ PS=2.52U PD=2.52U
* device instance _196 r0 *1 597.6,835.15 nfet_05v0
XM_196 n_I2522 n_I2521 VSS VSS nfet_05v0 L=1U W=0.82U AS=0.3608P AD=0.3608P
+ PS=2.52U PD=2.52U
* device instance _197 r0 *1 595.36,835.15 nfet_05v0
XM_197 n_I2520 n_I2519 VSS VSS nfet_05v0 L=1U W=0.82U AS=0.3608P AD=0.3608P
+ PS=2.52U PD=2.52U
* device instance _198 r0 *1 593.12,835.15 nfet_05v0
XM_198 n_I2518 n_I2517 VSS VSS nfet_05v0 L=1U W=0.82U AS=0.3608P AD=0.3608P
+ PS=2.52U PD=2.52U
* device instance _199 r0 *1 514.72,837.37 pfet_05v0
XM_199 VDD_DEC n_I2532 n_I2531 VDD_DEC pfet_05v0 L=1U W=1.22U AS=0.5368P
+ AD=0.5368P PS=3.32U PD=3.32U
* device instance _200 r0 *1 512.48,837.37 pfet_05v0
XM_200 VDD_DEC n_I2530 n_I2529 VDD_DEC pfet_05v0 L=1U W=1.22U AS=0.5368P
+ AD=0.5368P PS=3.32U PD=3.32U
* device instance _201 r0 *1 510.24,837.37 pfet_05v0
XM_201 VDD_DEC n_I2528 n_I2527 VDD_DEC pfet_05v0 L=1U W=1.22U AS=0.5368P
+ AD=0.5368P PS=3.32U PD=3.32U
* device instance _202 r0 *1 508,837.37 pfet_05v0
XM_202 VDD_DEC n_I2526 n_I2525 VDD_DEC pfet_05v0 L=1U W=1.22U AS=0.5368P
+ AD=0.5368P PS=3.32U PD=3.32U
* device instance _203 r0 *1 514.72,835.15 nfet_05v0
XM_203 n_I2532 n_I2531 VSS VSS nfet_05v0 L=1U W=0.82U AS=0.3608P AD=0.3608P
+ PS=2.52U PD=2.52U
* device instance _204 r0 *1 512.48,835.15 nfet_05v0
XM_204 n_I2530 n_I2529 VSS VSS nfet_05v0 L=1U W=0.82U AS=0.3608P AD=0.3608P
+ PS=2.52U PD=2.52U
* device instance _205 r0 *1 510.24,835.15 nfet_05v0
XM_205 n_I2528 n_I2527 VSS VSS nfet_05v0 L=1U W=0.82U AS=0.3608P AD=0.3608P
+ PS=2.52U PD=2.52U
* device instance _206 r0 *1 508,835.15 nfet_05v0
XM_206 n_I2526 n_I2525 VSS VSS nfet_05v0 L=1U W=0.82U AS=0.3608P AD=0.3608P
+ PS=2.52U PD=2.52U
* device instance _207 r0 *1 495.68,829.53 pfet_05v0
XM_207 VDD_DEC n_I2540 n_I2539 VDD_DEC pfet_05v0 L=1U W=1.22U AS=0.5368P
+ AD=0.5368P PS=3.32U PD=3.32U
* device instance _208 r0 *1 493.44,829.53 pfet_05v0
XM_208 VDD_DEC n_I2538 n_I2537 VDD_DEC pfet_05v0 L=1U W=1.22U AS=0.5368P
+ AD=0.5368P PS=3.32U PD=3.32U
* device instance _209 r0 *1 491.2,829.53 pfet_05v0
XM_209 VDD_DEC n_I2536 n_I2535 VDD_DEC pfet_05v0 L=1U W=1.22U AS=0.5368P
+ AD=0.5368P PS=3.32U PD=3.32U
* device instance _210 r0 *1 488.96,829.53 pfet_05v0
XM_210 VDD_DEC n_I2534 n_I2533 VDD_DEC pfet_05v0 L=1U W=1.22U AS=0.5368P
+ AD=0.5368P PS=3.32U PD=3.32U
* device instance _211 r0 *1 495.68,827.31 nfet_05v0
XM_211 n_I2540 n_I2539 VSS VSS nfet_05v0 L=1U W=0.82U AS=0.3608P AD=0.3608P
+ PS=2.52U PD=2.52U
* device instance _212 r0 *1 493.44,827.31 nfet_05v0
XM_212 n_I2538 n_I2537 VSS VSS nfet_05v0 L=1U W=0.82U AS=0.3608P AD=0.3608P
+ PS=2.52U PD=2.52U
* device instance _213 r0 *1 491.2,827.31 nfet_05v0
XM_213 n_I2536 n_I2535 VSS VSS nfet_05v0 L=1U W=0.82U AS=0.3608P AD=0.3608P
+ PS=2.52U PD=2.52U
* device instance _214 r0 *1 488.96,827.31 nfet_05v0
XM_214 n_I2534 n_I2533 VSS VSS nfet_05v0 L=1U W=0.82U AS=0.3608P AD=0.3608P
+ PS=2.52U PD=2.52U
* device instance _215 m90 *1 523.83,837.37 pfet_05v0
XM_215 n_I2542 n_I2426 VDD_DEC VDD_DEC pfet_05v0 L=0.5U W=1.22U AS=0.5368P
+ AD=0.3172P PS=3.32U PD=1.74U
* device instance _216 m90 *1 522.81,837.37 pfet_05v0
XM_216 n_I2541 n_I2199 n_I2542 VDD_DEC pfet_05v0 L=0.5U W=1.22U AS=0.3172P
+ AD=0.3782P PS=1.74U PD=1.84U
* device instance _217 m90 *1 521.69,837.37 pfet_05v0
XM_217 n_I2201 n_I2200 n_I2541 VDD_DEC pfet_05v0 L=0.5U W=1.22U AS=0.3782P
+ AD=0.5368P PS=1.84U PD=3.32U
* device instance _218 m90 *1 523.88,835.157 nfet_05v0
XM_218 n_I2201 n_I2426 VSS VSS nfet_05v0 L=0.6U W=0.465U AS=0.2046P AD=0.1209P
+ PS=1.81U PD=0.985U
* device instance _219 m90 *1 522.76,835.157 nfet_05v0
XM_219 VSS n_I2199 n_I2201 VSS nfet_05v0 L=0.6U W=0.465U AS=0.1209P AD=0.1209P
+ PS=0.985U PD=0.985U
* device instance _220 m90 *1 521.64,835.157 nfet_05v0
XM_220 n_I2201 n_I2200 VSS VSS nfet_05v0 L=0.6U W=0.465U AS=0.1209P AD=0.2046P
+ PS=0.985U PD=1.81U
* device instance _221 m90 *1 611.19,813.85 pfet_05v0
XM_221 n_I2544 n_I2368 VDD_DEC VDD_DEC pfet_05v0 L=0.5U W=1.22U AS=0.5368P
+ AD=0.3172P PS=3.32U PD=1.74U
* device instance _222 m90 *1 610.17,813.85 pfet_05v0
XM_222 n_I2543 n_I2240 n_I2544 VDD_DEC pfet_05v0 L=0.5U W=1.22U AS=0.3172P
+ AD=0.3782P PS=1.74U PD=1.84U
* device instance _223 m90 *1 609.05,813.85 pfet_05v0
XM_223 n_I2056 n_I2236 n_I2543 VDD_DEC pfet_05v0 L=0.5U W=1.22U AS=0.3782P
+ AD=0.5368P PS=1.84U PD=3.32U
* device instance _224 m90 *1 611.24,811.637 nfet_05v0
XM_224 n_I2056 n_I2368 VSS VSS nfet_05v0 L=0.6U W=0.465U AS=0.2046P AD=0.1209P
+ PS=1.81U PD=0.985U
* device instance _225 m90 *1 610.12,811.637 nfet_05v0
XM_225 VSS n_I2240 n_I2056 VSS nfet_05v0 L=0.6U W=0.465U AS=0.1209P AD=0.1209P
+ PS=0.985U PD=0.985U
* device instance _226 m90 *1 609,811.637 nfet_05v0
XM_226 n_I2056 n_I2236 VSS VSS nfet_05v0 L=0.6U W=0.465U AS=0.1209P AD=0.2046P
+ PS=0.985U PD=1.81U
* device instance _227 m90 *1 628.55,813.85 pfet_05v0
XM_227 n_I2546 n_I2277 VDD_DEC VDD_DEC pfet_05v0 L=0.5U W=1.22U AS=0.5368P
+ AD=0.3172P PS=3.32U PD=1.74U
* device instance _228 m90 *1 627.53,813.85 pfet_05v0
XM_228 n_I2545 n_I2240 n_I2546 VDD_DEC pfet_05v0 L=0.5U W=1.22U AS=0.3172P
+ AD=0.3782P PS=1.74U PD=1.84U
* device instance _229 m90 *1 626.41,813.85 pfet_05v0
XM_229 n_I2137 n_I2239 n_I2545 VDD_DEC pfet_05v0 L=0.5U W=1.22U AS=0.3782P
+ AD=0.5368P PS=1.84U PD=3.32U
* device instance _230 m90 *1 628.6,811.637 nfet_05v0
XM_230 n_I2137 n_I2277 VSS VSS nfet_05v0 L=0.6U W=0.465U AS=0.2046P AD=0.1209P
+ PS=1.81U PD=0.985U
* device instance _231 m90 *1 627.48,811.637 nfet_05v0
XM_231 VSS n_I2240 n_I2137 VSS nfet_05v0 L=0.6U W=0.465U AS=0.1209P AD=0.1209P
+ PS=0.985U PD=0.985U
* device instance _232 m90 *1 626.36,811.637 nfet_05v0
XM_232 n_I2137 n_I2239 VSS VSS nfet_05v0 L=0.6U W=0.465U AS=0.1209P AD=0.2046P
+ PS=0.985U PD=1.81U
* device instance _233 m90 *1 528.31,829.53 pfet_05v0
XM_233 n_I2548 n_I2381 VDD_DEC VDD_DEC pfet_05v0 L=0.5U W=1.22U AS=0.5368P
+ AD=0.3172P PS=3.32U PD=1.74U
* device instance _234 m90 *1 527.29,829.53 pfet_05v0
XM_234 n_I2547 n_I2332 n_I2548 VDD_DEC pfet_05v0 L=0.5U W=1.22U AS=0.3172P
+ AD=0.3782P PS=1.74U PD=1.84U
* device instance _235 m90 *1 526.17,829.53 pfet_05v0
XM_235 n_I2160 n_I2331 n_I2547 VDD_DEC pfet_05v0 L=0.5U W=1.22U AS=0.3782P
+ AD=0.5368P PS=1.84U PD=3.32U
* device instance _236 m90 *1 528.36,827.317 nfet_05v0
XM_236 n_I2160 n_I2381 VSS VSS nfet_05v0 L=0.6U W=0.465U AS=0.2046P AD=0.1209P
+ PS=1.81U PD=0.985U
* device instance _237 m90 *1 527.24,827.317 nfet_05v0
XM_237 VSS n_I2332 n_I2160 VSS nfet_05v0 L=0.6U W=0.465U AS=0.1209P AD=0.1209P
+ PS=0.985U PD=0.985U
* device instance _238 m90 *1 526.12,827.317 nfet_05v0
XM_238 n_I2160 n_I2331 VSS VSS nfet_05v0 L=0.6U W=0.465U AS=0.1209P AD=0.2046P
+ PS=0.985U PD=1.81U
* device instance _239 m90 *1 569.19,829.53 pfet_05v0
XM_239 n_I2550 n_I2426 VDD_DEC VDD_DEC pfet_05v0 L=0.5U W=1.22U AS=0.5368P
+ AD=0.3172P PS=3.32U PD=1.74U
* device instance _240 m90 *1 568.17,829.53 pfet_05v0
XM_240 n_I2549 n_I2202 n_I2550 VDD_DEC pfet_05v0 L=0.5U W=1.22U AS=0.3172P
+ AD=0.3782P PS=1.74U PD=1.84U
* device instance _241 m90 *1 567.05,829.53 pfet_05v0
XM_241 n_I2131 n_I2203 n_I2549 VDD_DEC pfet_05v0 L=0.5U W=1.22U AS=0.3782P
+ AD=0.5368P PS=1.84U PD=3.32U
* device instance _242 m90 *1 569.24,827.317 nfet_05v0
XM_242 n_I2131 n_I2426 VSS VSS nfet_05v0 L=0.6U W=0.465U AS=0.2046P AD=0.1209P
+ PS=1.81U PD=0.985U
* device instance _243 m90 *1 568.12,827.317 nfet_05v0
XM_243 VSS n_I2202 n_I2131 VSS nfet_05v0 L=0.6U W=0.465U AS=0.1209P AD=0.1209P
+ PS=0.985U PD=0.985U
* device instance _244 m90 *1 567,827.317 nfet_05v0
XM_244 n_I2131 n_I2203 VSS VSS nfet_05v0 L=0.6U W=0.465U AS=0.1209P AD=0.2046P
+ PS=0.985U PD=1.81U
* device instance _245 m90 *1 505.35,829.53 pfet_05v0
XM_245 n_I2552 n_I2400 VDD_DEC VDD_DEC pfet_05v0 L=0.5U W=1.22U AS=0.5368P
+ AD=0.3172P PS=3.32U PD=1.74U
* device instance _246 m90 *1 504.33,829.53 pfet_05v0
XM_246 n_I2551 n_I2196 n_I2552 VDD_DEC pfet_05v0 L=0.5U W=1.22U AS=0.3172P
+ AD=0.3782P PS=1.74U PD=1.84U
* device instance _247 m90 *1 503.21,829.53 pfet_05v0
XM_247 n_I2122 n_I2195 n_I2551 VDD_DEC pfet_05v0 L=0.5U W=1.22U AS=0.3782P
+ AD=0.5368P PS=1.84U PD=3.32U
* device instance _248 m90 *1 505.4,827.317 nfet_05v0
XM_248 n_I2122 n_I2400 VSS VSS nfet_05v0 L=0.6U W=0.465U AS=0.2046P AD=0.1209P
+ PS=1.81U PD=0.985U
* device instance _249 m90 *1 504.28,827.317 nfet_05v0
XM_249 VSS n_I2196 n_I2122 VSS nfet_05v0 L=0.6U W=0.465U AS=0.1209P AD=0.1209P
+ PS=0.985U PD=0.985U
* device instance _250 m90 *1 503.16,827.317 nfet_05v0
XM_250 n_I2122 n_I2195 VSS VSS nfet_05v0 L=0.6U W=0.465U AS=0.1209P AD=0.2046P
+ PS=0.985U PD=1.81U
* device instance _251 m90 *1 548.47,837.37 pfet_05v0
XM_251 n_I2554 n_I2431 VDD_DEC VDD_DEC pfet_05v0 L=0.5U W=1.22U AS=0.5368P
+ AD=0.3172P PS=3.32U PD=1.74U
* device instance _252 m90 *1 547.45,837.37 pfet_05v0
XM_252 n_I2553 n_I2416 n_I2554 VDD_DEC pfet_05v0 L=0.5U W=1.22U AS=0.3172P
+ AD=0.3782P PS=1.74U PD=1.84U
* device instance _253 m90 *1 546.33,837.37 pfet_05v0
XM_253 n_I2051 n_I2359 n_I2553 VDD_DEC pfet_05v0 L=0.5U W=1.22U AS=0.3782P
+ AD=0.5368P PS=1.84U PD=3.32U
* device instance _254 m90 *1 548.52,835.157 nfet_05v0
XM_254 n_I2051 n_I2431 VSS VSS nfet_05v0 L=0.6U W=0.465U AS=0.2046P AD=0.1209P
+ PS=1.81U PD=0.985U
* device instance _255 m90 *1 547.4,835.157 nfet_05v0
XM_255 VSS n_I2416 n_I2051 VSS nfet_05v0 L=0.6U W=0.465U AS=0.1209P AD=0.1209P
+ PS=0.985U PD=0.985U
* device instance _256 m90 *1 546.28,835.157 nfet_05v0
XM_256 n_I2051 n_I2359 VSS VSS nfet_05v0 L=0.6U W=0.465U AS=0.1209P AD=0.2046P
+ PS=0.985U PD=1.81U
* device instance _257 m90 *1 559.11,829.53 pfet_05v0
XM_257 n_I2556 n_I2427 VDD_DEC VDD_DEC pfet_05v0 L=0.5U W=1.22U AS=0.5368P
+ AD=0.3172P PS=3.32U PD=1.74U
* device instance _258 m90 *1 558.09,829.53 pfet_05v0
XM_258 n_I2555 n_I2416 n_I2556 VDD_DEC pfet_05v0 L=0.5U W=1.22U AS=0.3172P
+ AD=0.3782P PS=1.74U PD=1.84U
* device instance _259 m90 *1 556.97,829.53 pfet_05v0
XM_259 n_I2279 n_I2359 n_I2555 VDD_DEC pfet_05v0 L=0.5U W=1.22U AS=0.3782P
+ AD=0.5368P PS=1.84U PD=3.32U
* device instance _260 m90 *1 559.16,827.317 nfet_05v0
XM_260 n_I2279 n_I2427 VSS VSS nfet_05v0 L=0.6U W=0.465U AS=0.2046P AD=0.1209P
+ PS=1.81U PD=0.985U
* device instance _261 m90 *1 558.04,827.317 nfet_05v0
XM_261 VSS n_I2416 n_I2279 VSS nfet_05v0 L=0.6U W=0.465U AS=0.1209P AD=0.1209P
+ PS=0.985U PD=0.985U
* device instance _262 m90 *1 556.92,827.317 nfet_05v0
XM_262 n_I2279 n_I2359 VSS VSS nfet_05v0 L=0.6U W=0.465U AS=0.1209P AD=0.2046P
+ PS=0.985U PD=1.81U
* device instance _263 m90 *1 523.83,829.53 pfet_05v0
XM_263 n_I2558 n_I2277 VDD_DEC VDD_DEC pfet_05v0 L=0.5U W=1.22U AS=0.5368P
+ AD=0.3172P PS=3.32U PD=1.74U
* device instance _264 m90 *1 522.81,829.53 pfet_05v0
XM_264 n_I2557 n_I2332 n_I2558 VDD_DEC pfet_05v0 L=0.5U W=1.22U AS=0.3172P
+ AD=0.3782P PS=1.74U PD=1.84U
* device instance _265 m90 *1 521.69,829.53 pfet_05v0
XM_265 n_I2021 n_I2359 n_I2557 VDD_DEC pfet_05v0 L=0.5U W=1.22U AS=0.3782P
+ AD=0.5368P PS=1.84U PD=3.32U
* device instance _266 m90 *1 523.88,827.317 nfet_05v0
XM_266 n_I2021 n_I2277 VSS VSS nfet_05v0 L=0.6U W=0.465U AS=0.2046P AD=0.1209P
+ PS=1.81U PD=0.985U
* device instance _267 m90 *1 522.76,827.317 nfet_05v0
XM_267 VSS n_I2332 n_I2021 VSS nfet_05v0 L=0.6U W=0.465U AS=0.1209P AD=0.1209P
+ PS=0.985U PD=0.985U
* device instance _268 m90 *1 521.64,827.317 nfet_05v0
XM_268 n_I2021 n_I2359 VSS VSS nfet_05v0 L=0.6U W=0.465U AS=0.1209P AD=0.2046P
+ PS=0.985U PD=1.81U
* device instance _269 m90 *1 505.35,821.69 pfet_05v0
XM_269 n_I2560 n_I2405 VDD_DEC VDD_DEC pfet_05v0 L=0.5U W=1.22U AS=0.5368P
+ AD=0.3172P PS=3.32U PD=1.74U
* device instance _270 m90 *1 504.33,821.69 pfet_05v0
XM_270 n_I2559 n_I2199 n_I2560 VDD_DEC pfet_05v0 L=0.5U W=1.22U AS=0.3172P
+ AD=0.3782P PS=1.74U PD=1.84U
* device instance _271 m90 *1 503.21,821.69 pfet_05v0
XM_271 n_I2124 n_I2200 n_I2559 VDD_DEC pfet_05v0 L=0.5U W=1.22U AS=0.3782P
+ AD=0.5368P PS=1.84U PD=3.32U
* device instance _272 m90 *1 505.4,819.477 nfet_05v0
XM_272 n_I2124 n_I2405 VSS VSS nfet_05v0 L=0.6U W=0.465U AS=0.2046P AD=0.1209P
+ PS=1.81U PD=0.985U
* device instance _273 m90 *1 504.28,819.477 nfet_05v0
XM_273 VSS n_I2199 n_I2124 VSS nfet_05v0 L=0.6U W=0.465U AS=0.1209P AD=0.1209P
+ PS=0.985U PD=0.985U
* device instance _274 m90 *1 503.16,819.477 nfet_05v0
XM_274 n_I2124 n_I2200 VSS VSS nfet_05v0 L=0.6U W=0.465U AS=0.1209P AD=0.2046P
+ PS=0.985U PD=1.81U
* device instance _275 m0 *1 570.57,823.59 pfet_05v0
XM_275 n_I2562 n_I2406 VDD_DEC VDD_DEC pfet_05v0 L=0.5U W=1.22U AS=0.5368P
+ AD=0.3172P PS=3.32U PD=1.74U
* device instance _276 m0 *1 571.59,823.59 pfet_05v0
XM_276 n_I2561 n_I2206 n_I2562 VDD_DEC pfet_05v0 L=0.5U W=1.22U AS=0.3172P
+ AD=0.3782P PS=1.74U PD=1.84U
* device instance _277 m0 *1 572.71,823.59 pfet_05v0
XM_277 n_I2209 n_I2236 n_I2561 VDD_DEC pfet_05v0 L=0.5U W=1.22U AS=0.3782P
+ AD=0.5368P PS=1.84U PD=3.32U
* device instance _278 m0 *1 570.52,825.803 nfet_05v0
XM_278 n_I2209 n_I2406 VSS VSS nfet_05v0 L=0.6U W=0.465U AS=0.2046P AD=0.1209P
+ PS=1.81U PD=0.985U
* device instance _279 m0 *1 571.64,825.803 nfet_05v0
XM_279 VSS n_I2206 n_I2209 VSS nfet_05v0 L=0.6U W=0.465U AS=0.1209P AD=0.1209P
+ PS=0.985U PD=0.985U
* device instance _280 m0 *1 572.76,825.803 nfet_05v0
XM_280 n_I2209 n_I2236 VSS VSS nfet_05v0 L=0.6U W=0.465U AS=0.1209P AD=0.2046P
+ PS=0.985U PD=1.81U
* device instance _281 m0 *1 528.01,792.23 pfet_05v0
XM_281 n_I2564 n_I2233 VDD_DEC VDD_DEC pfet_05v0 L=0.5U W=1.22U AS=0.5368P
+ AD=0.3172P PS=3.32U PD=1.74U
* device instance _282 m0 *1 529.03,792.23 pfet_05v0
XM_282 n_I2563 n_I2202 n_I2564 VDD_DEC pfet_05v0 L=0.5U W=1.22U AS=0.3172P
+ AD=0.3782P PS=1.74U PD=1.84U
* device instance _283 m0 *1 530.15,792.23 pfet_05v0
XM_283 n_I2127 n_I2203 n_I2563 VDD_DEC pfet_05v0 L=0.5U W=1.22U AS=0.3782P
+ AD=0.5368P PS=1.84U PD=3.32U
* device instance _284 m0 *1 527.96,794.443 nfet_05v0
XM_284 n_I2127 n_I2233 VSS VSS nfet_05v0 L=0.6U W=0.465U AS=0.2046P AD=0.1209P
+ PS=1.81U PD=0.985U
* device instance _285 m0 *1 529.08,794.443 nfet_05v0
XM_285 VSS n_I2202 n_I2127 VSS nfet_05v0 L=0.6U W=0.465U AS=0.1209P AD=0.1209P
+ PS=0.985U PD=0.985U
* device instance _286 m0 *1 530.2,794.443 nfet_05v0
XM_286 n_I2127 n_I2203 VSS VSS nfet_05v0 L=0.6U W=0.465U AS=0.1209P AD=0.2046P
+ PS=0.985U PD=1.81U
* device instance _287 m0 *1 619.85,800.07 pfet_05v0
XM_287 n_I2566 n_I2233 VDD_DEC VDD_DEC pfet_05v0 L=0.5U W=1.22U AS=0.5368P
+ AD=0.3172P PS=3.32U PD=1.74U
* device instance _288 m0 *1 620.87,800.07 pfet_05v0
XM_288 n_I2565 n_I2240 n_I2566 VDD_DEC pfet_05v0 L=0.5U W=1.22U AS=0.3172P
+ AD=0.3782P PS=1.74U PD=1.84U
* device instance _289 m0 *1 621.99,800.07 pfet_05v0
XM_289 n_I2257 n_I2239 n_I2565 VDD_DEC pfet_05v0 L=0.5U W=1.22U AS=0.3782P
+ AD=0.5368P PS=1.84U PD=3.32U
* device instance _290 m0 *1 619.8,802.283 nfet_05v0
XM_290 n_I2257 n_I2233 VSS VSS nfet_05v0 L=0.6U W=0.465U AS=0.2046P AD=0.1209P
+ PS=1.81U PD=0.985U
* device instance _291 m0 *1 620.92,802.283 nfet_05v0
XM_291 VSS n_I2240 n_I2257 VSS nfet_05v0 L=0.6U W=0.465U AS=0.1209P AD=0.1209P
+ PS=0.985U PD=0.985U
* device instance _292 m0 *1 622.04,802.283 nfet_05v0
XM_292 n_I2257 n_I2239 VSS VSS nfet_05v0 L=0.6U W=0.465U AS=0.1209P AD=0.2046P
+ PS=0.985U PD=1.81U
* device instance _293 m0 *1 645.61,807.91 pfet_05v0
XM_293 n_I2568 n_I2405 VDD_DEC VDD_DEC pfet_05v0 L=0.5U W=1.22U AS=0.5368P
+ AD=0.3172P PS=3.32U PD=1.74U
* device instance _294 m0 *1 646.63,807.91 pfet_05v0
XM_294 n_I2567 n_I2140 n_I2568 VDD_DEC pfet_05v0 L=0.5U W=1.22U AS=0.3172P
+ AD=0.3782P PS=1.74U PD=1.84U
* device instance _295 m0 *1 647.75,807.91 pfet_05v0
XM_295 n_I2327 n_I2138 n_I2567 VDD_DEC pfet_05v0 L=0.5U W=1.22U AS=0.3782P
+ AD=0.5368P PS=1.84U PD=3.32U
* device instance _296 m0 *1 645.56,810.123 nfet_05v0
XM_296 n_I2327 n_I2405 VSS VSS nfet_05v0 L=0.6U W=0.465U AS=0.2046P AD=0.1209P
+ PS=1.81U PD=0.985U
* device instance _297 m0 *1 646.68,810.123 nfet_05v0
XM_297 VSS n_I2140 n_I2327 VSS nfet_05v0 L=0.6U W=0.465U AS=0.1209P AD=0.1209P
+ PS=0.985U PD=0.985U
* device instance _298 m0 *1 647.8,810.123 nfet_05v0
XM_298 n_I2327 n_I2138 VSS VSS nfet_05v0 L=0.6U W=0.465U AS=0.1209P AD=0.2046P
+ PS=0.985U PD=1.81U
* device instance _299 m0 *1 610.89,823.59 pfet_05v0
XM_299 n_I2570 n_I2368 VDD_DEC VDD_DEC pfet_05v0 L=0.5U W=1.22U AS=0.5368P
+ AD=0.3172P PS=3.32U PD=1.74U
* device instance _300 m0 *1 611.91,823.59 pfet_05v0
XM_300 n_I2569 n_I2285 n_I2570 VDD_DEC pfet_05v0 L=0.5U W=1.22U AS=0.3172P
+ AD=0.3782P PS=1.74U PD=1.84U
* device instance _301 m0 *1 613.03,823.59 pfet_05v0
XM_301 n_I2420 n_I2213 n_I2569 VDD_DEC pfet_05v0 L=0.5U W=1.22U AS=0.3782P
+ AD=0.5368P PS=1.84U PD=3.32U
* device instance _302 m0 *1 610.84,825.803 nfet_05v0
XM_302 n_I2420 n_I2368 VSS VSS nfet_05v0 L=0.6U W=0.465U AS=0.2046P AD=0.1209P
+ PS=1.81U PD=0.985U
* device instance _303 m0 *1 611.96,825.803 nfet_05v0
XM_303 VSS n_I2285 n_I2420 VSS nfet_05v0 L=0.6U W=0.465U AS=0.1209P AD=0.1209P
+ PS=0.985U PD=0.985U
* device instance _304 m0 *1 613.08,825.803 nfet_05v0
XM_304 n_I2420 n_I2213 VSS VSS nfet_05v0 L=0.6U W=0.465U AS=0.1209P AD=0.2046P
+ PS=0.985U PD=1.81U
* device instance _305 m0 *1 615.93,823.59 pfet_05v0
XM_305 n_I2572 n_I2400 VDD_DEC VDD_DEC pfet_05v0 L=0.5U W=1.22U AS=0.5368P
+ AD=0.3172P PS=3.32U PD=1.74U
* device instance _306 m0 *1 616.95,823.59 pfet_05v0
XM_306 n_I2571 n_I2286 n_I2572 VDD_DEC pfet_05v0 L=0.5U W=1.22U AS=0.3172P
+ AD=0.3782P PS=1.74U PD=1.84U
* device instance _307 m0 *1 618.07,823.59 pfet_05v0
XM_307 n_I2245 n_I2213 n_I2571 VDD_DEC pfet_05v0 L=0.5U W=1.22U AS=0.3782P
+ AD=0.5368P PS=1.84U PD=3.32U
* device instance _308 m0 *1 615.88,825.803 nfet_05v0
XM_308 n_I2245 n_I2400 VSS VSS nfet_05v0 L=0.6U W=0.465U AS=0.2046P AD=0.1209P
+ PS=1.81U PD=0.985U
* device instance _309 m0 *1 617,825.803 nfet_05v0
XM_309 VSS n_I2286 n_I2245 VSS nfet_05v0 L=0.6U W=0.465U AS=0.1209P AD=0.1209P
+ PS=0.985U PD=0.985U
* device instance _310 m0 *1 618.12,825.803 nfet_05v0
XM_310 n_I2245 n_I2213 VSS VSS nfet_05v0 L=0.6U W=0.465U AS=0.1209P AD=0.2046P
+ PS=0.985U PD=1.81U
* device instance _311 m0 *1 600.81,815.75 pfet_05v0
XM_311 n_I2574 n_I2340 VDD_DEC VDD_DEC pfet_05v0 L=0.5U W=1.22U AS=0.5368P
+ AD=0.3172P PS=3.32U PD=1.74U
* device instance _312 m0 *1 601.83,815.75 pfet_05v0
XM_312 n_I2573 n_I2285 n_I2574 VDD_DEC pfet_05v0 L=0.5U W=1.22U AS=0.3172P
+ AD=0.3782P PS=1.74U PD=1.84U
* device instance _313 m0 *1 602.95,815.75 pfet_05v0
XM_313 n_I2103 n_I2213 n_I2573 VDD_DEC pfet_05v0 L=0.5U W=1.22U AS=0.3782P
+ AD=0.5368P PS=1.84U PD=3.32U
* device instance _314 m0 *1 600.76,817.963 nfet_05v0
XM_314 n_I2103 n_I2340 VSS VSS nfet_05v0 L=0.6U W=0.465U AS=0.2046P AD=0.1209P
+ PS=1.81U PD=0.985U
* device instance _315 m0 *1 601.88,817.963 nfet_05v0
XM_315 VSS n_I2285 n_I2103 VSS nfet_05v0 L=0.6U W=0.465U AS=0.1209P AD=0.1209P
+ PS=0.985U PD=0.985U
* device instance _316 m0 *1 603,817.963 nfet_05v0
XM_316 n_I2103 n_I2213 VSS VSS nfet_05v0 L=0.6U W=0.465U AS=0.1209P AD=0.2046P
+ PS=0.985U PD=1.81U
* device instance _317 m0 *1 595.21,815.75 pfet_05v0
XM_317 n_I2576 n_I2381 VDD_DEC VDD_DEC pfet_05v0 L=0.5U W=1.22U AS=0.5368P
+ AD=0.3172P PS=3.32U PD=1.74U
* device instance _318 m0 *1 596.23,815.75 pfet_05v0
XM_318 n_I2575 n_I2288 n_I2576 VDD_DEC pfet_05v0 L=0.5U W=1.22U AS=0.3172P
+ AD=0.3782P PS=1.74U PD=1.84U
* device instance _319 m0 *1 597.35,815.75 pfet_05v0
XM_319 n_I2173 n_I2252 n_I2575 VDD_DEC pfet_05v0 L=0.5U W=1.22U AS=0.3782P
+ AD=0.5368P PS=1.84U PD=3.32U
* device instance _320 m0 *1 595.16,817.963 nfet_05v0
XM_320 n_I2173 n_I2381 VSS VSS nfet_05v0 L=0.6U W=0.465U AS=0.2046P AD=0.1209P
+ PS=1.81U PD=0.985U
* device instance _321 m0 *1 596.28,817.963 nfet_05v0
XM_321 VSS n_I2288 n_I2173 VSS nfet_05v0 L=0.6U W=0.465U AS=0.1209P AD=0.1209P
+ PS=0.985U PD=0.985U
* device instance _322 m0 *1 597.4,817.963 nfet_05v0
XM_322 n_I2173 n_I2252 VSS VSS nfet_05v0 L=0.6U W=0.465U AS=0.1209P AD=0.2046P
+ PS=0.985U PD=1.81U
* device instance _323 r180 *1 511.51,831.43 pfet_05v0
XM_323 n_I2578 n_I2431 VDD_DEC VDD_DEC pfet_05v0 L=0.5U W=1.22U AS=0.5368P
+ AD=0.3172P PS=3.32U PD=1.74U
* device instance _324 r180 *1 510.49,831.43 pfet_05v0
XM_324 n_I2577 n_I2196 n_I2578 VDD_DEC pfet_05v0 L=0.5U W=1.22U AS=0.3172P
+ AD=0.3782P PS=1.74U PD=1.84U
* device instance _325 r180 *1 509.37,831.43 pfet_05v0
XM_325 n_I2307 n_I2195 n_I2577 VDD_DEC pfet_05v0 L=0.5U W=1.22U AS=0.3782P
+ AD=0.5368P PS=1.84U PD=3.32U
* device instance _326 r180 *1 511.56,833.643 nfet_05v0
XM_326 n_I2307 n_I2431 VSS VSS nfet_05v0 L=0.6U W=0.465U AS=0.2046P AD=0.1209P
+ PS=1.81U PD=0.985U
* device instance _327 r180 *1 510.44,833.643 nfet_05v0
XM_327 VSS n_I2196 n_I2307 VSS nfet_05v0 L=0.6U W=0.465U AS=0.1209P AD=0.1209P
+ PS=0.985U PD=0.985U
* device instance _328 r180 *1 509.32,833.643 nfet_05v0
XM_328 n_I2307 n_I2195 VSS VSS nfet_05v0 L=0.6U W=0.465U AS=0.1209P AD=0.2046P
+ PS=0.985U PD=1.81U
* device instance _329 r180 *1 515.99,831.43 pfet_05v0
XM_329 n_I2580 n_I2427 VDD_DEC VDD_DEC pfet_05v0 L=0.5U W=1.22U AS=0.5368P
+ AD=0.3172P PS=3.32U PD=1.74U
* device instance _330 r180 *1 514.97,831.43 pfet_05v0
XM_330 n_I2579 n_I2199 n_I2580 VDD_DEC pfet_05v0 L=0.5U W=1.22U AS=0.3172P
+ AD=0.3782P PS=1.74U PD=1.84U
* device instance _331 r180 *1 513.85,831.43 pfet_05v0
XM_331 n_I2019 n_I2195 n_I2579 VDD_DEC pfet_05v0 L=0.5U W=1.22U AS=0.3782P
+ AD=0.5368P PS=1.84U PD=3.32U
* device instance _332 r180 *1 516.04,833.643 nfet_05v0
XM_332 n_I2019 n_I2427 VSS VSS nfet_05v0 L=0.6U W=0.465U AS=0.2046P AD=0.1209P
+ PS=1.81U PD=0.985U
* device instance _333 r180 *1 514.92,833.643 nfet_05v0
XM_333 VSS n_I2199 n_I2019 VSS nfet_05v0 L=0.6U W=0.465U AS=0.1209P AD=0.1209P
+ PS=0.985U PD=0.985U
* device instance _334 r180 *1 513.8,833.643 nfet_05v0
XM_334 n_I2019 n_I2195 VSS VSS nfet_05v0 L=0.6U W=0.465U AS=0.1209P AD=0.2046P
+ PS=0.985U PD=1.81U
* device instance _335 r180 *1 520.47,831.43 pfet_05v0
XM_335 n_I2582 n_I2406 VDD_DEC VDD_DEC pfet_05v0 L=0.5U W=1.22U AS=0.5368P
+ AD=0.3172P PS=3.32U PD=1.74U
* device instance _336 r180 *1 519.45,831.43 pfet_05v0
XM_336 n_I2581 n_I2332 n_I2582 VDD_DEC pfet_05v0 L=0.5U W=1.22U AS=0.3172P
+ AD=0.3782P PS=1.74U PD=1.84U
* device instance _337 r180 *1 518.33,831.43 pfet_05v0
XM_337 n_I2308 n_I2331 n_I2581 VDD_DEC pfet_05v0 L=0.5U W=1.22U AS=0.3782P
+ AD=0.5368P PS=1.84U PD=3.32U
* device instance _338 r180 *1 520.52,833.643 nfet_05v0
XM_338 n_I2308 n_I2406 VSS VSS nfet_05v0 L=0.6U W=0.465U AS=0.2046P AD=0.1209P
+ PS=1.81U PD=0.985U
* device instance _339 r180 *1 519.4,833.643 nfet_05v0
XM_339 VSS n_I2332 n_I2308 VSS nfet_05v0 L=0.6U W=0.465U AS=0.1209P AD=0.1209P
+ PS=0.985U PD=0.985U
* device instance _340 r180 *1 518.28,833.643 nfet_05v0
XM_340 n_I2308 n_I2331 VSS VSS nfet_05v0 L=0.6U W=0.465U AS=0.1209P AD=0.2046P
+ PS=0.985U PD=1.81U
* device instance _341 r180 *1 585.43,823.59 pfet_05v0
XM_341 n_I2584 n_I2400 VDD_DEC VDD_DEC pfet_05v0 L=0.5U W=1.22U AS=0.5368P
+ AD=0.3172P PS=3.32U PD=1.74U
* device instance _342 r180 *1 584.41,823.59 pfet_05v0
XM_342 n_I2583 n_I2172 n_I2584 VDD_DEC pfet_05v0 L=0.5U W=1.22U AS=0.3172P
+ AD=0.3782P PS=1.74U PD=1.84U
* device instance _343 r180 *1 583.29,823.59 pfet_05v0
XM_343 n_I2067 n_I2171 n_I2583 VDD_DEC pfet_05v0 L=0.5U W=1.22U AS=0.3782P
+ AD=0.5368P PS=1.84U PD=3.32U
* device instance _344 r180 *1 585.48,825.803 nfet_05v0
XM_344 n_I2067 n_I2400 VSS VSS nfet_05v0 L=0.6U W=0.465U AS=0.2046P AD=0.1209P
+ PS=1.81U PD=0.985U
* device instance _345 r180 *1 584.36,825.803 nfet_05v0
XM_345 VSS n_I2172 n_I2067 VSS nfet_05v0 L=0.6U W=0.465U AS=0.1209P AD=0.1209P
+ PS=0.985U PD=0.985U
* device instance _346 r180 *1 583.24,825.803 nfet_05v0
XM_346 n_I2067 n_I2171 VSS VSS nfet_05v0 L=0.6U W=0.465U AS=0.1209P AD=0.2046P
+ PS=0.985U PD=1.81U
* device instance _347 r180 *1 510.39,823.59 pfet_05v0
XM_347 n_I2586 n_I2233 VDD_DEC VDD_DEC pfet_05v0 L=0.5U W=1.22U AS=0.5368P
+ AD=0.3172P PS=3.32U PD=1.74U
* device instance _348 r180 *1 509.37,823.59 pfet_05v0
XM_348 n_I2585 n_I2199 n_I2586 VDD_DEC pfet_05v0 L=0.5U W=1.22U AS=0.3172P
+ AD=0.3782P PS=1.74U PD=1.84U
* device instance _349 r180 *1 508.25,823.59 pfet_05v0
XM_349 n_I2020 n_I2200 n_I2585 VDD_DEC pfet_05v0 L=0.5U W=1.22U AS=0.3782P
+ AD=0.5368P PS=1.84U PD=3.32U
* device instance _350 r180 *1 510.44,825.803 nfet_05v0
XM_350 n_I2020 n_I2233 VSS VSS nfet_05v0 L=0.6U W=0.465U AS=0.2046P AD=0.1209P
+ PS=1.81U PD=0.985U
* device instance _351 r180 *1 509.32,825.803 nfet_05v0
XM_351 VSS n_I2199 n_I2020 VSS nfet_05v0 L=0.6U W=0.465U AS=0.1209P AD=0.1209P
+ PS=0.985U PD=0.985U
* device instance _352 r180 *1 508.2,825.803 nfet_05v0
XM_352 n_I2020 n_I2200 VSS VSS nfet_05v0 L=0.6U W=0.465U AS=0.1209P AD=0.2046P
+ PS=0.985U PD=1.81U
* device instance _353 r180 *1 588.79,807.91 pfet_05v0
XM_353 n_I2588 n_I2340 VDD_DEC VDD_DEC pfet_05v0 L=0.5U W=1.22U AS=0.5368P
+ AD=0.3172P PS=3.32U PD=1.74U
* device instance _354 r180 *1 587.77,807.91 pfet_05v0
XM_354 n_I2587 n_I2211 n_I2588 VDD_DEC pfet_05v0 L=0.5U W=1.22U AS=0.3172P
+ AD=0.3782P PS=1.74U PD=1.84U
* device instance _355 r180 *1 586.65,807.91 pfet_05v0
XM_355 n_I2234 n_I2236 n_I2587 VDD_DEC pfet_05v0 L=0.5U W=1.22U AS=0.3782P
+ AD=0.5368P PS=1.84U PD=3.32U
* device instance _356 r180 *1 588.84,810.123 nfet_05v0
XM_356 n_I2234 n_I2340 VSS VSS nfet_05v0 L=0.6U W=0.465U AS=0.2046P AD=0.1209P
+ PS=1.81U PD=0.985U
* device instance _357 r180 *1 587.72,810.123 nfet_05v0
XM_357 VSS n_I2211 n_I2234 VSS nfet_05v0 L=0.6U W=0.465U AS=0.1209P AD=0.1209P
+ PS=0.985U PD=0.985U
* device instance _358 r180 *1 586.6,810.123 nfet_05v0
XM_358 n_I2234 n_I2236 VSS VSS nfet_05v0 L=0.6U W=0.465U AS=0.1209P AD=0.2046P
+ PS=0.985U PD=1.81U
* device instance _359 r180 *1 554.63,823.59 pfet_05v0
XM_359 n_I2590 n_I2405 VDD_DEC VDD_DEC pfet_05v0 L=0.5U W=1.22U AS=0.5368P
+ AD=0.3172P PS=3.32U PD=1.74U
* device instance _360 r180 *1 553.61,823.59 pfet_05v0
XM_360 n_I2589 n_I2416 n_I2590 VDD_DEC pfet_05v0 L=0.5U W=1.22U AS=0.3172P
+ AD=0.3782P PS=1.74U PD=1.84U
* device instance _361 r180 *1 552.49,823.59 pfet_05v0
XM_361 n_I2162 n_I2203 n_I2589 VDD_DEC pfet_05v0 L=0.5U W=1.22U AS=0.3782P
+ AD=0.5368P PS=1.84U PD=3.32U
* device instance _362 r180 *1 554.68,825.803 nfet_05v0
XM_362 n_I2162 n_I2405 VSS VSS nfet_05v0 L=0.6U W=0.465U AS=0.2046P AD=0.1209P
+ PS=1.81U PD=0.985U
* device instance _363 r180 *1 553.56,825.803 nfet_05v0
XM_363 VSS n_I2416 n_I2162 VSS nfet_05v0 L=0.6U W=0.465U AS=0.1209P AD=0.1209P
+ PS=0.985U PD=0.985U
* device instance _364 r180 *1 552.44,825.803 nfet_05v0
XM_364 n_I2162 n_I2203 VSS VSS nfet_05v0 L=0.6U W=0.465U AS=0.1209P AD=0.2046P
+ PS=0.985U PD=1.81U
* device instance _365 r180 *1 559.11,831.43 pfet_05v0
XM_365 n_I2592 n_I2400 VDD_DEC VDD_DEC pfet_05v0 L=0.5U W=1.22U AS=0.5368P
+ AD=0.3172P PS=3.32U PD=1.74U
* device instance _366 r180 *1 558.09,831.43 pfet_05v0
XM_366 n_I2591 n_I2416 n_I2592 VDD_DEC pfet_05v0 L=0.5U W=1.22U AS=0.3172P
+ AD=0.3782P PS=1.74U PD=1.84U
* device instance _367 r180 *1 556.97,831.43 pfet_05v0
XM_367 n_I2128 n_I2359 n_I2591 VDD_DEC pfet_05v0 L=0.5U W=1.22U AS=0.3782P
+ AD=0.5368P PS=1.84U PD=3.32U
* device instance _368 r180 *1 559.16,833.643 nfet_05v0
XM_368 n_I2128 n_I2400 VSS VSS nfet_05v0 L=0.6U W=0.465U AS=0.2046P AD=0.1209P
+ PS=1.81U PD=0.985U
* device instance _369 r180 *1 558.04,833.643 nfet_05v0
XM_369 VSS n_I2416 n_I2128 VSS nfet_05v0 L=0.6U W=0.465U AS=0.1209P AD=0.1209P
+ PS=0.985U PD=0.985U
* device instance _370 r180 *1 556.92,833.643 nfet_05v0
XM_370 n_I2128 n_I2359 VSS VSS nfet_05v0 L=0.6U W=0.465U AS=0.1209P AD=0.2046P
+ PS=0.985U PD=1.81U
* device instance _371 r180 *1 535.59,831.43 pfet_05v0
XM_371 n_I2594 n_I2354 VDD_DEC VDD_DEC pfet_05v0 L=0.5U W=1.22U AS=0.5368P
+ AD=0.3172P PS=3.32U PD=1.74U
* device instance _372 r180 *1 534.57,831.43 pfet_05v0
XM_372 n_I2593 n_I2322 n_I2594 VDD_DEC pfet_05v0 L=0.5U W=1.22U AS=0.3172P
+ AD=0.3782P PS=1.74U PD=1.84U
* device instance _373 r180 *1 533.45,831.43 pfet_05v0
XM_373 n_I2399 n_I2353 n_I2593 VDD_DEC pfet_05v0 L=0.5U W=1.22U AS=0.3782P
+ AD=0.5368P PS=1.84U PD=3.32U
* device instance _374 r180 *1 535.64,833.643 nfet_05v0
XM_374 n_I2399 n_I2354 VSS VSS nfet_05v0 L=0.6U W=0.465U AS=0.2046P AD=0.1209P
+ PS=1.81U PD=0.985U
* device instance _375 r180 *1 534.52,833.643 nfet_05v0
XM_375 VSS n_I2322 n_I2399 VSS nfet_05v0 L=0.6U W=0.465U AS=0.1209P AD=0.1209P
+ PS=0.985U PD=0.985U
* device instance _376 r180 *1 533.4,833.643 nfet_05v0
XM_376 n_I2399 n_I2353 VSS VSS nfet_05v0 L=0.6U W=0.465U AS=0.1209P AD=0.2046P
+ PS=0.985U PD=1.81U
* device instance _377 r180 *1 671.11,807.91 pfet_05v0
XM_377 n_I2596 n_I2406 VDD_DEC VDD_DEC pfet_05v0 L=0.5U W=1.22U AS=0.5368P
+ AD=0.3172P PS=3.32U PD=1.74U
* device instance _378 r180 *1 670.09,807.91 pfet_05v0
XM_378 n_I2595 n_I2176 n_I2596 VDD_DEC pfet_05v0 L=0.5U W=1.22U AS=0.3172P
+ AD=0.3782P PS=1.74U PD=1.84U
* device instance _379 r180 *1 668.97,807.91 pfet_05v0
XM_379 n_I2409 n_I2177 n_I2595 VDD_DEC pfet_05v0 L=0.5U W=1.22U AS=0.3782P
+ AD=0.5368P PS=1.84U PD=3.32U
* device instance _380 r180 *1 671.16,810.123 nfet_05v0
XM_380 n_I2409 n_I2406 VSS VSS nfet_05v0 L=0.6U W=0.465U AS=0.2046P AD=0.1209P
+ PS=1.81U PD=0.985U
* device instance _381 r180 *1 670.04,810.123 nfet_05v0
XM_381 VSS n_I2176 n_I2409 VSS nfet_05v0 L=0.6U W=0.465U AS=0.1209P AD=0.1209P
+ PS=0.985U PD=0.985U
* device instance _382 r180 *1 668.92,810.123 nfet_05v0
XM_382 n_I2409 n_I2177 VSS VSS nfet_05v0 L=0.6U W=0.465U AS=0.1209P AD=0.2046P
+ PS=0.985U PD=1.81U
* device instance _383 r0 *1 597.45,821.69 pfet_05v0
XM_383 n_I2598 n_I2426 VDD_DEC VDD_DEC pfet_05v0 L=0.5U W=1.22U AS=0.5368P
+ AD=0.3172P PS=3.32U PD=1.74U
* device instance _384 r0 *1 598.47,821.69 pfet_05v0
XM_384 n_I2597 n_I2240 n_I2598 VDD_DEC pfet_05v0 L=0.5U W=1.22U AS=0.3172P
+ AD=0.3782P PS=1.74U PD=1.84U
* device instance _385 r0 *1 599.59,821.69 pfet_05v0
XM_385 n_I2072 n_I2239 n_I2597 VDD_DEC pfet_05v0 L=0.5U W=1.22U AS=0.3782P
+ AD=0.5368P PS=1.84U PD=3.32U
* device instance _386 r0 *1 597.4,819.477 nfet_05v0
XM_386 n_I2072 n_I2426 VSS VSS nfet_05v0 L=0.6U W=0.465U AS=0.2046P AD=0.1209P
+ PS=1.81U PD=0.985U
* device instance _387 r0 *1 598.52,819.477 nfet_05v0
XM_387 VSS n_I2240 n_I2072 VSS nfet_05v0 L=0.6U W=0.465U AS=0.1209P AD=0.1209P
+ PS=0.985U PD=0.985U
* device instance _388 r0 *1 599.64,819.477 nfet_05v0
XM_388 n_I2072 n_I2239 VSS VSS nfet_05v0 L=0.6U W=0.465U AS=0.1209P AD=0.2046P
+ PS=0.985U PD=1.81U
* device instance _389 r0 *1 592.97,821.69 pfet_05v0
XM_389 n_I2600 n_I2405 VDD_DEC VDD_DEC pfet_05v0 L=0.5U W=1.22U AS=0.5368P
+ AD=0.3172P PS=3.32U PD=1.74U
* device instance _390 r0 *1 593.99,821.69 pfet_05v0
XM_390 n_I2599 n_I2172 n_I2600 VDD_DEC pfet_05v0 L=0.5U W=1.22U AS=0.3172P
+ AD=0.3782P PS=1.74U PD=1.84U
* device instance _391 r0 *1 595.11,821.69 pfet_05v0
XM_391 n_I2367 n_I2171 n_I2599 VDD_DEC pfet_05v0 L=0.5U W=1.22U AS=0.3782P
+ AD=0.5368P PS=1.84U PD=3.32U
* device instance _392 r0 *1 592.92,819.477 nfet_05v0
XM_392 n_I2367 n_I2405 VSS VSS nfet_05v0 L=0.6U W=0.465U AS=0.2046P AD=0.1209P
+ PS=1.81U PD=0.985U
* device instance _393 r0 *1 594.04,819.477 nfet_05v0
XM_393 VSS n_I2172 n_I2367 VSS nfet_05v0 L=0.6U W=0.465U AS=0.1209P AD=0.1209P
+ PS=0.985U PD=0.985U
* device instance _394 r0 *1 595.16,819.477 nfet_05v0
XM_394 n_I2367 n_I2171 VSS VSS nfet_05v0 L=0.6U W=0.465U AS=0.1209P AD=0.2046P
+ PS=0.985U PD=1.81U
* device instance _395 r0 *1 659.61,798.17 pfet_05v0
XM_395 n_I2602 n_I2233 VDD_DEC VDD_DEC pfet_05v0 L=0.5U W=1.22U AS=0.5368P
+ AD=0.3172P PS=3.32U PD=1.74U
* device instance _396 r0 *1 660.63,798.17 pfet_05v0
XM_396 n_I2601 n_I2140 n_I2602 VDD_DEC pfet_05v0 L=0.5U W=1.22U AS=0.3172P
+ AD=0.3782P PS=1.74U PD=1.84U
* device instance _397 r0 *1 661.75,798.17 pfet_05v0
XM_397 n_I2244 n_I2138 n_I2601 VDD_DEC pfet_05v0 L=0.5U W=1.22U AS=0.3782P
+ AD=0.5368P PS=1.84U PD=3.32U
* device instance _398 r0 *1 659.56,795.957 nfet_05v0
XM_398 n_I2244 n_I2233 VSS VSS nfet_05v0 L=0.6U W=0.465U AS=0.2046P AD=0.1209P
+ PS=1.81U PD=0.985U
* device instance _399 r0 *1 660.68,795.957 nfet_05v0
XM_399 VSS n_I2140 n_I2244 VSS nfet_05v0 L=0.6U W=0.465U AS=0.1209P AD=0.1209P
+ PS=0.985U PD=0.985U
* device instance _400 r0 *1 661.8,795.957 nfet_05v0
XM_400 n_I2244 n_I2138 VSS VSS nfet_05v0 L=0.6U W=0.465U AS=0.1209P AD=0.2046P
+ PS=0.985U PD=1.81U
* device instance _401 r0 *1 548.17,798.17 pfet_05v0
XM_401 n_I2604 n_I2277 VDD_DEC VDD_DEC pfet_05v0 L=0.5U W=1.22U AS=0.5368P
+ AD=0.3172P PS=3.32U PD=1.74U
* device instance _402 r0 *1 549.19,798.17 pfet_05v0
XM_402 n_I2603 n_I2206 n_I2604 VDD_DEC pfet_05v0 L=0.5U W=1.22U AS=0.3172P
+ AD=0.3782P PS=1.74U PD=1.84U
* device instance _403 r0 *1 550.31,798.17 pfet_05v0
XM_403 n_I2061 n_I2236 n_I2603 VDD_DEC pfet_05v0 L=0.5U W=1.22U AS=0.3782P
+ AD=0.5368P PS=1.84U PD=3.32U
* device instance _404 r0 *1 548.12,795.957 nfet_05v0
XM_404 n_I2061 n_I2277 VSS VSS nfet_05v0 L=0.6U W=0.465U AS=0.2046P AD=0.1209P
+ PS=1.81U PD=0.985U
* device instance _405 r0 *1 549.24,795.957 nfet_05v0
XM_405 VSS n_I2206 n_I2061 VSS nfet_05v0 L=0.6U W=0.465U AS=0.1209P AD=0.1209P
+ PS=0.985U PD=0.985U
* device instance _406 r0 *1 550.36,795.957 nfet_05v0
XM_406 n_I2061 n_I2236 VSS VSS nfet_05v0 L=0.6U W=0.465U AS=0.1209P AD=0.2046P
+ PS=0.985U PD=1.81U
* device instance _407 r0 *1 617.05,829.53 pfet_05v0
XM_407 n_I2606 n_I2431 VDD_DEC VDD_DEC pfet_05v0 L=0.5U W=1.22U AS=0.5368P
+ AD=0.3172P PS=3.32U PD=1.74U
* device instance _408 r0 *1 618.07,829.53 pfet_05v0
XM_408 n_I2605 n_I2286 n_I2606 VDD_DEC pfet_05v0 L=0.5U W=1.22U AS=0.3172P
+ AD=0.3782P PS=1.74U PD=1.84U
* device instance _409 r0 *1 619.19,829.53 pfet_05v0
XM_409 n_I2032 n_I2213 n_I2605 VDD_DEC pfet_05v0 L=0.5U W=1.22U AS=0.3782P
+ AD=0.5368P PS=1.84U PD=3.32U
* device instance _410 r0 *1 617,827.317 nfet_05v0
XM_410 n_I2032 n_I2431 VSS VSS nfet_05v0 L=0.6U W=0.465U AS=0.2046P AD=0.1209P
+ PS=1.81U PD=0.985U
* device instance _411 r0 *1 618.12,827.317 nfet_05v0
XM_411 VSS n_I2286 n_I2032 VSS nfet_05v0 L=0.6U W=0.465U AS=0.1209P AD=0.1209P
+ PS=0.985U PD=0.985U
* device instance _412 r0 *1 619.24,827.317 nfet_05v0
XM_412 n_I2032 n_I2213 VSS VSS nfet_05v0 L=0.6U W=0.465U AS=0.1209P AD=0.2046P
+ PS=0.985U PD=1.81U
* device instance _413 r0 *1 610.33,829.53 pfet_05v0
XM_413 n_I2608 n_I2406 VDD_DEC VDD_DEC pfet_05v0 L=0.5U W=1.22U AS=0.5368P
+ AD=0.3172P PS=3.32U PD=1.74U
* device instance _414 r0 *1 611.35,829.53 pfet_05v0
XM_414 n_I2607 n_I2240 n_I2608 VDD_DEC pfet_05v0 L=0.5U W=1.22U AS=0.3172P
+ AD=0.3782P PS=1.74U PD=1.84U
* device instance _415 r0 *1 612.47,829.53 pfet_05v0
XM_415 n_I2073 n_I2239 n_I2607 VDD_DEC pfet_05v0 L=0.5U W=1.22U AS=0.3782P
+ AD=0.5368P PS=1.84U PD=3.32U
* device instance _416 r0 *1 610.28,827.317 nfet_05v0
XM_416 n_I2073 n_I2406 VSS VSS nfet_05v0 L=0.6U W=0.465U AS=0.2046P AD=0.1209P
+ PS=1.81U PD=0.985U
* device instance _417 r0 *1 611.4,827.317 nfet_05v0
XM_417 VSS n_I2240 n_I2073 VSS nfet_05v0 L=0.6U W=0.465U AS=0.1209P AD=0.1209P
+ PS=0.985U PD=0.985U
* device instance _418 r0 *1 612.52,827.317 nfet_05v0
XM_418 n_I2073 n_I2239 VSS VSS nfet_05v0 L=0.6U W=0.465U AS=0.1209P AD=0.2046P
+ PS=0.985U PD=1.81U
* device instance _419 r0 *1 626.01,829.53 pfet_05v0
XM_419 n_I2610 n_I2427 VDD_DEC VDD_DEC pfet_05v0 L=0.5U W=1.22U AS=0.5368P
+ AD=0.3172P PS=3.32U PD=1.74U
* device instance _420 r0 *1 627.03,829.53 pfet_05v0
XM_420 n_I2609 n_I2140 n_I2610 VDD_DEC pfet_05v0 L=0.5U W=1.22U AS=0.3172P
+ AD=0.3782P PS=1.74U PD=1.84U
* device instance _421 r0 *1 628.15,829.53 pfet_05v0
XM_421 n_I2076 n_I2138 n_I2609 VDD_DEC pfet_05v0 L=0.5U W=1.22U AS=0.3782P
+ AD=0.5368P PS=1.84U PD=3.32U
* device instance _422 r0 *1 625.96,827.317 nfet_05v0
XM_422 n_I2076 n_I2427 VSS VSS nfet_05v0 L=0.6U W=0.465U AS=0.2046P AD=0.1209P
+ PS=1.81U PD=0.985U
* device instance _423 r0 *1 627.08,827.317 nfet_05v0
XM_423 VSS n_I2140 n_I2076 VSS nfet_05v0 L=0.6U W=0.465U AS=0.1209P AD=0.1209P
+ PS=0.985U PD=0.985U
* device instance _424 r0 *1 628.2,827.317 nfet_05v0
XM_424 n_I2076 n_I2138 VSS VSS nfet_05v0 L=0.6U W=0.465U AS=0.1209P AD=0.2046P
+ PS=0.985U PD=1.81U
* device instance _425 r0 *1 665.21,813.85 pfet_05v0
XM_425 n_I2612 n_I2277 VDD_DEC VDD_DEC pfet_05v0 L=0.5U W=1.22U AS=0.5368P
+ AD=0.3172P PS=3.32U PD=1.74U
* device instance _426 r0 *1 666.23,813.85 pfet_05v0
XM_426 n_I2611 n_I2176 n_I2612 VDD_DEC pfet_05v0 L=0.5U W=1.22U AS=0.3172P
+ AD=0.3782P PS=1.74U PD=1.84U
* device instance _427 r0 *1 667.35,813.85 pfet_05v0
XM_427 n_I2370 n_I2177 n_I2611 VDD_DEC pfet_05v0 L=0.5U W=1.22U AS=0.3782P
+ AD=0.5368P PS=1.84U PD=3.32U
* device instance _428 r0 *1 665.16,811.637 nfet_05v0
XM_428 n_I2370 n_I2277 VSS VSS nfet_05v0 L=0.6U W=0.465U AS=0.2046P AD=0.1209P
+ PS=1.81U PD=0.985U
* device instance _429 r0 *1 666.28,811.637 nfet_05v0
XM_429 VSS n_I2176 n_I2370 VSS nfet_05v0 L=0.6U W=0.465U AS=0.1209P AD=0.1209P
+ PS=0.985U PD=0.985U
* device instance _430 r0 *1 667.4,811.637 nfet_05v0
XM_430 n_I2370 n_I2177 VSS VSS nfet_05v0 L=0.6U W=0.465U AS=0.1209P AD=0.2046P
+ PS=0.985U PD=1.81U
* device instance _431 r0 *1 572.25,798.17 pfet_05v0
XM_431 n_I2614 n_I2427 VDD_DEC VDD_DEC pfet_05v0 L=0.5U W=1.22U AS=0.5368P
+ AD=0.3172P PS=3.32U PD=1.74U
* device instance _432 r0 *1 573.27,798.17 pfet_05v0
XM_432 n_I2613 n_I2172 n_I2614 VDD_DEC pfet_05v0 L=0.5U W=1.22U AS=0.3172P
+ AD=0.3782P PS=1.74U PD=1.84U
* device instance _433 r0 *1 574.39,798.17 pfet_05v0
XM_433 n_I2133 n_I2171 n_I2613 VDD_DEC pfet_05v0 L=0.5U W=1.22U AS=0.3782P
+ AD=0.5368P PS=1.84U PD=3.32U
* device instance _434 r0 *1 572.2,795.957 nfet_05v0
XM_434 n_I2133 n_I2427 VSS VSS nfet_05v0 L=0.6U W=0.465U AS=0.2046P AD=0.1209P
+ PS=1.81U PD=0.985U
* device instance _435 r0 *1 573.32,795.957 nfet_05v0
XM_435 VSS n_I2172 n_I2133 VSS nfet_05v0 L=0.6U W=0.465U AS=0.1209P AD=0.1209P
+ PS=0.985U PD=0.985U
* device instance _436 r0 *1 574.44,795.957 nfet_05v0
XM_436 n_I2133 n_I2171 VSS VSS nfet_05v0 L=0.6U W=0.465U AS=0.1209P AD=0.2046P
+ PS=0.985U PD=1.81U
* device instance _437 r0 *1 634.97,829.53 pfet_05v0
XM_437 n_I2616 n_I2426 VDD_DEC VDD_DEC pfet_05v0 L=0.5U W=1.22U AS=0.5368P
+ AD=0.3172P PS=3.32U PD=1.74U
* device instance _438 r0 *1 635.99,829.53 pfet_05v0
XM_438 n_I2615 n_I2140 n_I2616 VDD_DEC pfet_05v0 L=0.5U W=1.22U AS=0.3172P
+ AD=0.3782P PS=1.74U PD=1.84U
* device instance _439 r0 *1 637.11,829.53 pfet_05v0
XM_439 n_I2417 n_I2177 n_I2615 VDD_DEC pfet_05v0 L=0.5U W=1.22U AS=0.3782P
+ AD=0.5368P PS=1.84U PD=3.32U
* device instance _440 r0 *1 634.92,827.317 nfet_05v0
XM_440 n_I2417 n_I2426 VSS VSS nfet_05v0 L=0.6U W=0.465U AS=0.2046P AD=0.1209P
+ PS=1.81U PD=0.985U
* device instance _441 r0 *1 636.04,827.317 nfet_05v0
XM_441 VSS n_I2140 n_I2417 VSS nfet_05v0 L=0.6U W=0.465U AS=0.1209P AD=0.1209P
+ PS=0.985U PD=0.985U
* device instance _442 r0 *1 637.16,827.317 nfet_05v0
XM_442 n_I2417 n_I2177 VSS VSS nfet_05v0 L=0.6U W=0.465U AS=0.1209P AD=0.2046P
+ PS=0.985U PD=1.81U
* device instance _443 m90 *1 599.43,774.65 pfet_05v0
XM_443 n_I2618 n_I2431 VDD_DEC VDD_DEC pfet_05v0 L=0.5U W=1.22U AS=0.5368P
+ AD=0.3172P PS=3.32U PD=1.74U
* device instance _444 m90 *1 598.41,774.65 pfet_05v0
XM_444 n_I2617 n_I2172 n_I2618 VDD_DEC pfet_05v0 L=0.5U W=1.22U AS=0.3172P
+ AD=0.3782P PS=1.74U PD=1.84U
* device instance _445 m90 *1 597.29,774.65 pfet_05v0
XM_445 n_I2135 n_I2171 n_I2617 VDD_DEC pfet_05v0 L=0.5U W=1.22U AS=0.3782P
+ AD=0.5368P PS=1.84U PD=3.32U
* device instance _446 m90 *1 599.48,772.437 nfet_05v0
XM_446 n_I2135 n_I2431 VSS VSS nfet_05v0 L=0.6U W=0.465U AS=0.2046P AD=0.1209P
+ PS=1.81U PD=0.985U
* device instance _447 m90 *1 598.36,772.437 nfet_05v0
XM_447 VSS n_I2172 n_I2135 VSS nfet_05v0 L=0.6U W=0.465U AS=0.1209P AD=0.1209P
+ PS=0.985U PD=0.985U
* device instance _448 m90 *1 597.24,772.437 nfet_05v0
XM_448 n_I2135 n_I2171 VSS VSS nfet_05v0 L=0.6U W=0.465U AS=0.1209P AD=0.2046P
+ PS=0.985U PD=1.81U
* device instance _449 m0 *1 615.52,831.43 pfet_05v0
XM_449 VDD_DEC n_I2639 n_I2623 VDD_DEC pfet_05v0 L=1U W=1.22U AS=0.5368P
+ AD=0.5368P PS=3.32U PD=3.32U
* device instance _450 m0 *1 635.68,831.43 pfet_05v0
XM_450 VDD_DEC n_I2648 n_I2632 VDD_DEC pfet_05v0 L=1U W=1.22U AS=0.5368P
+ AD=0.5368P PS=3.32U PD=3.32U
* device instance _451 m0 *1 613.28,831.43 pfet_05v0
XM_451 VDD_DEC n_I2638 n_I2622 VDD_DEC pfet_05v0 L=1U W=1.22U AS=0.5368P
+ AD=0.5368P PS=3.32U PD=3.32U
* device instance _452 m0 *1 617.76,831.43 pfet_05v0
XM_452 VDD_DEC n_I2640 n_I2624 VDD_DEC pfet_05v0 L=1U W=1.22U AS=0.5368P
+ AD=0.5368P PS=3.32U PD=3.32U
* device instance _453 m0 *1 620,831.43 pfet_05v0
XM_453 VDD_DEC n_I2641 n_I2625 VDD_DEC pfet_05v0 L=1U W=1.22U AS=0.5368P
+ AD=0.5368P PS=3.32U PD=3.32U
* device instance _454 m0 *1 606.56,831.43 pfet_05v0
XM_454 VDD_DEC n_I2635 n_I2619 VDD_DEC pfet_05v0 L=1U W=1.22U AS=0.5368P
+ AD=0.5368P PS=3.32U PD=3.32U
* device instance _455 m0 *1 611.04,831.43 pfet_05v0
XM_455 VDD_DEC n_I2637 n_I2621 VDD_DEC pfet_05v0 L=1U W=1.22U AS=0.5368P
+ AD=0.5368P PS=3.32U PD=3.32U
* device instance _456 m0 *1 633.44,831.43 pfet_05v0
XM_456 VDD_DEC n_I2647 n_I2631 VDD_DEC pfet_05v0 L=1U W=1.22U AS=0.5368P
+ AD=0.5368P PS=3.32U PD=3.32U
* device instance _457 m0 *1 608.8,831.43 pfet_05v0
XM_457 VDD_DEC n_I2636 n_I2620 VDD_DEC pfet_05v0 L=1U W=1.22U AS=0.5368P
+ AD=0.5368P PS=3.32U PD=3.32U
* device instance _458 m0 *1 622.24,831.43 pfet_05v0
XM_458 VDD_DEC n_I2642 n_I2626 VDD_DEC pfet_05v0 L=1U W=1.22U AS=0.5368P
+ AD=0.5368P PS=3.32U PD=3.32U
* device instance _459 m0 *1 624.48,831.43 pfet_05v0
XM_459 VDD_DEC n_I2643 n_I2627 VDD_DEC pfet_05v0 L=1U W=1.22U AS=0.5368P
+ AD=0.5368P PS=3.32U PD=3.32U
* device instance _460 m0 *1 626.72,831.43 pfet_05v0
XM_460 VDD_DEC n_I2644 n_I2628 VDD_DEC pfet_05v0 L=1U W=1.22U AS=0.5368P
+ AD=0.5368P PS=3.32U PD=3.32U
* device instance _461 m0 *1 631.2,831.43 pfet_05v0
XM_461 VDD_DEC n_I2646 n_I2630 VDD_DEC pfet_05v0 L=1U W=1.22U AS=0.5368P
+ AD=0.5368P PS=3.32U PD=3.32U
* device instance _462 m0 *1 637.92,831.43 pfet_05v0
XM_462 VDD_DEC n_I2649 n_I2633 VDD_DEC pfet_05v0 L=1U W=1.22U AS=0.5368P
+ AD=0.5368P PS=3.32U PD=3.32U
* device instance _463 m0 *1 640.16,831.43 pfet_05v0
XM_463 VDD_DEC n_I2650 n_I2634 VDD_DEC pfet_05v0 L=1U W=1.22U AS=0.5368P
+ AD=0.5368P PS=3.32U PD=3.32U
* device instance _464 m0 *1 628.96,831.43 pfet_05v0
XM_464 VDD_DEC n_I2645 n_I2629 VDD_DEC pfet_05v0 L=1U W=1.22U AS=0.5368P
+ AD=0.5368P PS=3.32U PD=3.32U
* device instance _465 m0 *1 640.16,833.65 nfet_05v0
XM_465 n_I2650 n_I2634 VSS VSS nfet_05v0 L=1U W=0.82U AS=0.3608P AD=0.3608P
+ PS=2.52U PD=2.52U
* device instance _466 m0 *1 608.8,833.65 nfet_05v0
XM_466 n_I2636 n_I2620 VSS VSS nfet_05v0 L=1U W=0.82U AS=0.3608P AD=0.3608P
+ PS=2.52U PD=2.52U
* device instance _467 m0 *1 617.76,833.65 nfet_05v0
XM_467 n_I2640 n_I2624 VSS VSS nfet_05v0 L=1U W=0.82U AS=0.3608P AD=0.3608P
+ PS=2.52U PD=2.52U
* device instance _468 m0 *1 615.52,833.65 nfet_05v0
XM_468 n_I2639 n_I2623 VSS VSS nfet_05v0 L=1U W=0.82U AS=0.3608P AD=0.3608P
+ PS=2.52U PD=2.52U
* device instance _469 m0 *1 628.96,833.65 nfet_05v0
XM_469 n_I2645 n_I2629 VSS VSS nfet_05v0 L=1U W=0.82U AS=0.3608P AD=0.3608P
+ PS=2.52U PD=2.52U
* device instance _470 m0 *1 613.28,833.65 nfet_05v0
XM_470 n_I2638 n_I2622 VSS VSS nfet_05v0 L=1U W=0.82U AS=0.3608P AD=0.3608P
+ PS=2.52U PD=2.52U
* device instance _471 m0 *1 611.04,833.65 nfet_05v0
XM_471 n_I2637 n_I2621 VSS VSS nfet_05v0 L=1U W=0.82U AS=0.3608P AD=0.3608P
+ PS=2.52U PD=2.52U
* device instance _472 m0 *1 637.92,833.65 nfet_05v0
XM_472 n_I2649 n_I2633 VSS VSS nfet_05v0 L=1U W=0.82U AS=0.3608P AD=0.3608P
+ PS=2.52U PD=2.52U
* device instance _473 m0 *1 633.44,833.65 nfet_05v0
XM_473 n_I2647 n_I2631 VSS VSS nfet_05v0 L=1U W=0.82U AS=0.3608P AD=0.3608P
+ PS=2.52U PD=2.52U
* device instance _474 m0 *1 606.56,833.65 nfet_05v0
XM_474 n_I2635 n_I2619 VSS VSS nfet_05v0 L=1U W=0.82U AS=0.3608P AD=0.3608P
+ PS=2.52U PD=2.52U
* device instance _475 m0 *1 622.24,833.65 nfet_05v0
XM_475 n_I2642 n_I2626 VSS VSS nfet_05v0 L=1U W=0.82U AS=0.3608P AD=0.3608P
+ PS=2.52U PD=2.52U
* device instance _476 m0 *1 620,833.65 nfet_05v0
XM_476 n_I2641 n_I2625 VSS VSS nfet_05v0 L=1U W=0.82U AS=0.3608P AD=0.3608P
+ PS=2.52U PD=2.52U
* device instance _477 m0 *1 624.48,833.65 nfet_05v0
XM_477 n_I2643 n_I2627 VSS VSS nfet_05v0 L=1U W=0.82U AS=0.3608P AD=0.3608P
+ PS=2.52U PD=2.52U
* device instance _478 m0 *1 631.2,833.65 nfet_05v0
XM_478 n_I2646 n_I2630 VSS VSS nfet_05v0 L=1U W=0.82U AS=0.3608P AD=0.3608P
+ PS=2.52U PD=2.52U
* device instance _479 m0 *1 626.72,833.65 nfet_05v0
XM_479 n_I2644 n_I2628 VSS VSS nfet_05v0 L=1U W=0.82U AS=0.3608P AD=0.3608P
+ PS=2.52U PD=2.52U
* device instance _480 m0 *1 635.68,833.65 nfet_05v0
XM_480 n_I2648 n_I2632 VSS VSS nfet_05v0 L=1U W=0.82U AS=0.3608P AD=0.3608P
+ PS=2.52U PD=2.52U
* device instance _481 m0 *1 576.32,831.43 pfet_05v0
XM_481 VDD_DEC n_I2671 n_I2655 VDD_DEC pfet_05v0 L=1U W=1.22U AS=0.5368P
+ AD=0.5368P PS=3.32U PD=3.32U
* device instance _482 m0 *1 596.48,831.43 pfet_05v0
XM_482 VDD_DEC n_I2680 n_I2664 VDD_DEC pfet_05v0 L=1U W=1.22U AS=0.5368P
+ AD=0.5368P PS=3.32U PD=3.32U
* device instance _483 m0 *1 574.08,831.43 pfet_05v0
XM_483 VDD_DEC n_I2670 n_I2654 VDD_DEC pfet_05v0 L=1U W=1.22U AS=0.5368P
+ AD=0.5368P PS=3.32U PD=3.32U
* device instance _484 m0 *1 578.56,831.43 pfet_05v0
XM_484 VDD_DEC n_I2672 n_I2656 VDD_DEC pfet_05v0 L=1U W=1.22U AS=0.5368P
+ AD=0.5368P PS=3.32U PD=3.32U
* device instance _485 m0 *1 580.8,831.43 pfet_05v0
XM_485 VDD_DEC n_I2673 n_I2657 VDD_DEC pfet_05v0 L=1U W=1.22U AS=0.5368P
+ AD=0.5368P PS=3.32U PD=3.32U
* device instance _486 m0 *1 567.36,831.43 pfet_05v0
XM_486 VDD_DEC n_I2667 n_I2651 VDD_DEC pfet_05v0 L=1U W=1.22U AS=0.5368P
+ AD=0.5368P PS=3.32U PD=3.32U
* device instance _487 m0 *1 571.84,831.43 pfet_05v0
XM_487 VDD_DEC n_I2669 n_I2653 VDD_DEC pfet_05v0 L=1U W=1.22U AS=0.5368P
+ AD=0.5368P PS=3.32U PD=3.32U
* device instance _488 m0 *1 594.24,831.43 pfet_05v0
XM_488 VDD_DEC n_I2679 n_I2663 VDD_DEC pfet_05v0 L=1U W=1.22U AS=0.5368P
+ AD=0.5368P PS=3.32U PD=3.32U
* device instance _489 m0 *1 569.6,831.43 pfet_05v0
XM_489 VDD_DEC n_I2668 n_I2652 VDD_DEC pfet_05v0 L=1U W=1.22U AS=0.5368P
+ AD=0.5368P PS=3.32U PD=3.32U
* device instance _490 m0 *1 583.04,831.43 pfet_05v0
XM_490 VDD_DEC n_I2674 n_I2658 VDD_DEC pfet_05v0 L=1U W=1.22U AS=0.5368P
+ AD=0.5368P PS=3.32U PD=3.32U
* device instance _491 m0 *1 585.28,831.43 pfet_05v0
XM_491 VDD_DEC n_I2675 n_I2659 VDD_DEC pfet_05v0 L=1U W=1.22U AS=0.5368P
+ AD=0.5368P PS=3.32U PD=3.32U
* device instance _492 m0 *1 587.52,831.43 pfet_05v0
XM_492 VDD_DEC n_I2676 n_I2660 VDD_DEC pfet_05v0 L=1U W=1.22U AS=0.5368P
+ AD=0.5368P PS=3.32U PD=3.32U
* device instance _493 m0 *1 592,831.43 pfet_05v0
XM_493 VDD_DEC n_I2678 n_I2662 VDD_DEC pfet_05v0 L=1U W=1.22U AS=0.5368P
+ AD=0.5368P PS=3.32U PD=3.32U
* device instance _494 m0 *1 598.72,831.43 pfet_05v0
XM_494 VDD_DEC n_I2681 n_I2665 VDD_DEC pfet_05v0 L=1U W=1.22U AS=0.5368P
+ AD=0.5368P PS=3.32U PD=3.32U
* device instance _495 m0 *1 600.96,831.43 pfet_05v0
XM_495 VDD_DEC n_I2682 n_I2666 VDD_DEC pfet_05v0 L=1U W=1.22U AS=0.5368P
+ AD=0.5368P PS=3.32U PD=3.32U
* device instance _496 m0 *1 589.76,831.43 pfet_05v0
XM_496 VDD_DEC n_I2677 n_I2661 VDD_DEC pfet_05v0 L=1U W=1.22U AS=0.5368P
+ AD=0.5368P PS=3.32U PD=3.32U
* device instance _497 m0 *1 600.96,833.65 nfet_05v0
XM_497 n_I2682 n_I2666 VSS VSS nfet_05v0 L=1U W=0.82U AS=0.3608P AD=0.3608P
+ PS=2.52U PD=2.52U
* device instance _498 m0 *1 569.6,833.65 nfet_05v0
XM_498 n_I2668 n_I2652 VSS VSS nfet_05v0 L=1U W=0.82U AS=0.3608P AD=0.3608P
+ PS=2.52U PD=2.52U
* device instance _499 m0 *1 578.56,833.65 nfet_05v0
XM_499 n_I2672 n_I2656 VSS VSS nfet_05v0 L=1U W=0.82U AS=0.3608P AD=0.3608P
+ PS=2.52U PD=2.52U
* device instance _500 m0 *1 576.32,833.65 nfet_05v0
XM_500 n_I2671 n_I2655 VSS VSS nfet_05v0 L=1U W=0.82U AS=0.3608P AD=0.3608P
+ PS=2.52U PD=2.52U
* device instance _501 m0 *1 589.76,833.65 nfet_05v0
XM_501 n_I2677 n_I2661 VSS VSS nfet_05v0 L=1U W=0.82U AS=0.3608P AD=0.3608P
+ PS=2.52U PD=2.52U
* device instance _502 m0 *1 574.08,833.65 nfet_05v0
XM_502 n_I2670 n_I2654 VSS VSS nfet_05v0 L=1U W=0.82U AS=0.3608P AD=0.3608P
+ PS=2.52U PD=2.52U
* device instance _503 m0 *1 571.84,833.65 nfet_05v0
XM_503 n_I2669 n_I2653 VSS VSS nfet_05v0 L=1U W=0.82U AS=0.3608P AD=0.3608P
+ PS=2.52U PD=2.52U
* device instance _504 m0 *1 598.72,833.65 nfet_05v0
XM_504 n_I2681 n_I2665 VSS VSS nfet_05v0 L=1U W=0.82U AS=0.3608P AD=0.3608P
+ PS=2.52U PD=2.52U
* device instance _505 m0 *1 594.24,833.65 nfet_05v0
XM_505 n_I2679 n_I2663 VSS VSS nfet_05v0 L=1U W=0.82U AS=0.3608P AD=0.3608P
+ PS=2.52U PD=2.52U
* device instance _506 m0 *1 567.36,833.65 nfet_05v0
XM_506 n_I2667 n_I2651 VSS VSS nfet_05v0 L=1U W=0.82U AS=0.3608P AD=0.3608P
+ PS=2.52U PD=2.52U
* device instance _507 m0 *1 583.04,833.65 nfet_05v0
XM_507 n_I2674 n_I2658 VSS VSS nfet_05v0 L=1U W=0.82U AS=0.3608P AD=0.3608P
+ PS=2.52U PD=2.52U
* device instance _508 m0 *1 580.8,833.65 nfet_05v0
XM_508 n_I2673 n_I2657 VSS VSS nfet_05v0 L=1U W=0.82U AS=0.3608P AD=0.3608P
+ PS=2.52U PD=2.52U
* device instance _509 m0 *1 585.28,833.65 nfet_05v0
XM_509 n_I2675 n_I2659 VSS VSS nfet_05v0 L=1U W=0.82U AS=0.3608P AD=0.3608P
+ PS=2.52U PD=2.52U
* device instance _510 m0 *1 592,833.65 nfet_05v0
XM_510 n_I2678 n_I2662 VSS VSS nfet_05v0 L=1U W=0.82U AS=0.3608P AD=0.3608P
+ PS=2.52U PD=2.52U
* device instance _511 m0 *1 587.52,833.65 nfet_05v0
XM_511 n_I2676 n_I2660 VSS VSS nfet_05v0 L=1U W=0.82U AS=0.3608P AD=0.3608P
+ PS=2.52U PD=2.52U
* device instance _512 m0 *1 596.48,833.65 nfet_05v0
XM_512 n_I2680 n_I2664 VSS VSS nfet_05v0 L=1U W=0.82U AS=0.3608P AD=0.3608P
+ PS=2.52U PD=2.52U
* device instance _513 m0 *1 603.2,823.59 pfet_05v0
XM_513 VDD_DEC n_I2698 n_I2690 VDD_DEC pfet_05v0 L=1U W=1.22U AS=0.5368P
+ AD=0.5368P PS=3.32U PD=3.32U
* device instance _514 m0 *1 596.48,823.59 pfet_05v0
XM_514 VDD_DEC n_I2695 n_I2687 VDD_DEC pfet_05v0 L=1U W=1.22U AS=0.5368P
+ AD=0.5368P PS=3.32U PD=3.32U
* device instance _515 m0 *1 589.76,823.59 pfet_05v0
XM_515 VDD_DEC n_I2692 n_I2684 VDD_DEC pfet_05v0 L=1U W=1.22U AS=0.5368P
+ AD=0.5368P PS=3.32U PD=3.32U
* device instance _516 m0 *1 598.72,823.59 pfet_05v0
XM_516 VDD_DEC n_I2696 n_I2688 VDD_DEC pfet_05v0 L=1U W=1.22U AS=0.5368P
+ AD=0.5368P PS=3.32U PD=3.32U
* device instance _517 m0 *1 592,823.59 pfet_05v0
XM_517 VDD_DEC n_I2693 n_I2685 VDD_DEC pfet_05v0 L=1U W=1.22U AS=0.5368P
+ AD=0.5368P PS=3.32U PD=3.32U
* device instance _518 m0 *1 600.96,823.59 pfet_05v0
XM_518 VDD_DEC n_I2697 n_I2689 VDD_DEC pfet_05v0 L=1U W=1.22U AS=0.5368P
+ AD=0.5368P PS=3.32U PD=3.32U
* device instance _519 m0 *1 587.52,823.59 pfet_05v0
XM_519 VDD_DEC n_I2691 n_I2683 VDD_DEC pfet_05v0 L=1U W=1.22U AS=0.5368P
+ AD=0.5368P PS=3.32U PD=3.32U
* device instance _520 m0 *1 594.24,823.59 pfet_05v0
XM_520 VDD_DEC n_I2694 n_I2686 VDD_DEC pfet_05v0 L=1U W=1.22U AS=0.5368P
+ AD=0.5368P PS=3.32U PD=3.32U
* device instance _521 m0 *1 603.2,825.81 nfet_05v0
XM_521 n_I2698 n_I2690 VSS VSS nfet_05v0 L=1U W=0.82U AS=0.3608P AD=0.3608P
+ PS=2.52U PD=2.52U
* device instance _522 m0 *1 600.96,825.81 nfet_05v0
XM_522 n_I2697 n_I2689 VSS VSS nfet_05v0 L=1U W=0.82U AS=0.3608P AD=0.3608P
+ PS=2.52U PD=2.52U
* device instance _523 m0 *1 587.52,825.81 nfet_05v0
XM_523 n_I2691 n_I2683 VSS VSS nfet_05v0 L=1U W=0.82U AS=0.3608P AD=0.3608P
+ PS=2.52U PD=2.52U
* device instance _524 m0 *1 592,825.81 nfet_05v0
XM_524 n_I2693 n_I2685 VSS VSS nfet_05v0 L=1U W=0.82U AS=0.3608P AD=0.3608P
+ PS=2.52U PD=2.52U
* device instance _525 m0 *1 594.24,825.81 nfet_05v0
XM_525 n_I2694 n_I2686 VSS VSS nfet_05v0 L=1U W=0.82U AS=0.3608P AD=0.3608P
+ PS=2.52U PD=2.52U
* device instance _526 m0 *1 596.48,825.81 nfet_05v0
XM_526 n_I2695 n_I2687 VSS VSS nfet_05v0 L=1U W=0.82U AS=0.3608P AD=0.3608P
+ PS=2.52U PD=2.52U
* device instance _527 m0 *1 598.72,825.81 nfet_05v0
XM_527 n_I2696 n_I2688 VSS VSS nfet_05v0 L=1U W=0.82U AS=0.3608P AD=0.3608P
+ PS=2.52U PD=2.52U
* device instance _528 m0 *1 589.76,825.81 nfet_05v0
XM_528 n_I2692 n_I2684 VSS VSS nfet_05v0 L=1U W=0.82U AS=0.3608P AD=0.3608P
+ PS=2.52U PD=2.52U
* device instance _529 m0 *1 504.64,831.43 pfet_05v0
XM_529 VDD_DEC n_I2714 n_I2706 VDD_DEC pfet_05v0 L=1U W=1.22U AS=0.5368P
+ AD=0.5368P PS=3.32U PD=3.32U
* device instance _530 m0 *1 497.92,831.43 pfet_05v0
XM_530 VDD_DEC n_I2711 n_I2703 VDD_DEC pfet_05v0 L=1U W=1.22U AS=0.5368P
+ AD=0.5368P PS=3.32U PD=3.32U
* device instance _531 m0 *1 491.2,831.43 pfet_05v0
XM_531 VDD_DEC n_I2708 n_I2700 VDD_DEC pfet_05v0 L=1U W=1.22U AS=0.5368P
+ AD=0.5368P PS=3.32U PD=3.32U
* device instance _532 m0 *1 500.16,831.43 pfet_05v0
XM_532 VDD_DEC n_I2712 n_I2704 VDD_DEC pfet_05v0 L=1U W=1.22U AS=0.5368P
+ AD=0.5368P PS=3.32U PD=3.32U
* device instance _533 m0 *1 493.44,831.43 pfet_05v0
XM_533 VDD_DEC n_I2709 n_I2701 VDD_DEC pfet_05v0 L=1U W=1.22U AS=0.5368P
+ AD=0.5368P PS=3.32U PD=3.32U
* device instance _534 m0 *1 502.4,831.43 pfet_05v0
XM_534 VDD_DEC n_I2713 n_I2705 VDD_DEC pfet_05v0 L=1U W=1.22U AS=0.5368P
+ AD=0.5368P PS=3.32U PD=3.32U
* device instance _535 m0 *1 488.96,831.43 pfet_05v0
XM_535 VDD_DEC n_I2707 n_I2699 VDD_DEC pfet_05v0 L=1U W=1.22U AS=0.5368P
+ AD=0.5368P PS=3.32U PD=3.32U
* device instance _536 m0 *1 495.68,831.43 pfet_05v0
XM_536 VDD_DEC n_I2710 n_I2702 VDD_DEC pfet_05v0 L=1U W=1.22U AS=0.5368P
+ AD=0.5368P PS=3.32U PD=3.32U
* device instance _537 m0 *1 504.64,833.65 nfet_05v0
XM_537 n_I2714 n_I2706 VSS VSS nfet_05v0 L=1U W=0.82U AS=0.3608P AD=0.3608P
+ PS=2.52U PD=2.52U
* device instance _538 m0 *1 502.4,833.65 nfet_05v0
XM_538 n_I2713 n_I2705 VSS VSS nfet_05v0 L=1U W=0.82U AS=0.3608P AD=0.3608P
+ PS=2.52U PD=2.52U
* device instance _539 m0 *1 488.96,833.65 nfet_05v0
XM_539 n_I2707 n_I2699 VSS VSS nfet_05v0 L=1U W=0.82U AS=0.3608P AD=0.3608P
+ PS=2.52U PD=2.52U
* device instance _540 m0 *1 493.44,833.65 nfet_05v0
XM_540 n_I2709 n_I2701 VSS VSS nfet_05v0 L=1U W=0.82U AS=0.3608P AD=0.3608P
+ PS=2.52U PD=2.52U
* device instance _541 m0 *1 495.68,833.65 nfet_05v0
XM_541 n_I2710 n_I2702 VSS VSS nfet_05v0 L=1U W=0.82U AS=0.3608P AD=0.3608P
+ PS=2.52U PD=2.52U
* device instance _542 m0 *1 497.92,833.65 nfet_05v0
XM_542 n_I2711 n_I2703 VSS VSS nfet_05v0 L=1U W=0.82U AS=0.3608P AD=0.3608P
+ PS=2.52U PD=2.52U
* device instance _543 m0 *1 500.16,833.65 nfet_05v0
XM_543 n_I2712 n_I2704 VSS VSS nfet_05v0 L=1U W=0.82U AS=0.3608P AD=0.3608P
+ PS=2.52U PD=2.52U
* device instance _544 m0 *1 491.2,833.65 nfet_05v0
XM_544 n_I2708 n_I2700 VSS VSS nfet_05v0 L=1U W=0.82U AS=0.3608P AD=0.3608P
+ PS=2.52U PD=2.52U
* device instance _545 r0 *1 580.8,837.37 pfet_05v0
XM_545 VDD_DEC n_I2730 n_I2722 VDD_DEC pfet_05v0 L=1U W=1.22U AS=0.5368P
+ AD=0.5368P PS=3.32U PD=3.32U
* device instance _546 r0 *1 574.08,837.37 pfet_05v0
XM_546 VDD_DEC n_I2727 n_I2719 VDD_DEC pfet_05v0 L=1U W=1.22U AS=0.5368P
+ AD=0.5368P PS=3.32U PD=3.32U
* device instance _547 r0 *1 567.36,837.37 pfet_05v0
XM_547 VDD_DEC n_I2724 n_I2716 VDD_DEC pfet_05v0 L=1U W=1.22U AS=0.5368P
+ AD=0.5368P PS=3.32U PD=3.32U
* device instance _548 r0 *1 576.32,837.37 pfet_05v0
XM_548 VDD_DEC n_I2728 n_I2720 VDD_DEC pfet_05v0 L=1U W=1.22U AS=0.5368P
+ AD=0.5368P PS=3.32U PD=3.32U
* device instance _549 r0 *1 569.6,837.37 pfet_05v0
XM_549 VDD_DEC n_I2725 n_I2717 VDD_DEC pfet_05v0 L=1U W=1.22U AS=0.5368P
+ AD=0.5368P PS=3.32U PD=3.32U
* device instance _550 r0 *1 578.56,837.37 pfet_05v0
XM_550 VDD_DEC n_I2729 n_I2721 VDD_DEC pfet_05v0 L=1U W=1.22U AS=0.5368P
+ AD=0.5368P PS=3.32U PD=3.32U
* device instance _551 r0 *1 565.12,837.37 pfet_05v0
XM_551 VDD_DEC n_I2723 n_I2715 VDD_DEC pfet_05v0 L=1U W=1.22U AS=0.5368P
+ AD=0.5368P PS=3.32U PD=3.32U
* device instance _552 r0 *1 571.84,837.37 pfet_05v0
XM_552 VDD_DEC n_I2726 n_I2718 VDD_DEC pfet_05v0 L=1U W=1.22U AS=0.5368P
+ AD=0.5368P PS=3.32U PD=3.32U
* device instance _553 r0 *1 580.8,835.15 nfet_05v0
XM_553 n_I2730 n_I2722 VSS VSS nfet_05v0 L=1U W=0.82U AS=0.3608P AD=0.3608P
+ PS=2.52U PD=2.52U
* device instance _554 r0 *1 578.56,835.15 nfet_05v0
XM_554 n_I2729 n_I2721 VSS VSS nfet_05v0 L=1U W=0.82U AS=0.3608P AD=0.3608P
+ PS=2.52U PD=2.52U
* device instance _555 r0 *1 565.12,835.15 nfet_05v0
XM_555 n_I2723 n_I2715 VSS VSS nfet_05v0 L=1U W=0.82U AS=0.3608P AD=0.3608P
+ PS=2.52U PD=2.52U
* device instance _556 r0 *1 569.6,835.15 nfet_05v0
XM_556 n_I2725 n_I2717 VSS VSS nfet_05v0 L=1U W=0.82U AS=0.3608P AD=0.3608P
+ PS=2.52U PD=2.52U
* device instance _557 r0 *1 571.84,835.15 nfet_05v0
XM_557 n_I2726 n_I2718 VSS VSS nfet_05v0 L=1U W=0.82U AS=0.3608P AD=0.3608P
+ PS=2.52U PD=2.52U
* device instance _558 r0 *1 574.08,835.15 nfet_05v0
XM_558 n_I2727 n_I2719 VSS VSS nfet_05v0 L=1U W=0.82U AS=0.3608P AD=0.3608P
+ PS=2.52U PD=2.52U
* device instance _559 r0 *1 576.32,835.15 nfet_05v0
XM_559 n_I2728 n_I2720 VSS VSS nfet_05v0 L=1U W=0.82U AS=0.3608P AD=0.3608P
+ PS=2.52U PD=2.52U
* device instance _560 r0 *1 567.36,835.15 nfet_05v0
XM_560 n_I2724 n_I2716 VSS VSS nfet_05v0 L=1U W=0.82U AS=0.3608P AD=0.3608P
+ PS=2.52U PD=2.52U
* device instance _561 r0 *1 637.92,837.37 pfet_05v0
XM_561 VDD_DEC n_I2746 n_I2738 VDD_DEC pfet_05v0 L=1U W=1.22U AS=0.5368P
+ AD=0.5368P PS=3.32U PD=3.32U
* device instance _562 r0 *1 631.2,837.37 pfet_05v0
XM_562 VDD_DEC n_I2743 n_I2735 VDD_DEC pfet_05v0 L=1U W=1.22U AS=0.5368P
+ AD=0.5368P PS=3.32U PD=3.32U
* device instance _563 r0 *1 624.48,837.37 pfet_05v0
XM_563 VDD_DEC n_I2740 n_I2732 VDD_DEC pfet_05v0 L=1U W=1.22U AS=0.5368P
+ AD=0.5368P PS=3.32U PD=3.32U
* device instance _564 r0 *1 633.44,837.37 pfet_05v0
XM_564 VDD_DEC n_I2744 n_I2736 VDD_DEC pfet_05v0 L=1U W=1.22U AS=0.5368P
+ AD=0.5368P PS=3.32U PD=3.32U
* device instance _565 r0 *1 626.72,837.37 pfet_05v0
XM_565 VDD_DEC n_I2741 n_I2733 VDD_DEC pfet_05v0 L=1U W=1.22U AS=0.5368P
+ AD=0.5368P PS=3.32U PD=3.32U
* device instance _566 r0 *1 635.68,837.37 pfet_05v0
XM_566 VDD_DEC n_I2745 n_I2737 VDD_DEC pfet_05v0 L=1U W=1.22U AS=0.5368P
+ AD=0.5368P PS=3.32U PD=3.32U
* device instance _567 r0 *1 622.24,837.37 pfet_05v0
XM_567 VDD_DEC n_I2739 n_I2731 VDD_DEC pfet_05v0 L=1U W=1.22U AS=0.5368P
+ AD=0.5368P PS=3.32U PD=3.32U
* device instance _568 r0 *1 628.96,837.37 pfet_05v0
XM_568 VDD_DEC n_I2742 n_I2734 VDD_DEC pfet_05v0 L=1U W=1.22U AS=0.5368P
+ AD=0.5368P PS=3.32U PD=3.32U
* device instance _569 r0 *1 637.92,835.15 nfet_05v0
XM_569 n_I2746 n_I2738 VSS VSS nfet_05v0 L=1U W=0.82U AS=0.3608P AD=0.3608P
+ PS=2.52U PD=2.52U
* device instance _570 r0 *1 635.68,835.15 nfet_05v0
XM_570 n_I2745 n_I2737 VSS VSS nfet_05v0 L=1U W=0.82U AS=0.3608P AD=0.3608P
+ PS=2.52U PD=2.52U
* device instance _571 r0 *1 622.24,835.15 nfet_05v0
XM_571 n_I2739 n_I2731 VSS VSS nfet_05v0 L=1U W=0.82U AS=0.3608P AD=0.3608P
+ PS=2.52U PD=2.52U
* device instance _572 r0 *1 626.72,835.15 nfet_05v0
XM_572 n_I2741 n_I2733 VSS VSS nfet_05v0 L=1U W=0.82U AS=0.3608P AD=0.3608P
+ PS=2.52U PD=2.52U
* device instance _573 r0 *1 628.96,835.15 nfet_05v0
XM_573 n_I2742 n_I2734 VSS VSS nfet_05v0 L=1U W=0.82U AS=0.3608P AD=0.3608P
+ PS=2.52U PD=2.52U
* device instance _574 r0 *1 631.2,835.15 nfet_05v0
XM_574 n_I2743 n_I2735 VSS VSS nfet_05v0 L=1U W=0.82U AS=0.3608P AD=0.3608P
+ PS=2.52U PD=2.52U
* device instance _575 r0 *1 633.44,835.15 nfet_05v0
XM_575 n_I2744 n_I2736 VSS VSS nfet_05v0 L=1U W=0.82U AS=0.3608P AD=0.3608P
+ PS=2.52U PD=2.52U
* device instance _576 r0 *1 624.48,835.15 nfet_05v0
XM_576 n_I2740 n_I2732 VSS VSS nfet_05v0 L=1U W=0.82U AS=0.3608P AD=0.3608P
+ PS=2.52U PD=2.52U
* device instance _577 r0 *1 602.64,829.53 pfet_05v0
XM_577 VDD_DEC n_I2762 n_I2754 VDD_DEC pfet_05v0 L=1U W=1.22U AS=0.5368P
+ AD=0.5368P PS=3.32U PD=3.32U
* device instance _578 r0 *1 595.92,829.53 pfet_05v0
XM_578 VDD_DEC n_I2759 n_I2751 VDD_DEC pfet_05v0 L=1U W=1.22U AS=0.5368P
+ AD=0.5368P PS=3.32U PD=3.32U
* device instance _579 r0 *1 589.2,829.53 pfet_05v0
XM_579 VDD_DEC n_I2756 n_I2748 VDD_DEC pfet_05v0 L=1U W=1.22U AS=0.5368P
+ AD=0.5368P PS=3.32U PD=3.32U
* device instance _580 r0 *1 598.16,829.53 pfet_05v0
XM_580 VDD_DEC n_I2760 n_I2752 VDD_DEC pfet_05v0 L=1U W=1.22U AS=0.5368P
+ AD=0.5368P PS=3.32U PD=3.32U
* device instance _581 r0 *1 591.44,829.53 pfet_05v0
XM_581 VDD_DEC n_I2757 n_I2749 VDD_DEC pfet_05v0 L=1U W=1.22U AS=0.5368P
+ AD=0.5368P PS=3.32U PD=3.32U
* device instance _582 r0 *1 600.4,829.53 pfet_05v0
XM_582 VDD_DEC n_I2761 n_I2753 VDD_DEC pfet_05v0 L=1U W=1.22U AS=0.5368P
+ AD=0.5368P PS=3.32U PD=3.32U
* device instance _583 r0 *1 586.96,829.53 pfet_05v0
XM_583 VDD_DEC n_I2755 n_I2747 VDD_DEC pfet_05v0 L=1U W=1.22U AS=0.5368P
+ AD=0.5368P PS=3.32U PD=3.32U
* device instance _584 r0 *1 593.68,829.53 pfet_05v0
XM_584 VDD_DEC n_I2758 n_I2750 VDD_DEC pfet_05v0 L=1U W=1.22U AS=0.5368P
+ AD=0.5368P PS=3.32U PD=3.32U
* device instance _585 r0 *1 602.64,827.31 nfet_05v0
XM_585 n_I2762 n_I2754 VSS VSS nfet_05v0 L=1U W=0.82U AS=0.3608P AD=0.3608P
+ PS=2.52U PD=2.52U
* device instance _586 r0 *1 600.4,827.31 nfet_05v0
XM_586 n_I2761 n_I2753 VSS VSS nfet_05v0 L=1U W=0.82U AS=0.3608P AD=0.3608P
+ PS=2.52U PD=2.52U
* device instance _587 r0 *1 586.96,827.31 nfet_05v0
XM_587 n_I2755 n_I2747 VSS VSS nfet_05v0 L=1U W=0.82U AS=0.3608P AD=0.3608P
+ PS=2.52U PD=2.52U
* device instance _588 r0 *1 591.44,827.31 nfet_05v0
XM_588 n_I2757 n_I2749 VSS VSS nfet_05v0 L=1U W=0.82U AS=0.3608P AD=0.3608P
+ PS=2.52U PD=2.52U
* device instance _589 r0 *1 593.68,827.31 nfet_05v0
XM_589 n_I2758 n_I2750 VSS VSS nfet_05v0 L=1U W=0.82U AS=0.3608P AD=0.3608P
+ PS=2.52U PD=2.52U
* device instance _590 r0 *1 595.92,827.31 nfet_05v0
XM_590 n_I2759 n_I2751 VSS VSS nfet_05v0 L=1U W=0.82U AS=0.3608P AD=0.3608P
+ PS=2.52U PD=2.52U
* device instance _591 r0 *1 598.16,827.31 nfet_05v0
XM_591 n_I2760 n_I2752 VSS VSS nfet_05v0 L=1U W=0.82U AS=0.3608P AD=0.3608P
+ PS=2.52U PD=2.52U
* device instance _592 r0 *1 589.2,827.31 nfet_05v0
XM_592 n_I2756 n_I2748 VSS VSS nfet_05v0 L=1U W=0.82U AS=0.3608P AD=0.3608P
+ PS=2.52U PD=2.52U
* device instance _593 m0 *1 669.84,831.43 pfet_05v0
XM_593 VDD_DEC n_I2766 n_I2765 VDD_DEC pfet_05v0 L=1U W=1.22U AS=0.5368P
+ AD=0.5368P PS=3.32U PD=3.32U
* device instance _594 m0 *1 667.6,831.43 pfet_05v0
XM_594 VDD_DEC n_I2764 n_I2763 VDD_DEC pfet_05v0 L=1U W=1.22U AS=0.5368P
+ AD=0.5368P PS=3.32U PD=3.32U
* device instance _595 m0 *1 669.84,833.65 nfet_05v0
XM_595 n_I2766 n_I2765 VSS VSS nfet_05v0 L=1U W=0.82U AS=0.3608P AD=0.3608P
+ PS=2.52U PD=2.52U
* device instance _596 m0 *1 667.6,833.65 nfet_05v0
XM_596 n_I2764 n_I2763 VSS VSS nfet_05v0 L=1U W=0.82U AS=0.3608P AD=0.3608P
+ PS=2.52U PD=2.52U
* device instance _597 m0 *1 500.16,823.59 pfet_05v0
XM_597 VDD_DEC n_I2770 n_I2769 VDD_DEC pfet_05v0 L=1U W=1.22U AS=0.5368P
+ AD=0.5368P PS=3.32U PD=3.32U
* device instance _598 m0 *1 497.92,823.59 pfet_05v0
XM_598 VDD_DEC n_I2768 n_I2767 VDD_DEC pfet_05v0 L=1U W=1.22U AS=0.5368P
+ AD=0.5368P PS=3.32U PD=3.32U
* device instance _599 m0 *1 500.16,825.81 nfet_05v0
XM_599 n_I2770 n_I2769 VSS VSS nfet_05v0 L=1U W=0.82U AS=0.3608P AD=0.3608P
+ PS=2.52U PD=2.52U
* device instance _600 m0 *1 497.92,825.81 nfet_05v0
XM_600 n_I2768 n_I2767 VSS VSS nfet_05v0 L=1U W=0.82U AS=0.3608P AD=0.3608P
+ PS=2.52U PD=2.52U
* device instance _601 r0 *1 491.2,821.69 pfet_05v0
XM_601 VDD_DEC n_I2774 n_I2773 VDD_DEC pfet_05v0 L=1U W=1.22U AS=0.5368P
+ AD=0.5368P PS=3.32U PD=3.32U
* device instance _602 r0 *1 488.96,821.69 pfet_05v0
XM_602 VDD_DEC n_I2772 n_I2771 VDD_DEC pfet_05v0 L=1U W=1.22U AS=0.5368P
+ AD=0.5368P PS=3.32U PD=3.32U
* device instance _603 r0 *1 491.2,819.47 nfet_05v0
XM_603 n_I2774 n_I2773 VSS VSS nfet_05v0 L=1U W=0.82U AS=0.3608P AD=0.3608P
+ PS=2.52U PD=2.52U
* device instance _604 r0 *1 488.96,819.47 nfet_05v0
XM_604 n_I2772 n_I2771 VSS VSS nfet_05v0 L=1U W=0.82U AS=0.3608P AD=0.3608P
+ PS=2.52U PD=2.52U
* device instance _605 r0 *1 667.6,829.53 pfet_05v0
XM_605 VDD_DEC n_I2778 n_I2777 VDD_DEC pfet_05v0 L=1U W=1.22U AS=0.5368P
+ AD=0.5368P PS=3.32U PD=3.32U
* device instance _606 r0 *1 665.36,829.53 pfet_05v0
XM_606 VDD_DEC n_I2776 n_I2775 VDD_DEC pfet_05v0 L=1U W=1.22U AS=0.5368P
+ AD=0.5368P PS=3.32U PD=3.32U
* device instance _607 r0 *1 667.6,827.31 nfet_05v0
XM_607 n_I2778 n_I2777 VSS VSS nfet_05v0 L=1U W=0.82U AS=0.3608P AD=0.3608P
+ PS=2.52U PD=2.52U
* device instance _608 r0 *1 665.36,827.31 nfet_05v0
XM_608 n_I2776 n_I2775 VSS VSS nfet_05v0 L=1U W=0.82U AS=0.3608P AD=0.3608P
+ PS=2.52U PD=2.52U
* device instance _609 r0 *1 583.6,829.53 pfet_05v0
XM_609 VDD_DEC n_I2782 n_I2781 VDD_DEC pfet_05v0 L=1U W=1.22U AS=0.5368P
+ AD=0.5368P PS=3.32U PD=3.32U
* device instance _610 r0 *1 581.36,829.53 pfet_05v0
XM_610 VDD_DEC n_I2780 n_I2779 VDD_DEC pfet_05v0 L=1U W=1.22U AS=0.5368P
+ AD=0.5368P PS=3.32U PD=3.32U
* device instance _611 r0 *1 583.6,827.31 nfet_05v0
XM_611 n_I2782 n_I2781 VSS VSS nfet_05v0 L=1U W=0.82U AS=0.3608P AD=0.3608P
+ PS=2.52U PD=2.52U
* device instance _612 r0 *1 581.36,827.31 nfet_05v0
XM_612 n_I2780 n_I2779 VSS VSS nfet_05v0 L=1U W=0.82U AS=0.3608P AD=0.3608P
+ PS=2.52U PD=2.52U
* device instance _613 r0 *1 667.6,821.69 pfet_05v0
XM_613 VDD_DEC n_I2786 n_I2785 VDD_DEC pfet_05v0 L=1U W=1.22U AS=0.5368P
+ AD=0.5368P PS=3.32U PD=3.32U
* device instance _614 r0 *1 665.36,821.69 pfet_05v0
XM_614 VDD_DEC n_I2784 n_I2783 VDD_DEC pfet_05v0 L=1U W=1.22U AS=0.5368P
+ AD=0.5368P PS=3.32U PD=3.32U
* device instance _615 r0 *1 667.6,819.47 nfet_05v0
XM_615 n_I2786 n_I2785 VSS VSS nfet_05v0 L=1U W=0.82U AS=0.3608P AD=0.3608P
+ PS=2.52U PD=2.52U
* device instance _616 r0 *1 665.36,819.47 nfet_05v0
XM_616 n_I2784 n_I2783 VSS VSS nfet_05v0 L=1U W=0.82U AS=0.3608P AD=0.3608P
+ PS=2.52U PD=2.52U
* device instance _617 r0 *1 491.2,837.37 pfet_05v0
XM_617 VDD_DEC n_I2790 n_I2789 VDD_DEC pfet_05v0 L=1U W=1.22U AS=0.5368P
+ AD=0.5368P PS=3.32U PD=3.32U
* device instance _618 r0 *1 488.96,837.37 pfet_05v0
XM_618 VDD_DEC n_I2788 n_I2787 VDD_DEC pfet_05v0 L=1U W=1.22U AS=0.5368P
+ AD=0.5368P PS=3.32U PD=3.32U
* device instance _619 r0 *1 491.2,835.15 nfet_05v0
XM_619 n_I2790 n_I2789 VSS VSS nfet_05v0 L=1U W=0.82U AS=0.3608P AD=0.3608P
+ PS=2.52U PD=2.52U
* device instance _620 r0 *1 488.96,835.15 nfet_05v0
XM_620 n_I2788 n_I2787 VSS VSS nfet_05v0 L=1U W=0.82U AS=0.3608P AD=0.3608P
+ PS=2.52U PD=2.52U
* device instance _621 r0 *1 605.44,837.37 pfet_05v0
XM_621 VDD_DEC n_I2794 n_I2793 VDD_DEC pfet_05v0 L=1U W=1.22U AS=0.5368P
+ AD=0.5368P PS=3.32U PD=3.32U
* device instance _622 r0 *1 603.2,837.37 pfet_05v0
XM_622 VDD_DEC n_I2792 n_I2791 VDD_DEC pfet_05v0 L=1U W=1.22U AS=0.5368P
+ AD=0.5368P PS=3.32U PD=3.32U
* device instance _623 r0 *1 605.44,835.15 nfet_05v0
XM_623 n_I2794 n_I2793 VSS VSS nfet_05v0 L=1U W=0.82U AS=0.3608P AD=0.3608P
+ PS=2.52U PD=2.52U
* device instance _624 r0 *1 603.2,835.15 nfet_05v0
XM_624 n_I2792 n_I2791 VSS VSS nfet_05v0 L=1U W=0.82U AS=0.3608P AD=0.3608P
+ PS=2.52U PD=2.52U
* device instance _625 r0 *1 500.16,829.53 pfet_05v0
XM_625 VDD_DEC n_I2798 n_I2797 VDD_DEC pfet_05v0 L=1U W=1.22U AS=0.5368P
+ AD=0.5368P PS=3.32U PD=3.32U
* device instance _626 r0 *1 497.92,829.53 pfet_05v0
XM_626 VDD_DEC n_I2796 n_I2795 VDD_DEC pfet_05v0 L=1U W=1.22U AS=0.5368P
+ AD=0.5368P PS=3.32U PD=3.32U
* device instance _627 r0 *1 500.16,827.31 nfet_05v0
XM_627 n_I2798 n_I2797 VSS VSS nfet_05v0 L=1U W=0.82U AS=0.3608P AD=0.3608P
+ PS=2.52U PD=2.52U
* device instance _628 r0 *1 497.92,827.31 nfet_05v0
XM_628 n_I2796 n_I2795 VSS VSS nfet_05v0 L=1U W=0.82U AS=0.3608P AD=0.3608P
+ PS=2.52U PD=2.52U
* device instance _629 m0 *1 491.2,815.75 pfet_05v0
XM_629 VDD_DEC n_I2802 n_I2801 VDD_DEC pfet_05v0 L=1U W=1.22U AS=0.5368P
+ AD=0.5368P PS=3.32U PD=3.32U
* device instance _630 m0 *1 488.96,815.75 pfet_05v0
XM_630 VDD_DEC n_I2800 n_I2799 VDD_DEC pfet_05v0 L=1U W=1.22U AS=0.5368P
+ AD=0.5368P PS=3.32U PD=3.32U
* device instance _631 m0 *1 491.2,817.97 nfet_05v0
XM_631 n_I2802 n_I2801 VSS VSS nfet_05v0 L=1U W=0.82U AS=0.3608P AD=0.3608P
+ PS=2.52U PD=2.52U
* device instance _632 m0 *1 488.96,817.97 nfet_05v0
XM_632 n_I2800 n_I2799 VSS VSS nfet_05v0 L=1U W=0.82U AS=0.3608P AD=0.3608P
+ PS=2.52U PD=2.52U
* device instance _633 m0 *1 607.005,823.628 pfet_05v0
XM_633 n_I2324 n_I2366 VDD_DEC VDD_DEC pfet_05v0 L=0.5U W=0.985U AS=0.4334P
+ AD=0.2561P PS=2.85U PD=1.505U
* device instance _634 m0 *1 608.025,823.628 pfet_05v0
XM_634 VDD_DEC n_I2285 n_I2324 VDD_DEC pfet_05v0 L=0.5U W=0.985U AS=0.2561P
+ AD=0.2561P PS=1.505U PD=1.505U
* device instance _635 m0 *1 609.045,823.628 pfet_05v0
XM_635 n_I2324 n_I2287 VDD_DEC VDD_DEC pfet_05v0 L=0.5U W=0.985U AS=0.2561P
+ AD=0.4334P PS=1.505U PD=2.85U
* device instance _636 m0 *1 607.055,825.81 nfet_05v0
XM_636 n_I2804 n_I2366 VSS VSS nfet_05v0 L=0.6U W=0.82U AS=0.3608P AD=0.1312P
+ PS=2.52U PD=1.14U
* device instance _637 m0 *1 607.975,825.81 nfet_05v0
XM_637 n_I2803 n_I2285 n_I2804 VSS nfet_05v0 L=0.6U W=0.82U AS=0.1312P
+ AD=0.1722P PS=1.14U PD=1.24U
* device instance _638 m0 *1 608.995,825.81 nfet_05v0
XM_638 n_I2324 n_I2287 n_I2803 VSS nfet_05v0 L=0.6U W=0.82U AS=0.1722P
+ AD=0.3608P PS=1.24U PD=2.52U
* device instance _639 m0 *1 562.205,823.628 pfet_05v0
XM_639 n_I2339 n_I2335 VDD_DEC VDD_DEC pfet_05v0 L=0.5U W=0.985U AS=0.4334P
+ AD=0.2561P PS=2.85U PD=1.505U
* device instance _640 m0 *1 563.225,823.628 pfet_05v0
XM_640 VDD_DEC n_I2337 n_I2339 VDD_DEC pfet_05v0 L=0.5U W=0.985U AS=0.2561P
+ AD=0.2561P PS=1.505U PD=1.505U
* device instance _641 m0 *1 564.245,823.628 pfet_05v0
XM_641 n_I2339 n_I2383 VDD_DEC VDD_DEC pfet_05v0 L=0.5U W=0.985U AS=0.2561P
+ AD=0.4334P PS=1.505U PD=2.85U
* device instance _642 m0 *1 562.255,825.81 nfet_05v0
XM_642 n_I2806 n_I2335 VSS VSS nfet_05v0 L=0.6U W=0.82U AS=0.3608P AD=0.1312P
+ PS=2.52U PD=1.14U
* device instance _643 m0 *1 563.175,825.81 nfet_05v0
XM_643 n_I2805 n_I2337 n_I2806 VSS nfet_05v0 L=0.6U W=0.82U AS=0.1312P
+ AD=0.1722P PS=1.14U PD=1.24U
* device instance _644 m0 *1 564.195,825.81 nfet_05v0
XM_644 n_I2339 n_I2383 n_I2805 VSS nfet_05v0 L=0.6U W=0.82U AS=0.1722P
+ AD=0.3608P PS=1.24U PD=2.52U
* device instance _645 r180 *1 562.995,831.468 pfet_05v0
XM_645 n_I2382 n_I2354 VDD_DEC VDD_DEC pfet_05v0 L=0.5U W=0.985U AS=0.4334P
+ AD=0.2561P PS=2.85U PD=1.505U
* device instance _646 r180 *1 561.975,831.468 pfet_05v0
XM_646 VDD_DEC n_I2322 n_I2382 VDD_DEC pfet_05v0 L=0.5U W=0.985U AS=0.2561P
+ AD=0.2561P PS=1.505U PD=1.505U
* device instance _647 r180 *1 560.955,831.468 pfet_05v0
XM_647 n_I2382 n_I2353 VDD_DEC VDD_DEC pfet_05v0 L=0.5U W=0.985U AS=0.2561P
+ AD=0.4334P PS=1.505U PD=2.85U
* device instance _648 r180 *1 562.945,833.65 nfet_05v0
XM_648 n_I2808 n_I2354 VSS VSS nfet_05v0 L=0.6U W=0.82U AS=0.3608P AD=0.1312P
+ PS=2.52U PD=1.14U
* device instance _649 r180 *1 562.025,833.65 nfet_05v0
XM_649 n_I2807 n_I2322 n_I2808 VSS nfet_05v0 L=0.6U W=0.82U AS=0.1312P
+ AD=0.1722P PS=1.14U PD=1.24U
* device instance _650 r180 *1 561.005,833.65 nfet_05v0
XM_650 n_I2382 n_I2353 n_I2807 VSS nfet_05v0 L=0.6U W=0.82U AS=0.1722P
+ AD=0.3608P PS=1.24U PD=2.52U
* device instance _651 r0 *1 577.325,829.492 pfet_05v0
XM_651 n_I2340 n_I2407 VDD_DEC VDD_DEC pfet_05v0 L=0.5U W=0.985U AS=0.4334P
+ AD=0.2561P PS=2.85U PD=1.505U
* device instance _652 r0 *1 578.345,829.492 pfet_05v0
XM_652 VDD_DEC n_I2210 n_I2340 VDD_DEC pfet_05v0 L=0.5U W=0.985U AS=0.2561P
+ AD=0.2561P PS=1.505U PD=1.505U
* device instance _653 r0 *1 579.365,829.492 pfet_05v0
XM_653 n_I2340 n_I2384 VDD_DEC VDD_DEC pfet_05v0 L=0.5U W=0.985U AS=0.2561P
+ AD=0.4334P PS=1.505U PD=2.85U
* device instance _654 r0 *1 577.375,827.31 nfet_05v0
XM_654 n_I2810 n_I2407 VSS VSS nfet_05v0 L=0.6U W=0.82U AS=0.3608P AD=0.1312P
+ PS=2.52U PD=1.14U
* device instance _655 r0 *1 578.295,827.31 nfet_05v0
XM_655 n_I2809 n_I2210 n_I2810 VSS nfet_05v0 L=0.6U W=0.82U AS=0.1312P
+ AD=0.1722P PS=1.14U PD=1.24U
* device instance _656 r0 *1 579.315,827.31 nfet_05v0
XM_656 n_I2340 n_I2384 n_I2809 VSS nfet_05v0 L=0.6U W=0.82U AS=0.1722P
+ AD=0.3608P PS=1.24U PD=2.52U
* device instance _657 r0 *1 515.725,813.812 pfet_05v0
XM_657 n_I2357 n_I2364 VDD_DEC VDD_DEC pfet_05v0 L=0.5U W=0.985U AS=0.4334P
+ AD=0.2561P PS=2.85U PD=1.505U
* device instance _658 r0 *1 516.745,813.812 pfet_05v0
XM_658 VDD_DEC n_I2379 n_I2357 VDD_DEC pfet_05v0 L=0.5U W=0.985U AS=0.2561P
+ AD=0.2561P PS=1.505U PD=1.505U
* device instance _659 r0 *1 517.765,813.812 pfet_05v0
XM_659 n_I2357 n_I2354 VDD_DEC VDD_DEC pfet_05v0 L=0.5U W=0.985U AS=0.2561P
+ AD=0.4334P PS=1.505U PD=2.85U
* device instance _660 r0 *1 515.775,811.63 nfet_05v0
XM_660 n_I2812 n_I2364 VSS VSS nfet_05v0 L=0.6U W=0.82U AS=0.3608P AD=0.1312P
+ PS=2.52U PD=1.14U
* device instance _661 r0 *1 516.695,811.63 nfet_05v0
XM_661 n_I2811 n_I2379 n_I2812 VSS nfet_05v0 L=0.6U W=0.82U AS=0.1312P
+ AD=0.1722P PS=1.14U PD=1.24U
* device instance _662 r0 *1 517.715,811.63 nfet_05v0
XM_662 n_I2357 n_I2354 n_I2811 VSS nfet_05v0 L=0.6U W=0.82U AS=0.1722P
+ AD=0.3608P PS=1.24U PD=2.52U
* device instance _663 m90 *1 515.375,821.872 pfet_05v0
XM_663 n_I2400 n_I2364 VDD_DEC VDD_DEC pfet_05v0 L=0.5U W=0.845U AS=0.3718P
+ AD=0.2197P PS=2.57U PD=1.365U
* device instance _664 m90 *1 514.355,821.872 pfet_05v0
XM_664 VDD_DEC n_I2250 n_I2400 VDD_DEC pfet_05v0 L=0.5U W=0.845U AS=0.2197P
+ AD=0.2197P PS=1.365U PD=1.365U
* device instance _665 m90 *1 513.335,821.872 pfet_05v0
XM_665 n_I2400 n_I2329 VDD_DEC VDD_DEC pfet_05v0 L=0.5U W=0.845U AS=0.2197P
+ AD=0.2197P PS=1.365U PD=1.365U
* device instance _666 m90 *1 512.315,821.872 pfet_05v0
XM_666 VDD_DEC n_I2361 n_I2400 VDD_DEC pfet_05v0 L=0.5U W=0.845U AS=0.2197P
+ AD=0.3718P PS=1.365U PD=2.57U
* device instance _667 m90 *1 515.325,819.47 nfet_05v0
XM_667 n_I2815 n_I2364 VSS VSS nfet_05v0 L=0.6U W=0.82U AS=0.3608P AD=0.1517P
+ PS=2.52U PD=1.19U
* device instance _668 m90 *1 514.355,819.47 nfet_05v0
XM_668 n_I2814 n_I2250 n_I2815 VSS nfet_05v0 L=0.6U W=0.82U AS=0.1517P
+ AD=0.1722P PS=1.19U PD=1.24U
* device instance _669 m90 *1 513.335,819.47 nfet_05v0
XM_669 n_I2813 n_I2329 n_I2814 VSS nfet_05v0 L=0.6U W=0.82U AS=0.1722P
+ AD=0.1517P PS=1.24U PD=1.19U
* device instance _670 m90 *1 512.365,819.47 nfet_05v0
XM_670 n_I2400 n_I2361 n_I2813 VSS nfet_05v0 L=0.6U W=0.82U AS=0.1517P
+ AD=0.3608P PS=1.19U PD=2.52U
* device instance _671 m0 *1 516.305,815.568 pfet_05v0
XM_671 n_I2431 n_I2356 VDD_DEC VDD_DEC pfet_05v0 L=0.5U W=0.845U AS=0.3718P
+ AD=0.2197P PS=2.57U PD=1.365U
* device instance _672 m0 *1 517.325,815.568 pfet_05v0
XM_672 VDD_DEC n_I2250 n_I2431 VDD_DEC pfet_05v0 L=0.5U W=0.845U AS=0.2197P
+ AD=0.2197P PS=1.365U PD=1.365U
* device instance _673 m0 *1 518.345,815.568 pfet_05v0
XM_673 n_I2431 n_I2329 VDD_DEC VDD_DEC pfet_05v0 L=0.5U W=0.845U AS=0.2197P
+ AD=0.2197P PS=1.365U PD=1.365U
* device instance _674 m0 *1 519.365,815.568 pfet_05v0
XM_674 VDD_DEC n_I2354 n_I2431 VDD_DEC pfet_05v0 L=0.5U W=0.845U AS=0.2197P
+ AD=0.3718P PS=1.365U PD=2.57U
* device instance _675 m0 *1 516.355,817.97 nfet_05v0
XM_675 n_I2818 n_I2356 VSS VSS nfet_05v0 L=0.6U W=0.82U AS=0.3608P AD=0.1517P
+ PS=2.52U PD=1.19U
* device instance _676 m0 *1 517.325,817.97 nfet_05v0
XM_676 n_I2817 n_I2250 n_I2818 VSS nfet_05v0 L=0.6U W=0.82U AS=0.1517P
+ AD=0.1722P PS=1.19U PD=1.24U
* device instance _677 m0 *1 518.345,817.97 nfet_05v0
XM_677 n_I2816 n_I2329 n_I2817 VSS nfet_05v0 L=0.6U W=0.82U AS=0.1722P
+ AD=0.1517P PS=1.24U PD=1.19U
* device instance _678 m0 *1 519.315,817.97 nfet_05v0
XM_678 n_I2431 n_I2354 n_I2816 VSS nfet_05v0 L=0.6U W=0.82U AS=0.1517P
+ AD=0.3608P PS=1.19U PD=2.52U
* device instance _679 m0 *1 492.785,807.728 pfet_05v0
XM_679 n_I2246 n_I2329 VDD_DEC VDD_DEC pfet_05v0 L=0.5U W=0.845U AS=0.3718P
+ AD=0.2197P PS=2.57U PD=1.365U
* device instance _680 m0 *1 493.805,807.728 pfet_05v0
XM_680 VDD_DEC n_I2354 n_I2246 VDD_DEC pfet_05v0 L=0.5U W=0.845U AS=0.2197P
+ AD=0.2197P PS=1.365U PD=1.365U
* device instance _681 m0 *1 494.825,807.728 pfet_05v0
XM_681 n_I2246 n_I2322 VDD_DEC VDD_DEC pfet_05v0 L=0.5U W=0.845U AS=0.2197P
+ AD=0.2197P PS=1.365U PD=1.365U
* device instance _682 m0 *1 495.845,807.728 pfet_05v0
XM_682 VDD_DEC n_I2304 n_I2246 VDD_DEC pfet_05v0 L=0.5U W=0.845U AS=0.2197P
+ AD=0.3718P PS=1.365U PD=2.57U
* device instance _683 m0 *1 492.835,810.13 nfet_05v0
XM_683 n_I2821 n_I2329 VSS VSS nfet_05v0 L=0.6U W=0.82U AS=0.3608P AD=0.1517P
+ PS=2.52U PD=1.19U
* device instance _684 m0 *1 493.805,810.13 nfet_05v0
XM_684 n_I2820 n_I2354 n_I2821 VSS nfet_05v0 L=0.6U W=0.82U AS=0.1517P
+ AD=0.1722P PS=1.19U PD=1.24U
* device instance _685 m0 *1 494.825,810.13 nfet_05v0
XM_685 n_I2819 n_I2322 n_I2820 VSS nfet_05v0 L=0.6U W=0.82U AS=0.1722P
+ AD=0.1517P PS=1.24U PD=1.19U
* device instance _686 m0 *1 495.795,810.13 nfet_05v0
XM_686 n_I2246 n_I2304 n_I2819 VSS nfet_05v0 L=0.6U W=0.82U AS=0.1517P
+ AD=0.3608P PS=1.19U PD=2.52U
* device instance _687 m0 *1 503.985,815.568 pfet_05v0
XM_687 n_I2380 n_I2379 VDD_DEC VDD_DEC pfet_05v0 L=0.5U W=0.845U AS=0.3718P
+ AD=0.2197P PS=2.57U PD=1.365U
* device instance _688 m0 *1 505.005,815.568 pfet_05v0
XM_688 VDD_DEC n_I2354 n_I2380 VDD_DEC pfet_05v0 L=0.5U W=0.845U AS=0.2197P
+ AD=0.2197P PS=1.365U PD=1.365U
* device instance _689 m0 *1 506.025,815.568 pfet_05v0
XM_689 n_I2380 n_I2322 VDD_DEC VDD_DEC pfet_05v0 L=0.5U W=0.845U AS=0.2197P
+ AD=0.2197P PS=1.365U PD=1.365U
* device instance _690 m0 *1 507.045,815.568 pfet_05v0
XM_690 VDD_DEC n_I2304 n_I2380 VDD_DEC pfet_05v0 L=0.5U W=0.845U AS=0.2197P
+ AD=0.3718P PS=1.365U PD=2.57U
* device instance _691 m0 *1 504.035,817.97 nfet_05v0
XM_691 n_I2824 n_I2379 VSS VSS nfet_05v0 L=0.6U W=0.82U AS=0.3608P AD=0.1517P
+ PS=2.52U PD=1.19U
* device instance _692 m0 *1 505.005,817.97 nfet_05v0
XM_692 n_I2823 n_I2354 n_I2824 VSS nfet_05v0 L=0.6U W=0.82U AS=0.1517P
+ AD=0.1722P PS=1.19U PD=1.24U
* device instance _693 m0 *1 506.025,817.97 nfet_05v0
XM_693 n_I2822 n_I2322 n_I2823 VSS nfet_05v0 L=0.6U W=0.82U AS=0.1722P
+ AD=0.1517P PS=1.24U PD=1.19U
* device instance _694 m0 *1 506.995,817.97 nfet_05v0
XM_694 n_I2380 n_I2304 n_I2822 VSS nfet_05v0 L=0.6U W=0.82U AS=0.1517P
+ AD=0.3608P PS=1.19U PD=2.52U
* device instance _695 m0 *1 519.665,823.408 pfet_05v0
XM_695 n_I2233 n_I2364 VDD_DEC VDD_DEC pfet_05v0 L=0.5U W=0.845U AS=0.3718P
+ AD=0.2197P PS=2.57U PD=1.365U
* device instance _696 m0 *1 520.685,823.408 pfet_05v0
XM_696 VDD_DEC n_I2358 n_I2233 VDD_DEC pfet_05v0 L=0.5U W=0.845U AS=0.2197P
+ AD=0.2197P PS=1.365U PD=1.365U
* device instance _697 m0 *1 521.705,823.408 pfet_05v0
XM_697 n_I2233 n_I2329 VDD_DEC VDD_DEC pfet_05v0 L=0.5U W=0.845U AS=0.2197P
+ AD=0.2197P PS=1.365U PD=1.365U
* device instance _698 m0 *1 522.725,823.408 pfet_05v0
XM_698 VDD_DEC n_I2361 n_I2233 VDD_DEC pfet_05v0 L=0.5U W=0.845U AS=0.2197P
+ AD=0.3718P PS=1.365U PD=2.57U
* device instance _699 m0 *1 519.715,825.81 nfet_05v0
XM_699 n_I2827 n_I2364 VSS VSS nfet_05v0 L=0.6U W=0.82U AS=0.3608P AD=0.1517P
+ PS=2.52U PD=1.19U
* device instance _700 m0 *1 520.685,825.81 nfet_05v0
XM_700 n_I2826 n_I2358 n_I2827 VSS nfet_05v0 L=0.6U W=0.82U AS=0.1517P
+ AD=0.1722P PS=1.19U PD=1.24U
* device instance _701 m0 *1 521.705,825.81 nfet_05v0
XM_701 n_I2825 n_I2329 n_I2826 VSS nfet_05v0 L=0.6U W=0.82U AS=0.1722P
+ AD=0.1517P PS=1.24U PD=1.19U
* device instance _702 m0 *1 522.675,825.81 nfet_05v0
XM_702 n_I2233 n_I2361 n_I2825 VSS nfet_05v0 L=0.6U W=0.82U AS=0.1517P
+ AD=0.3608P PS=1.19U PD=2.52U
* device instance _703 m0 *1 493.905,815.568 pfet_05v0
XM_703 n_I2330 n_I2329 VDD_DEC VDD_DEC pfet_05v0 L=0.5U W=0.845U AS=0.3718P
+ AD=0.2197P PS=2.57U PD=1.365U
* device instance _704 m0 *1 494.925,815.568 pfet_05v0
XM_704 VDD_DEC n_I2354 n_I2330 VDD_DEC pfet_05v0 L=0.5U W=0.845U AS=0.2197P
+ AD=0.2197P PS=1.365U PD=1.365U
* device instance _705 m0 *1 495.945,815.568 pfet_05v0
XM_705 n_I2330 n_I2303 VDD_DEC VDD_DEC pfet_05v0 L=0.5U W=0.845U AS=0.2197P
+ AD=0.2197P PS=1.365U PD=1.365U
* device instance _706 m0 *1 496.965,815.568 pfet_05v0
XM_706 VDD_DEC n_I2353 n_I2330 VDD_DEC pfet_05v0 L=0.5U W=0.845U AS=0.2197P
+ AD=0.3718P PS=1.365U PD=2.57U
* device instance _707 m0 *1 493.955,817.97 nfet_05v0
XM_707 n_I2830 n_I2329 VSS VSS nfet_05v0 L=0.6U W=0.82U AS=0.3608P AD=0.1517P
+ PS=2.52U PD=1.19U
* device instance _708 m0 *1 494.925,817.97 nfet_05v0
XM_708 n_I2829 n_I2354 n_I2830 VSS nfet_05v0 L=0.6U W=0.82U AS=0.1517P
+ AD=0.1722P PS=1.19U PD=1.24U
* device instance _709 m0 *1 495.945,817.97 nfet_05v0
XM_709 n_I2828 n_I2303 n_I2829 VSS nfet_05v0 L=0.6U W=0.82U AS=0.1722P
+ AD=0.1517P PS=1.24U PD=1.19U
* device instance _710 m0 *1 496.915,817.97 nfet_05v0
XM_710 n_I2330 n_I2353 n_I2828 VSS nfet_05v0 L=0.6U W=0.82U AS=0.1517P
+ AD=0.3608P PS=1.19U PD=2.52U
* device instance _711 m0 *1 575.105,823.408 pfet_05v0
XM_711 n_I2283 n_I2407 VDD_DEC VDD_DEC pfet_05v0 L=0.5U W=0.845U AS=0.3718P
+ AD=0.2197P PS=2.57U PD=1.365U
* device instance _712 m0 *1 576.125,823.408 pfet_05v0
XM_712 VDD_DEC n_I2211 n_I2283 VDD_DEC pfet_05v0 L=0.5U W=0.845U AS=0.2197P
+ AD=0.2197P PS=1.365U PD=1.365U
* device instance _713 m0 *1 577.145,823.408 pfet_05v0
XM_713 n_I2283 n_I2284 VDD_DEC VDD_DEC pfet_05v0 L=0.5U W=0.845U AS=0.2197P
+ AD=0.2197P PS=1.365U PD=1.365U
* device instance _714 m0 *1 578.165,823.408 pfet_05v0
XM_714 VDD_DEC n_I2384 n_I2283 VDD_DEC pfet_05v0 L=0.5U W=0.845U AS=0.2197P
+ AD=0.3718P PS=1.365U PD=2.57U
* device instance _715 m0 *1 575.155,825.81 nfet_05v0
XM_715 n_I2833 n_I2407 VSS VSS nfet_05v0 L=0.6U W=0.82U AS=0.3608P AD=0.1517P
+ PS=2.52U PD=1.19U
* device instance _716 m0 *1 576.125,825.81 nfet_05v0
XM_716 n_I2832 n_I2211 n_I2833 VSS nfet_05v0 L=0.6U W=0.82U AS=0.1517P
+ AD=0.1722P PS=1.19U PD=1.24U
* device instance _717 m0 *1 577.145,825.81 nfet_05v0
XM_717 n_I2831 n_I2284 n_I2832 VSS nfet_05v0 L=0.6U W=0.82U AS=0.1722P
+ AD=0.1517P PS=1.24U PD=1.19U
* device instance _718 m0 *1 578.115,825.81 nfet_05v0
XM_718 n_I2283 n_I2384 n_I2831 VSS nfet_05v0 L=0.6U W=0.82U AS=0.1517P
+ AD=0.3608P PS=1.19U PD=2.52U
* device instance _719 m0 *1 528.625,823.408 pfet_05v0
XM_719 n_I2405 n_I2356 VDD_DEC VDD_DEC pfet_05v0 L=0.5U W=0.845U AS=0.3718P
+ AD=0.2197P PS=2.57U PD=1.365U
* device instance _720 m0 *1 529.645,823.408 pfet_05v0
XM_720 VDD_DEC n_I2250 n_I2405 VDD_DEC pfet_05v0 L=0.5U W=0.845U AS=0.2197P
+ AD=0.2197P PS=1.365U PD=1.365U
* device instance _721 m0 *1 530.665,823.408 pfet_05v0
XM_721 n_I2405 n_I2379 VDD_DEC VDD_DEC pfet_05v0 L=0.5U W=0.845U AS=0.2197P
+ AD=0.2197P PS=1.365U PD=1.365U
* device instance _722 m0 *1 531.685,823.408 pfet_05v0
XM_722 VDD_DEC n_I2418 n_I2405 VDD_DEC pfet_05v0 L=0.5U W=0.845U AS=0.2197P
+ AD=0.3718P PS=1.365U PD=2.57U
* device instance _723 m0 *1 528.675,825.81 nfet_05v0
XM_723 n_I2836 n_I2356 VSS VSS nfet_05v0 L=0.6U W=0.82U AS=0.3608P AD=0.1517P
+ PS=2.52U PD=1.19U
* device instance _724 m0 *1 529.645,825.81 nfet_05v0
XM_724 n_I2835 n_I2250 n_I2836 VSS nfet_05v0 L=0.6U W=0.82U AS=0.1517P
+ AD=0.1722P PS=1.19U PD=1.24U
* device instance _725 m0 *1 530.665,825.81 nfet_05v0
XM_725 n_I2834 n_I2379 n_I2835 VSS nfet_05v0 L=0.6U W=0.82U AS=0.1722P
+ AD=0.1517P PS=1.24U PD=1.19U
* device instance _726 m0 *1 531.635,825.81 nfet_05v0
XM_726 n_I2405 n_I2418 n_I2834 VSS nfet_05v0 L=0.6U W=0.82U AS=0.1517P
+ AD=0.3608P PS=1.19U PD=2.52U
* device instance _727 r180 *1 501.935,815.568 pfet_05v0
XM_727 n_I2231 n_I2329 VDD_DEC VDD_DEC pfet_05v0 L=0.5U W=0.845U AS=0.3718P
+ AD=0.2197P PS=2.57U PD=1.365U
* device instance _728 r180 *1 500.915,815.568 pfet_05v0
XM_728 VDD_DEC n_I2361 n_I2231 VDD_DEC pfet_05v0 L=0.5U W=0.845U AS=0.2197P
+ AD=0.2197P PS=1.365U PD=1.365U
* device instance _729 r180 *1 499.895,815.568 pfet_05v0
XM_729 n_I2231 n_I2322 VDD_DEC VDD_DEC pfet_05v0 L=0.5U W=0.845U AS=0.2197P
+ AD=0.2197P PS=1.365U PD=1.365U
* device instance _730 r180 *1 498.875,815.568 pfet_05v0
XM_730 VDD_DEC n_I2304 n_I2231 VDD_DEC pfet_05v0 L=0.5U W=0.845U AS=0.2197P
+ AD=0.3718P PS=1.365U PD=2.57U
* device instance _731 r180 *1 501.885,817.97 nfet_05v0
XM_731 n_I2839 n_I2329 VSS VSS nfet_05v0 L=0.6U W=0.82U AS=0.3608P AD=0.1517P
+ PS=2.52U PD=1.19U
* device instance _732 r180 *1 500.915,817.97 nfet_05v0
XM_732 n_I2838 n_I2361 n_I2839 VSS nfet_05v0 L=0.6U W=0.82U AS=0.1517P
+ AD=0.1722P PS=1.19U PD=1.24U
* device instance _733 r180 *1 499.895,817.97 nfet_05v0
XM_733 n_I2837 n_I2322 n_I2838 VSS nfet_05v0 L=0.6U W=0.82U AS=0.1722P
+ AD=0.1517P PS=1.24U PD=1.19U
* device instance _734 r180 *1 498.925,817.97 nfet_05v0
XM_734 n_I2231 n_I2304 n_I2837 VSS nfet_05v0 L=0.6U W=0.82U AS=0.1517P
+ AD=0.3608P PS=1.19U PD=2.52U
* device instance _735 r180 *1 514.255,815.568 pfet_05v0
XM_735 n_I2427 n_I2364 VDD_DEC VDD_DEC pfet_05v0 L=0.5U W=0.845U AS=0.3718P
+ AD=0.2197P PS=2.57U PD=1.365U
* device instance _736 r180 *1 513.235,815.568 pfet_05v0
XM_736 VDD_DEC n_I2250 n_I2427 VDD_DEC pfet_05v0 L=0.5U W=0.845U AS=0.2197P
+ AD=0.2197P PS=1.365U PD=1.365U
* device instance _737 r180 *1 512.215,815.568 pfet_05v0
XM_737 n_I2427 n_I2379 VDD_DEC VDD_DEC pfet_05v0 L=0.5U W=0.845U AS=0.2197P
+ AD=0.2197P PS=1.365U PD=1.365U
* device instance _738 r180 *1 511.195,815.568 pfet_05v0
XM_738 VDD_DEC n_I2361 n_I2427 VDD_DEC pfet_05v0 L=0.5U W=0.845U AS=0.2197P
+ AD=0.3718P PS=1.365U PD=2.57U
* device instance _739 r180 *1 514.205,817.97 nfet_05v0
XM_739 n_I2842 n_I2364 VSS VSS nfet_05v0 L=0.6U W=0.82U AS=0.3608P AD=0.1517P
+ PS=2.52U PD=1.19U
* device instance _740 r180 *1 513.235,817.97 nfet_05v0
XM_740 n_I2841 n_I2250 n_I2842 VSS nfet_05v0 L=0.6U W=0.82U AS=0.1517P
+ AD=0.1722P PS=1.19U PD=1.24U
* device instance _741 r180 *1 512.215,817.97 nfet_05v0
XM_741 n_I2840 n_I2379 n_I2841 VSS nfet_05v0 L=0.6U W=0.82U AS=0.1722P
+ AD=0.1517P PS=1.24U PD=1.19U
* device instance _742 r180 *1 511.245,817.97 nfet_05v0
XM_742 n_I2427 n_I2361 n_I2840 VSS nfet_05v0 L=0.6U W=0.82U AS=0.1517P
+ AD=0.3608P PS=1.19U PD=2.52U
* device instance _743 r0 *1 497.265,821.872 pfet_05v0
XM_743 n_I2363 n_I2379 VDD_DEC VDD_DEC pfet_05v0 L=0.5U W=0.845U AS=0.3718P
+ AD=0.2197P PS=2.57U PD=1.365U
* device instance _744 r0 *1 498.285,821.872 pfet_05v0
XM_744 VDD_DEC n_I2361 n_I2363 VDD_DEC pfet_05v0 L=0.5U W=0.845U AS=0.2197P
+ AD=0.2197P PS=1.365U PD=1.365U
* device instance _745 r0 *1 499.305,821.872 pfet_05v0
XM_745 n_I2363 n_I2303 VDD_DEC VDD_DEC pfet_05v0 L=0.5U W=0.845U AS=0.2197P
+ AD=0.2197P PS=1.365U PD=1.365U
* device instance _746 r0 *1 500.325,821.872 pfet_05v0
XM_746 VDD_DEC n_I2353 n_I2363 VDD_DEC pfet_05v0 L=0.5U W=0.845U AS=0.2197P
+ AD=0.3718P PS=1.365U PD=2.57U
* device instance _747 r0 *1 497.315,819.47 nfet_05v0
XM_747 n_I2845 n_I2379 VSS VSS nfet_05v0 L=0.6U W=0.82U AS=0.3608P AD=0.1517P
+ PS=2.52U PD=1.19U
* device instance _748 r0 *1 498.285,819.47 nfet_05v0
XM_748 n_I2844 n_I2361 n_I2845 VSS nfet_05v0 L=0.6U W=0.82U AS=0.1517P
+ AD=0.1722P PS=1.19U PD=1.24U
* device instance _749 r0 *1 499.305,819.47 nfet_05v0
XM_749 n_I2843 n_I2303 n_I2844 VSS nfet_05v0 L=0.6U W=0.82U AS=0.1722P
+ AD=0.1517P PS=1.24U PD=1.19U
* device instance _750 r0 *1 500.275,819.47 nfet_05v0
XM_750 n_I2363 n_I2353 n_I2843 VSS nfet_05v0 L=0.6U W=0.82U AS=0.1517P
+ AD=0.3608P PS=1.19U PD=2.52U
* device instance _751 r0 *1 530.305,829.712 pfet_05v0
XM_751 n_I2426 n_I2356 VDD_DEC VDD_DEC pfet_05v0 L=0.5U W=0.845U AS=0.3718P
+ AD=0.2197P PS=2.57U PD=1.365U
* device instance _752 r0 *1 531.325,829.712 pfet_05v0
XM_752 VDD_DEC n_I2358 n_I2426 VDD_DEC pfet_05v0 L=0.5U W=0.845U AS=0.2197P
+ AD=0.2197P PS=1.365U PD=1.365U
* device instance _753 r0 *1 532.345,829.712 pfet_05v0
XM_753 n_I2426 n_I2329 VDD_DEC VDD_DEC pfet_05v0 L=0.5U W=0.845U AS=0.2197P
+ AD=0.2197P PS=1.365U PD=1.365U
* device instance _754 r0 *1 533.365,829.712 pfet_05v0
XM_754 VDD_DEC n_I2418 n_I2426 VDD_DEC pfet_05v0 L=0.5U W=0.845U AS=0.2197P
+ AD=0.3718P PS=1.365U PD=2.57U
* device instance _755 r0 *1 530.355,827.31 nfet_05v0
XM_755 n_I2848 n_I2356 VSS VSS nfet_05v0 L=0.6U W=0.82U AS=0.3608P AD=0.1517P
+ PS=2.52U PD=1.19U
* device instance _756 r0 *1 531.325,827.31 nfet_05v0
XM_756 n_I2847 n_I2358 n_I2848 VSS nfet_05v0 L=0.6U W=0.82U AS=0.1517P
+ AD=0.1722P PS=1.19U PD=1.24U
* device instance _757 r0 *1 532.345,827.31 nfet_05v0
XM_757 n_I2846 n_I2329 n_I2847 VSS nfet_05v0 L=0.6U W=0.82U AS=0.1722P
+ AD=0.1517P PS=1.24U PD=1.19U
* device instance _758 r0 *1 533.315,827.31 nfet_05v0
XM_758 n_I2426 n_I2418 n_I2846 VSS nfet_05v0 L=0.6U W=0.82U AS=0.1517P
+ AD=0.3608P PS=1.19U PD=2.52U
* device instance _759 r0 *1 579.025,821.872 pfet_05v0
XM_759 n_I2403 n_I2407 VDD_DEC VDD_DEC pfet_05v0 L=0.5U W=0.845U AS=0.3718P
+ AD=0.2197P PS=2.57U PD=1.365U
* device instance _760 r0 *1 580.045,821.872 pfet_05v0
XM_760 VDD_DEC n_I2211 n_I2403 VDD_DEC pfet_05v0 L=0.5U W=0.845U AS=0.2197P
+ AD=0.2197P PS=1.365U PD=1.365U
* device instance _761 r0 *1 581.065,821.872 pfet_05v0
XM_761 n_I2403 n_I2169 VDD_DEC VDD_DEC pfet_05v0 L=0.5U W=0.845U AS=0.2197P
+ AD=0.2197P PS=1.365U PD=1.365U
* device instance _762 r0 *1 582.085,821.872 pfet_05v0
XM_762 VDD_DEC n_I2384 n_I2403 VDD_DEC pfet_05v0 L=0.5U W=0.845U AS=0.2197P
+ AD=0.3718P PS=1.365U PD=2.57U
* device instance _763 r0 *1 579.075,819.47 nfet_05v0
XM_763 n_I2851 n_I2407 VSS VSS nfet_05v0 L=0.6U W=0.82U AS=0.3608P AD=0.1517P
+ PS=2.52U PD=1.19U
* device instance _764 r0 *1 580.045,819.47 nfet_05v0
XM_764 n_I2850 n_I2211 n_I2851 VSS nfet_05v0 L=0.6U W=0.82U AS=0.1517P
+ AD=0.1722P PS=1.19U PD=1.24U
* device instance _765 r0 *1 581.065,819.47 nfet_05v0
XM_765 n_I2849 n_I2169 n_I2850 VSS nfet_05v0 L=0.6U W=0.82U AS=0.1722P
+ AD=0.1517P PS=1.24U PD=1.19U
* device instance _766 r0 *1 582.035,819.47 nfet_05v0
XM_766 n_I2403 n_I2384 n_I2849 VSS nfet_05v0 L=0.6U W=0.82U AS=0.1517P
+ AD=0.3608P PS=1.19U PD=2.52U
* device instance _767 r0 *1 535.345,829.712 pfet_05v0
XM_767 n_I2277 n_I2356 VDD_DEC VDD_DEC pfet_05v0 L=0.5U W=0.845U AS=0.3718P
+ AD=0.2197P PS=2.57U PD=1.365U
* device instance _768 r0 *1 536.365,829.712 pfet_05v0
XM_768 VDD_DEC n_I2358 n_I2277 VDD_DEC pfet_05v0 L=0.5U W=0.845U AS=0.2197P
+ AD=0.2197P PS=1.365U PD=1.365U
* device instance _769 r0 *1 537.385,829.712 pfet_05v0
XM_769 n_I2277 n_I2379 VDD_DEC VDD_DEC pfet_05v0 L=0.5U W=0.845U AS=0.2197P
+ AD=0.2197P PS=1.365U PD=1.365U
* device instance _770 r0 *1 538.405,829.712 pfet_05v0
XM_770 VDD_DEC n_I2418 n_I2277 VDD_DEC pfet_05v0 L=0.5U W=0.845U AS=0.2197P
+ AD=0.3718P PS=1.365U PD=2.57U
* device instance _771 r0 *1 535.395,827.31 nfet_05v0
XM_771 n_I2854 n_I2356 VSS VSS nfet_05v0 L=0.6U W=0.82U AS=0.3608P AD=0.1517P
+ PS=2.52U PD=1.19U
* device instance _772 r0 *1 536.365,827.31 nfet_05v0
XM_772 n_I2853 n_I2358 n_I2854 VSS nfet_05v0 L=0.6U W=0.82U AS=0.1517P
+ AD=0.1722P PS=1.19U PD=1.24U
* device instance _773 r0 *1 537.385,827.31 nfet_05v0
XM_773 n_I2852 n_I2379 n_I2853 VSS nfet_05v0 L=0.6U W=0.82U AS=0.1722P
+ AD=0.1517P PS=1.24U PD=1.19U
* device instance _774 r0 *1 538.355,827.31 nfet_05v0
XM_774 n_I2277 n_I2418 n_I2852 VSS nfet_05v0 L=0.6U W=0.82U AS=0.1517P
+ AD=0.3608P PS=1.19U PD=2.52U
* device instance _775 r0 *1 517.425,821.872 pfet_05v0
XM_775 n_I2406 n_I2364 VDD_DEC VDD_DEC pfet_05v0 L=0.5U W=0.845U AS=0.3718P
+ AD=0.2197P PS=2.57U PD=1.365U
* device instance _776 r0 *1 518.445,821.872 pfet_05v0
XM_776 VDD_DEC n_I2358 n_I2406 VDD_DEC pfet_05v0 L=0.5U W=0.845U AS=0.2197P
+ AD=0.2197P PS=1.365U PD=1.365U
* device instance _777 r0 *1 519.465,821.872 pfet_05v0
XM_777 n_I2406 n_I2379 VDD_DEC VDD_DEC pfet_05v0 L=0.5U W=0.845U AS=0.2197P
+ AD=0.2197P PS=1.365U PD=1.365U
* device instance _778 r0 *1 520.485,821.872 pfet_05v0
XM_778 VDD_DEC n_I2361 n_I2406 VDD_DEC pfet_05v0 L=0.5U W=0.845U AS=0.2197P
+ AD=0.3718P PS=1.365U PD=2.57U
* device instance _779 r0 *1 517.475,819.47 nfet_05v0
XM_779 n_I2857 n_I2364 VSS VSS nfet_05v0 L=0.6U W=0.82U AS=0.3608P AD=0.1517P
+ PS=2.52U PD=1.19U
* device instance _780 r0 *1 518.445,819.47 nfet_05v0
XM_780 n_I2856 n_I2358 n_I2857 VSS nfet_05v0 L=0.6U W=0.82U AS=0.1517P
+ AD=0.1722P PS=1.19U PD=1.24U
* device instance _781 r0 *1 519.465,819.47 nfet_05v0
XM_781 n_I2855 n_I2379 n_I2856 VSS nfet_05v0 L=0.6U W=0.82U AS=0.1722P
+ AD=0.1517P PS=1.24U PD=1.19U
* device instance _782 r0 *1 520.435,819.47 nfet_05v0
XM_782 n_I2406 n_I2361 n_I2855 VSS nfet_05v0 L=0.6U W=0.82U AS=0.1517P
+ AD=0.3608P PS=1.19U PD=2.52U
* device instance _783 r0 *1 489.425,814.032 pfet_05v0
XM_783 n_I2362 n_I2329 VDD_DEC VDD_DEC pfet_05v0 L=0.5U W=0.845U AS=0.3718P
+ AD=0.2197P PS=2.57U PD=1.365U
* device instance _784 r0 *1 490.445,814.032 pfet_05v0
XM_784 VDD_DEC n_I2361 n_I2362 VDD_DEC pfet_05v0 L=0.5U W=0.845U AS=0.2197P
+ AD=0.2197P PS=1.365U PD=1.365U
* device instance _785 r0 *1 491.465,814.032 pfet_05v0
XM_785 n_I2362 n_I2303 VDD_DEC VDD_DEC pfet_05v0 L=0.5U W=0.845U AS=0.2197P
+ AD=0.2197P PS=1.365U PD=1.365U
* device instance _786 r0 *1 492.485,814.032 pfet_05v0
XM_786 VDD_DEC n_I2353 n_I2362 VDD_DEC pfet_05v0 L=0.5U W=0.845U AS=0.2197P
+ AD=0.3718P PS=1.365U PD=2.57U
* device instance _787 r0 *1 489.475,811.63 nfet_05v0
XM_787 n_I2860 n_I2329 VSS VSS nfet_05v0 L=0.6U W=0.82U AS=0.3608P AD=0.1517P
+ PS=2.52U PD=1.19U
* device instance _788 r0 *1 490.445,811.63 nfet_05v0
XM_788 n_I2859 n_I2361 n_I2860 VSS nfet_05v0 L=0.6U W=0.82U AS=0.1517P
+ AD=0.1722P PS=1.19U PD=1.24U
* device instance _789 r0 *1 491.465,811.63 nfet_05v0
XM_789 n_I2858 n_I2303 n_I2859 VSS nfet_05v0 L=0.6U W=0.82U AS=0.1722P
+ AD=0.1517P PS=1.24U PD=1.19U
* device instance _790 r0 *1 492.435,811.63 nfet_05v0
XM_790 n_I2362 n_I2353 n_I2858 VSS nfet_05v0 L=0.6U W=0.82U AS=0.1517P
+ AD=0.3608P PS=1.19U PD=2.52U
* device instance _791 r0 *1 494.465,814.032 pfet_05v0
XM_791 n_I2323 n_I2379 VDD_DEC VDD_DEC pfet_05v0 L=0.5U W=0.845U AS=0.3718P
+ AD=0.2197P PS=2.57U PD=1.365U
* device instance _792 r0 *1 495.485,814.032 pfet_05v0
XM_792 VDD_DEC n_I2354 n_I2323 VDD_DEC pfet_05v0 L=0.5U W=0.845U AS=0.2197P
+ AD=0.2197P PS=1.365U PD=1.365U
* device instance _793 r0 *1 496.505,814.032 pfet_05v0
XM_793 n_I2323 n_I2303 VDD_DEC VDD_DEC pfet_05v0 L=0.5U W=0.845U AS=0.2197P
+ AD=0.2197P PS=1.365U PD=1.365U
* device instance _794 r0 *1 497.525,814.032 pfet_05v0
XM_794 VDD_DEC n_I2353 n_I2323 VDD_DEC pfet_05v0 L=0.5U W=0.845U AS=0.2197P
+ AD=0.3718P PS=1.365U PD=2.57U
* device instance _795 r0 *1 494.515,811.63 nfet_05v0
XM_795 n_I2863 n_I2379 VSS VSS nfet_05v0 L=0.6U W=0.82U AS=0.3608P AD=0.1517P
+ PS=2.52U PD=1.19U
* device instance _796 r0 *1 495.485,811.63 nfet_05v0
XM_796 n_I2862 n_I2354 n_I2863 VSS nfet_05v0 L=0.6U W=0.82U AS=0.1517P
+ AD=0.1722P PS=1.19U PD=1.24U
* device instance _797 r0 *1 496.505,811.63 nfet_05v0
XM_797 n_I2861 n_I2303 n_I2862 VSS nfet_05v0 L=0.6U W=0.82U AS=0.1722P
+ AD=0.1517P PS=1.24U PD=1.19U
* device instance _798 r0 *1 497.475,811.63 nfet_05v0
XM_798 n_I2323 n_I2353 n_I2861 VSS nfet_05v0 L=0.6U W=0.82U AS=0.1517P
+ AD=0.3608P PS=1.19U PD=2.52U
* device instance _799 r0 *1 491.105,806.192 pfet_05v0
XM_799 n_I2306 n_I2379 VDD_DEC VDD_DEC pfet_05v0 L=0.5U W=0.845U AS=0.3718P
+ AD=0.2197P PS=2.57U PD=1.365U
* device instance _800 r0 *1 492.125,806.192 pfet_05v0
XM_800 VDD_DEC n_I2361 n_I2306 VDD_DEC pfet_05v0 L=0.5U W=0.845U AS=0.2197P
+ AD=0.2197P PS=1.365U PD=1.365U
* device instance _801 r0 *1 493.145,806.192 pfet_05v0
XM_801 n_I2306 n_I2322 VDD_DEC VDD_DEC pfet_05v0 L=0.5U W=0.845U AS=0.2197P
+ AD=0.2197P PS=1.365U PD=1.365U
* device instance _802 r0 *1 494.165,806.192 pfet_05v0
XM_802 VDD_DEC n_I2304 n_I2306 VDD_DEC pfet_05v0 L=0.5U W=0.845U AS=0.2197P
+ AD=0.3718P PS=1.365U PD=2.57U
* device instance _803 r0 *1 491.155,803.79 nfet_05v0
XM_803 n_I2866 n_I2379 VSS VSS nfet_05v0 L=0.6U W=0.82U AS=0.3608P AD=0.1517P
+ PS=2.52U PD=1.19U
* device instance _804 r0 *1 492.125,803.79 nfet_05v0
XM_804 n_I2865 n_I2361 n_I2866 VSS nfet_05v0 L=0.6U W=0.82U AS=0.1517P
+ AD=0.1722P PS=1.19U PD=1.24U
* device instance _805 r0 *1 493.145,803.79 nfet_05v0
XM_805 n_I2864 n_I2322 n_I2865 VSS nfet_05v0 L=0.6U W=0.82U AS=0.1722P
+ AD=0.1517P PS=1.24U PD=1.19U
* device instance _806 r0 *1 494.115,803.79 nfet_05v0
XM_806 n_I2306 n_I2304 n_I2864 VSS nfet_05v0 L=0.6U W=0.82U AS=0.1517P
+ AD=0.3608P PS=1.19U PD=2.52U
* device instance _807 m90 *1 508.81,806.01 pfet_05v0
XM_807 n_I2361 n_I2354 VDD_DEC VDD_DEC pfet_05v0 L=0.5U W=1.22U AS=0.5368P
+ AD=0.5368P PS=3.32U PD=3.32U
* device instance _808 m90 *1 508.76,803.96 nfet_05v0
XM_808 n_I2361 n_I2354 VSS VSS nfet_05v0 L=0.6U W=0.48U AS=0.2112P AD=0.2112P
+ PS=1.84U PD=1.84U
* device instance _809 m90 *1 637.61,821.69 pfet_05v0
XM_809 n_I2175 n_I2236 VDD_DEC VDD_DEC pfet_05v0 L=0.5U W=1.22U AS=0.5368P
+ AD=0.5368P PS=3.32U PD=3.32U
* device instance _810 m90 *1 637.56,819.64 nfet_05v0
XM_810 n_I2175 n_I2236 VSS VSS nfet_05v0 L=0.6U W=0.48U AS=0.2112P AD=0.2112P
+ PS=1.84U PD=1.84U
* device instance _811 m0 *1 642.15,823.59 pfet_05v0
XM_811 n_I2385 n_I2287 VDD_DEC VDD_DEC pfet_05v0 L=0.5U W=1.22U AS=0.5368P
+ AD=0.5368P PS=3.32U PD=3.32U
* device instance _812 m0 *1 642.2,825.64 nfet_05v0
XM_812 n_I2385 n_I2287 VSS VSS nfet_05v0 L=0.6U W=0.48U AS=0.2112P AD=0.2112P
+ PS=1.84U PD=1.84U
* device instance _813 r180 *1 642.09,807.91 pfet_05v0
XM_813 n_I2311 n_I2240 VDD_DEC VDD_DEC pfet_05v0 L=0.5U W=1.22U AS=0.5368P
+ AD=0.5368P PS=3.32U PD=3.32U
* device instance _814 r180 *1 642.04,809.96 nfet_05v0
XM_814 n_I2311 n_I2240 VSS VSS nfet_05v0 L=0.6U W=0.48U AS=0.2112P AD=0.2112P
+ PS=1.84U PD=1.84U
* device instance _815 r180 *1 490.89,807.91 pfet_05v0
XM_815 n_I2329 n_I2379 VDD_DEC VDD_DEC pfet_05v0 L=0.5U W=1.22U AS=0.5368P
+ AD=0.5368P PS=3.32U PD=3.32U
* device instance _816 r180 *1 490.84,809.96 nfet_05v0
XM_816 n_I2329 n_I2379 VSS VSS nfet_05v0 L=0.6U W=0.48U AS=0.2112P AD=0.2112P
+ PS=1.84U PD=1.84U
* device instance _817 r0 *1 504.95,813.85 pfet_05v0
XM_817 n_I2304 n_I2353 VDD_DEC VDD_DEC pfet_05v0 L=0.5U W=1.22U AS=0.5368P
+ AD=0.5368P PS=3.32U PD=3.32U
* device instance _818 r0 *1 505,811.8 nfet_05v0
XM_818 n_I2304 n_I2353 VSS VSS nfet_05v0 L=0.6U W=0.48U AS=0.2112P AD=0.2112P
+ PS=1.84U PD=1.84U
* device instance _819 r0 *1 488.71,806.01 pfet_05v0
XM_819 n_I2303 n_I2322 VDD_DEC VDD_DEC pfet_05v0 L=0.5U W=1.22U AS=0.5368P
+ AD=0.5368P PS=3.32U PD=3.32U
* device instance _820 r0 *1 488.76,803.96 nfet_05v0
XM_820 n_I2303 n_I2322 VSS VSS nfet_05v0 L=0.6U W=0.48U AS=0.2112P AD=0.2112P
+ PS=1.84U PD=1.84U
* device instance _821 m90 *1 519.45,837.37 pfet_05v0
XM_821 n_I2867 n_I2419 VDD_DEC VDD_DEC pfet_05v0 L=0.5U W=1.22U AS=0.5368P
+ AD=0.4087P PS=3.32U PD=1.89U
* device instance _822 m90 *1 518.28,837.37 pfet_05v0
XM_822 n_I2249 n_I2331 n_I2867 VDD_DEC pfet_05v0 L=0.5U W=1.22U AS=0.4087P
+ AD=0.5368P PS=1.89U PD=3.32U
* device instance _823 m90 *1 519.4,835.207 nfet_05v0
XM_823 n_I2249 n_I2419 VSS VSS nfet_05v0 L=0.6U W=0.565U AS=0.2486P AD=0.1469P
+ PS=2.01U PD=1.085U
* device instance _824 m90 *1 518.28,835.207 nfet_05v0
XM_824 VSS n_I2331 n_I2249 VSS nfet_05v0 L=0.6U W=0.565U AS=0.1469P AD=0.2486P
+ PS=1.085U PD=2.01U
* device instance _825 m90 *1 574.89,806.01 pfet_05v0
XM_825 n_I2868 n_I2283 VDD_DEC VDD_DEC pfet_05v0 L=0.5U W=1.22U AS=0.5368P
+ AD=0.4087P PS=3.32U PD=1.89U
* device instance _826 m90 *1 573.72,806.01 pfet_05v0
XM_826 n_I2063 n_I2236 n_I2868 VDD_DEC pfet_05v0 L=0.5U W=1.22U AS=0.4087P
+ AD=0.5368P PS=1.89U PD=3.32U
* device instance _827 m90 *1 574.84,803.847 nfet_05v0
XM_827 n_I2063 n_I2283 VSS VSS nfet_05v0 L=0.6U W=0.565U AS=0.2486P AD=0.1469P
+ PS=2.01U PD=1.085U
* device instance _828 m90 *1 573.72,803.847 nfet_05v0
XM_828 VSS n_I2236 n_I2063 VSS nfet_05v0 L=0.6U W=0.565U AS=0.1469P AD=0.2486P
+ PS=1.085U PD=2.01U
* device instance _829 m90 *1 611.85,806.01 pfet_05v0
XM_829 n_I2869 n_I2324 VDD_DEC VDD_DEC pfet_05v0 L=0.5U W=1.22U AS=0.5368P
+ AD=0.4087P PS=3.32U PD=1.89U
* device instance _830 m90 *1 610.68,806.01 pfet_05v0
XM_830 n_I2065 n_I2342 n_I2869 VDD_DEC pfet_05v0 L=0.5U W=1.22U AS=0.4087P
+ AD=0.5368P PS=1.89U PD=3.32U
* device instance _831 m90 *1 611.8,803.847 nfet_05v0
XM_831 n_I2065 n_I2324 VSS VSS nfet_05v0 L=0.6U W=0.565U AS=0.2486P AD=0.1469P
+ PS=2.01U PD=1.085U
* device instance _832 m90 *1 610.68,803.847 nfet_05v0
XM_832 VSS n_I2342 n_I2065 VSS nfet_05v0 L=0.6U W=0.565U AS=0.1469P AD=0.2486P
+ PS=1.085U PD=2.01U
* device instance _833 m0 *1 512.23,807.91 pfet_05v0
XM_833 n_I2870 n_I2322 VDD_DEC VDD_DEC pfet_05v0 L=0.5U W=1.22U AS=0.5368P
+ AD=0.4087P PS=3.32U PD=1.89U
* device instance _834 m0 *1 513.4,807.91 pfet_05v0
XM_834 n_I2356 n_I2353 n_I2870 VDD_DEC pfet_05v0 L=0.5U W=1.22U AS=0.4087P
+ AD=0.5368P PS=1.89U PD=3.32U
* device instance _835 m0 *1 512.28,810.073 nfet_05v0
XM_835 n_I2356 n_I2322 VSS VSS nfet_05v0 L=0.6U W=0.565U AS=0.2486P AD=0.1469P
+ PS=2.01U PD=1.085U
* device instance _836 m0 *1 513.4,810.073 nfet_05v0
XM_836 VSS n_I2353 n_I2356 VSS nfet_05v0 L=0.6U W=0.565U AS=0.1469P AD=0.2486P
+ PS=1.085U PD=2.01U
* device instance _837 m0 *1 646.07,831.43 pfet_05v0
XM_837 n_I2871 n_I2324 VDD_DEC VDD_DEC pfet_05v0 L=0.5U W=1.22U AS=0.5368P
+ AD=0.4087P PS=3.32U PD=1.89U
* device instance _838 m0 *1 647.24,831.43 pfet_05v0
XM_838 n_I2421 n_I2139 n_I2871 VDD_DEC pfet_05v0 L=0.5U W=1.22U AS=0.4087P
+ AD=0.5368P PS=1.89U PD=3.32U
* device instance _839 m0 *1 646.12,833.593 nfet_05v0
XM_839 n_I2421 n_I2324 VSS VSS nfet_05v0 L=0.6U W=0.565U AS=0.2486P AD=0.1469P
+ PS=2.01U PD=1.085U
* device instance _840 m0 *1 647.24,833.593 nfet_05v0
XM_840 VSS n_I2139 n_I2421 VSS nfet_05v0 L=0.6U W=0.565U AS=0.1469P AD=0.2486P
+ PS=1.085U PD=2.01U
* device instance _841 r180 *1 568.73,823.59 pfet_05v0
XM_841 n_I2872 n_I2403 VDD_DEC VDD_DEC pfet_05v0 L=0.5U W=1.22U AS=0.5368P
+ AD=0.4087P PS=3.32U PD=1.89U
* device instance _842 r180 *1 567.56,823.59 pfet_05v0
XM_842 n_I2129 n_I2280 n_I2872 VDD_DEC pfet_05v0 L=0.5U W=1.22U AS=0.4087P
+ AD=0.5368P PS=1.89U PD=3.32U
* device instance _843 r180 *1 568.68,825.753 nfet_05v0
XM_843 n_I2129 n_I2403 VSS VSS nfet_05v0 L=0.6U W=0.565U AS=0.2486P AD=0.1469P
+ PS=2.01U PD=1.085U
* device instance _844 r180 *1 567.56,825.753 nfet_05v0
XM_844 VSS n_I2280 n_I2129 VSS nfet_05v0 L=0.6U W=0.565U AS=0.1469P AD=0.2486P
+ PS=1.085U PD=2.01U
* device instance _845 r180 *1 529.53,815.75 pfet_05v0
XM_845 n_I2873 n_I2382 VDD_DEC VDD_DEC pfet_05v0 L=0.5U W=1.22U AS=0.5368P
+ AD=0.4087P PS=3.32U PD=1.89U
* device instance _846 r180 *1 528.36,815.75 pfet_05v0
XM_846 n_I2336 n_I2384 n_I2873 VDD_DEC pfet_05v0 L=0.5U W=1.22U AS=0.4087P
+ AD=0.5368P PS=1.89U PD=3.32U
* device instance _847 r180 *1 529.48,817.913 nfet_05v0
XM_847 n_I2336 n_I2382 VSS VSS nfet_05v0 L=0.6U W=0.565U AS=0.2486P AD=0.1469P
+ PS=2.01U PD=1.085U
* device instance _848 r180 *1 528.36,817.913 nfet_05v0
XM_848 VSS n_I2384 n_I2336 VSS nfet_05v0 L=0.6U W=0.565U AS=0.1469P AD=0.2486P
+ PS=1.085U PD=2.01U
* device instance _849 r180 *1 563.69,807.91 pfet_05v0
XM_849 n_I2874 n_I2339 VDD_DEC VDD_DEC pfet_05v0 L=0.5U W=1.22U AS=0.5368P
+ AD=0.4087P PS=3.32U PD=1.89U
* device instance _850 r180 *1 562.52,807.91 pfet_05v0
XM_850 n_I2281 n_I2280 n_I2874 VDD_DEC pfet_05v0 L=0.5U W=1.22U AS=0.4087P
+ AD=0.5368P PS=1.89U PD=3.32U
* device instance _851 r180 *1 563.64,810.073 nfet_05v0
XM_851 n_I2281 n_I2339 VSS VSS nfet_05v0 L=0.6U W=0.565U AS=0.2486P AD=0.1469P
+ PS=2.01U PD=1.085U
* device instance _852 r180 *1 562.52,810.073 nfet_05v0
XM_852 VSS n_I2280 n_I2281 VSS nfet_05v0 L=0.6U W=0.565U AS=0.1469P AD=0.2486P
+ PS=1.085U PD=2.01U
* device instance _853 r0 *1 586.71,821.69 pfet_05v0
XM_853 n_I2875 n_I2419 VDD_DEC VDD_DEC pfet_05v0 L=0.5U W=1.22U AS=0.5368P
+ AD=0.4087P PS=3.32U PD=1.89U
* device instance _854 r0 *1 587.88,821.69 pfet_05v0
XM_854 n_I2068 n_I2252 n_I2875 VDD_DEC pfet_05v0 L=0.5U W=1.22U AS=0.4087P
+ AD=0.5368P PS=1.89U PD=3.32U
* device instance _855 r0 *1 586.76,819.527 nfet_05v0
XM_855 n_I2068 n_I2419 VSS VSS nfet_05v0 L=0.6U W=0.565U AS=0.2486P AD=0.1469P
+ PS=2.01U PD=1.085U
* device instance _856 r0 *1 587.88,819.527 nfet_05v0
XM_856 VSS n_I2252 n_I2068 VSS nfet_05v0 L=0.6U W=0.565U AS=0.1469P AD=0.2486P
+ PS=1.085U PD=2.01U
* device instance _857 r0 *1 630.39,829.53 pfet_05v0
XM_857 n_I2876 n_I2339 VDD_DEC VDD_DEC pfet_05v0 L=0.5U W=1.22U AS=0.5368P
+ AD=0.4087P PS=3.32U PD=1.89U
* device instance _858 r0 *1 631.56,829.53 pfet_05v0
XM_858 n_I2408 n_I2139 n_I2876 VDD_DEC pfet_05v0 L=0.5U W=1.22U AS=0.4087P
+ AD=0.5368P PS=1.89U PD=3.32U
* device instance _859 r0 *1 630.44,827.367 nfet_05v0
XM_859 n_I2408 n_I2339 VSS VSS nfet_05v0 L=0.6U W=0.565U AS=0.2486P AD=0.1469P
+ PS=2.01U PD=1.085U
* device instance _860 r0 *1 631.56,827.367 nfet_05v0
XM_860 VSS n_I2139 n_I2408 VSS nfet_05v0 L=0.6U W=0.565U AS=0.1469P AD=0.2486P
+ PS=1.085U PD=2.01U
* device instance _861 r0 *1 643.83,806.01 pfet_05v0
XM_861 n_I2877 n_I2283 VDD_DEC VDD_DEC pfet_05v0 L=0.5U W=1.22U AS=0.5368P
+ AD=0.4087P PS=3.32U PD=1.89U
* device instance _862 r0 *1 645,806.01 pfet_05v0
XM_862 n_I2326 n_I2139 n_I2877 VDD_DEC pfet_05v0 L=0.5U W=1.22U AS=0.4087P
+ AD=0.5368P PS=1.89U PD=3.32U
* device instance _863 r0 *1 643.88,803.847 nfet_05v0
XM_863 n_I2326 n_I2283 VSS VSS nfet_05v0 L=0.6U W=0.565U AS=0.2486P AD=0.1469P
+ PS=2.01U PD=1.085U
* device instance _864 r0 *1 645,803.847 nfet_05v0
XM_864 VSS n_I2139 n_I2326 VSS nfet_05v0 L=0.6U W=0.565U AS=0.1469P AD=0.2486P
+ PS=1.085U PD=2.01U
* device instance _865 r0 *1 621.43,790.33 pfet_05v0
XM_865 n_I2878 n_I2403 VDD_DEC VDD_DEC pfet_05v0 L=0.5U W=1.22U AS=0.5368P
+ AD=0.4087P PS=3.32U PD=1.89U
* device instance _866 r0 *1 622.6,790.33 pfet_05v0
XM_866 n_I2174 n_I2175 n_I2878 VDD_DEC pfet_05v0 L=0.5U W=1.22U AS=0.4087P
+ AD=0.5368P PS=1.89U PD=3.32U
* device instance _867 r0 *1 621.48,788.167 nfet_05v0
XM_867 n_I2174 n_I2403 VSS VSS nfet_05v0 L=0.6U W=0.565U AS=0.2486P AD=0.1469P
+ PS=2.01U PD=1.085U
* device instance _868 r0 *1 622.6,788.167 nfet_05v0
XM_868 VSS n_I2175 n_I2174 VSS nfet_05v0 L=0.6U W=0.565U AS=0.1469P AD=0.2486P
+ PS=1.085U PD=2.01U
* device instance _869 m90 *1 590.47,790.33 pfet_05v0
XM_869 n_I2881 n_I2165 VDD_DEC VDD_DEC pfet_05v0 L=0.5U W=1.22U AS=0.5368P
+ AD=0.3172P PS=3.32U PD=1.74U
* device instance _870 m90 *1 589.45,790.33 pfet_05v0
XM_870 n_I2880 n_I2172 n_I2881 VDD_DEC pfet_05v0 L=0.5U W=1.22U AS=0.3172P
+ AD=0.3782P PS=1.74U PD=1.84U
* device instance _871 m90 *1 588.33,790.33 pfet_05v0
XM_871 n_I2879 n_I2210 n_I2880 VDD_DEC pfet_05v0 L=0.5U W=1.22U AS=0.3782P
+ AD=0.3782P PS=1.84U PD=1.84U
* device instance _872 m90 *1 587.21,790.33 pfet_05v0
XM_872 n_I2069 n_I2171 n_I2879 VDD_DEC pfet_05v0 L=0.5U W=1.22U AS=0.3782P
+ AD=0.5368P PS=1.84U PD=3.32U
* device instance _873 m90 *1 590.52,788.02 nfet_05v0
XM_873 n_I2069 n_I2165 VSS VSS nfet_05v0 L=0.6U W=0.36U AS=0.1584P AD=0.0936P
+ PS=1.6U PD=0.88U
* device instance _874 m90 *1 589.4,788.02 nfet_05v0
XM_874 VSS n_I2172 n_I2069 VSS nfet_05v0 L=0.6U W=0.36U AS=0.0936P AD=0.0936P
+ PS=0.88U PD=0.88U
* device instance _875 m90 *1 588.28,788.02 nfet_05v0
XM_875 n_I2069 n_I2210 VSS VSS nfet_05v0 L=0.6U W=0.36U AS=0.0936P AD=0.0936P
+ PS=0.88U PD=0.88U
* device instance _876 m90 *1 587.16,788.02 nfet_05v0
XM_876 VSS n_I2171 n_I2069 VSS nfet_05v0 L=0.6U W=0.36U AS=0.0936P AD=0.1584P
+ PS=0.88U PD=1.6U
* device instance _877 m90 *1 544.55,813.85 pfet_05v0
XM_877 n_I2884 n_I2309 VDD_DEC VDD_DEC pfet_05v0 L=0.5U W=1.22U AS=0.5368P
+ AD=0.3172P PS=3.32U PD=1.74U
* device instance _878 m90 *1 543.53,813.85 pfet_05v0
XM_878 n_I2883 n_I2202 n_I2884 VDD_DEC pfet_05v0 L=0.5U W=1.22U AS=0.3172P
+ AD=0.3782P PS=1.74U PD=1.84U
* device instance _879 m90 *1 542.41,813.85 pfet_05v0
XM_879 n_I2882 n_I2333 n_I2883 VDD_DEC pfet_05v0 L=0.5U W=1.22U AS=0.3782P
+ AD=0.3782P PS=1.84U PD=1.84U
* device instance _880 m90 *1 541.29,813.85 pfet_05v0
XM_880 n_I2058 n_I2359 n_I2882 VDD_DEC pfet_05v0 L=0.5U W=1.22U AS=0.3782P
+ AD=0.5368P PS=1.84U PD=3.32U
* device instance _881 m90 *1 544.6,811.54 nfet_05v0
XM_881 n_I2058 n_I2309 VSS VSS nfet_05v0 L=0.6U W=0.36U AS=0.1584P AD=0.0936P
+ PS=1.6U PD=0.88U
* device instance _882 m90 *1 543.48,811.54 nfet_05v0
XM_882 VSS n_I2202 n_I2058 VSS nfet_05v0 L=0.6U W=0.36U AS=0.0936P AD=0.0936P
+ PS=0.88U PD=0.88U
* device instance _883 m90 *1 542.36,811.54 nfet_05v0
XM_883 n_I2058 n_I2333 VSS VSS nfet_05v0 L=0.6U W=0.36U AS=0.0936P AD=0.0936P
+ PS=0.88U PD=0.88U
* device instance _884 m90 *1 541.24,811.54 nfet_05v0
XM_884 VSS n_I2359 n_I2058 VSS nfet_05v0 L=0.6U W=0.36U AS=0.0936P AD=0.1584P
+ PS=0.88U PD=1.6U
* device instance _885 m90 *1 559.11,813.85 pfet_05v0
XM_885 n_I2887 n_I2251 VDD_DEC VDD_DEC pfet_05v0 L=0.5U W=1.22U AS=0.5368P
+ AD=0.3172P PS=3.32U PD=1.74U
* device instance _886 m90 *1 558.09,813.85 pfet_05v0
XM_886 n_I2886 n_I2202 n_I2887 VDD_DEC pfet_05v0 L=0.5U W=1.22U AS=0.3172P
+ AD=0.3782P PS=1.74U PD=1.84U
* device instance _887 m90 *1 556.97,813.85 pfet_05v0
XM_887 n_I2885 n_I2383 n_I2886 VDD_DEC pfet_05v0 L=0.5U W=1.22U AS=0.3782P
+ AD=0.3782P PS=1.84U PD=1.84U
* device instance _888 m90 *1 555.85,813.85 pfet_05v0
XM_888 n_I2024 n_I2280 n_I2885 VDD_DEC pfet_05v0 L=0.5U W=1.22U AS=0.3782P
+ AD=0.5368P PS=1.84U PD=3.32U
* device instance _889 m90 *1 559.16,811.54 nfet_05v0
XM_889 n_I2024 n_I2251 VSS VSS nfet_05v0 L=0.6U W=0.36U AS=0.1584P AD=0.0936P
+ PS=1.6U PD=0.88U
* device instance _890 m90 *1 558.04,811.54 nfet_05v0
XM_890 VSS n_I2202 n_I2024 VSS nfet_05v0 L=0.6U W=0.36U AS=0.0936P AD=0.0936P
+ PS=0.88U PD=0.88U
* device instance _891 m90 *1 556.92,811.54 nfet_05v0
XM_891 n_I2024 n_I2383 VSS VSS nfet_05v0 L=0.6U W=0.36U AS=0.0936P AD=0.0936P
+ PS=0.88U PD=0.88U
* device instance _892 m90 *1 555.8,811.54 nfet_05v0
XM_892 VSS n_I2280 n_I2024 VSS nfet_05v0 L=0.6U W=0.36U AS=0.0936P AD=0.1584P
+ PS=0.88U PD=1.6U
* device instance _893 m90 *1 573.67,813.85 pfet_05v0
XM_893 n_I2890 n_I2208 VDD_DEC VDD_DEC pfet_05v0 L=0.5U W=1.22U AS=0.5368P
+ AD=0.3172P PS=3.32U PD=1.74U
* device instance _894 m90 *1 572.65,813.85 pfet_05v0
XM_894 n_I2889 n_I2206 n_I2890 VDD_DEC pfet_05v0 L=0.5U W=1.22U AS=0.3172P
+ AD=0.3782P PS=1.74U PD=1.84U
* device instance _895 m90 *1 571.53,813.85 pfet_05v0
XM_895 n_I2888 n_I2169 n_I2889 VDD_DEC pfet_05v0 L=0.5U W=1.22U AS=0.3782P
+ AD=0.3782P PS=1.84U PD=1.84U
* device instance _896 m90 *1 570.41,813.85 pfet_05v0
XM_896 n_I2163 n_I2203 n_I2888 VDD_DEC pfet_05v0 L=0.5U W=1.22U AS=0.3782P
+ AD=0.5368P PS=1.84U PD=3.32U
* device instance _897 m90 *1 573.72,811.54 nfet_05v0
XM_897 n_I2163 n_I2208 VSS VSS nfet_05v0 L=0.6U W=0.36U AS=0.1584P AD=0.0936P
+ PS=1.6U PD=0.88U
* device instance _898 m90 *1 572.6,811.54 nfet_05v0
XM_898 VSS n_I2206 n_I2163 VSS nfet_05v0 L=0.6U W=0.36U AS=0.0936P AD=0.0936P
+ PS=0.88U PD=0.88U
* device instance _899 m90 *1 571.48,811.54 nfet_05v0
XM_899 n_I2163 n_I2169 VSS VSS nfet_05v0 L=0.6U W=0.36U AS=0.0936P AD=0.0936P
+ PS=0.88U PD=0.88U
* device instance _900 m90 *1 570.36,811.54 nfet_05v0
XM_900 VSS n_I2203 n_I2163 VSS nfet_05v0 L=0.6U W=0.36U AS=0.0936P AD=0.1584P
+ PS=0.88U PD=1.6U
* device instance _901 m90 *1 503.11,813.85 pfet_05v0
XM_901 n_I2893 n_I2363 VDD_DEC VDD_DEC pfet_05v0 L=0.5U W=1.22U AS=0.5368P
+ AD=0.3172P PS=3.32U PD=1.74U
* device instance _902 m90 *1 502.09,813.85 pfet_05v0
XM_902 n_I2892 n_I2196 n_I2893 VDD_DEC pfet_05v0 L=0.5U W=1.22U AS=0.3172P
+ AD=0.3782P PS=1.74U PD=1.84U
* device instance _903 m90 *1 500.97,813.85 pfet_05v0
XM_903 n_I2891 n_I2248 n_I2892 VDD_DEC pfet_05v0 L=0.5U W=1.22U AS=0.3782P
+ AD=0.3782P PS=1.84U PD=1.84U
* device instance _904 m90 *1 499.85,813.85 pfet_05v0
XM_904 n_I2123 n_I2195 n_I2891 VDD_DEC pfet_05v0 L=0.5U W=1.22U AS=0.3782P
+ AD=0.5368P PS=1.84U PD=3.32U
* device instance _905 m90 *1 503.16,811.54 nfet_05v0
XM_905 n_I2123 n_I2363 VSS VSS nfet_05v0 L=0.6U W=0.36U AS=0.1584P AD=0.0936P
+ PS=1.6U PD=0.88U
* device instance _906 m90 *1 502.04,811.54 nfet_05v0
XM_906 VSS n_I2196 n_I2123 VSS nfet_05v0 L=0.6U W=0.36U AS=0.0936P AD=0.0936P
+ PS=0.88U PD=0.88U
* device instance _907 m90 *1 500.92,811.54 nfet_05v0
XM_907 n_I2123 n_I2248 VSS VSS nfet_05v0 L=0.6U W=0.36U AS=0.0936P AD=0.0936P
+ PS=0.88U PD=0.88U
* device instance _908 m90 *1 499.8,811.54 nfet_05v0
XM_908 VSS n_I2195 n_I2123 VSS nfet_05v0 L=0.6U W=0.36U AS=0.0936P AD=0.1584P
+ PS=0.88U PD=1.6U
* device instance _909 m90 *1 661.03,813.85 pfet_05v0
XM_909 n_I2896 n_I2237 VDD_DEC VDD_DEC pfet_05v0 L=0.5U W=1.22U AS=0.5368P
+ AD=0.3172P PS=3.32U PD=1.74U
* device instance _910 m90 *1 660.01,813.85 pfet_05v0
XM_910 n_I2895 n_I2176 n_I2896 VDD_DEC pfet_05v0 L=0.5U W=1.22U AS=0.3172P
+ AD=0.3782P PS=1.74U PD=1.84U
* device instance _911 m90 *1 658.89,813.85 pfet_05v0
XM_911 n_I2894 n_I2178 n_I2895 VDD_DEC pfet_05v0 L=0.5U W=1.22U AS=0.3782P
+ AD=0.3782P PS=1.84U PD=1.84U
* device instance _912 m90 *1 657.77,813.85 pfet_05v0
XM_912 n_I2369 n_I2177 n_I2894 VDD_DEC pfet_05v0 L=0.5U W=1.22U AS=0.3782P
+ AD=0.5368P PS=1.84U PD=3.32U
* device instance _913 m90 *1 661.08,811.54 nfet_05v0
XM_913 n_I2369 n_I2237 VSS VSS nfet_05v0 L=0.6U W=0.36U AS=0.1584P AD=0.0936P
+ PS=1.6U PD=0.88U
* device instance _914 m90 *1 659.96,811.54 nfet_05v0
XM_914 VSS n_I2176 n_I2369 VSS nfet_05v0 L=0.6U W=0.36U AS=0.0936P AD=0.0936P
+ PS=0.88U PD=0.88U
* device instance _915 m90 *1 658.84,811.54 nfet_05v0
XM_915 n_I2369 n_I2178 VSS VSS nfet_05v0 L=0.6U W=0.36U AS=0.0936P AD=0.0936P
+ PS=0.88U PD=0.88U
* device instance _916 m90 *1 657.72,811.54 nfet_05v0
XM_916 VSS n_I2177 n_I2369 VSS nfet_05v0 L=0.6U W=0.36U AS=0.0936P AD=0.1584P
+ PS=0.88U PD=1.6U
* device instance _917 m90 *1 564.71,829.53 pfet_05v0
XM_917 n_I2899 n_I2360 VDD_DEC VDD_DEC pfet_05v0 L=0.5U W=1.22U AS=0.5368P
+ AD=0.3172P PS=3.32U PD=1.74U
* device instance _918 m90 *1 563.69,829.53 pfet_05v0
XM_918 n_I2898 n_I2416 n_I2899 VDD_DEC pfet_05v0 L=0.5U W=1.22U AS=0.3172P
+ AD=0.3782P PS=1.74U PD=1.84U
* device instance _919 m90 *1 562.57,829.53 pfet_05v0
XM_919 n_I2897 n_I2169 n_I2898 VDD_DEC pfet_05v0 L=0.5U W=1.22U AS=0.3782P
+ AD=0.3782P PS=1.84U PD=1.84U
* device instance _920 m90 *1 561.45,829.53 pfet_05v0
XM_920 n_I2062 n_I2203 n_I2897 VDD_DEC pfet_05v0 L=0.5U W=1.22U AS=0.3782P
+ AD=0.5368P PS=1.84U PD=3.32U
* device instance _921 m90 *1 564.76,827.22 nfet_05v0
XM_921 n_I2062 n_I2360 VSS VSS nfet_05v0 L=0.6U W=0.36U AS=0.1584P AD=0.0936P
+ PS=1.6U PD=0.88U
* device instance _922 m90 *1 563.64,827.22 nfet_05v0
XM_922 VSS n_I2416 n_I2062 VSS nfet_05v0 L=0.6U W=0.36U AS=0.0936P AD=0.0936P
+ PS=0.88U PD=0.88U
* device instance _923 m90 *1 562.52,827.22 nfet_05v0
XM_923 n_I2062 n_I2169 VSS VSS nfet_05v0 L=0.6U W=0.36U AS=0.0936P AD=0.0936P
+ PS=0.88U PD=0.88U
* device instance _924 m90 *1 561.4,827.22 nfet_05v0
XM_924 VSS n_I2203 n_I2062 VSS nfet_05v0 L=0.6U W=0.36U AS=0.0936P AD=0.1584P
+ PS=0.88U PD=1.6U
* device instance _925 m90 *1 580.39,798.17 pfet_05v0
XM_925 n_I2902 n_I2251 VDD_DEC VDD_DEC pfet_05v0 L=0.5U W=1.22U AS=0.5368P
+ AD=0.3172P PS=3.32U PD=1.74U
* device instance _926 m90 *1 579.37,798.17 pfet_05v0
XM_926 n_I2901 n_I2206 n_I2902 VDD_DEC pfet_05v0 L=0.5U W=1.22U AS=0.3172P
+ AD=0.3782P PS=1.74U PD=1.84U
* device instance _927 m90 *1 578.25,798.17 pfet_05v0
XM_927 n_I2900 n_I2207 n_I2901 VDD_DEC pfet_05v0 L=0.5U W=1.22U AS=0.3782P
+ AD=0.3782P PS=1.84U PD=1.84U
* device instance _928 m90 *1 577.13,798.17 pfet_05v0
XM_928 n_I2027 n_I2236 n_I2900 VDD_DEC pfet_05v0 L=0.5U W=1.22U AS=0.3782P
+ AD=0.5368P PS=1.84U PD=3.32U
* device instance _929 m90 *1 580.44,795.86 nfet_05v0
XM_929 n_I2027 n_I2251 VSS VSS nfet_05v0 L=0.6U W=0.36U AS=0.1584P AD=0.0936P
+ PS=1.6U PD=0.88U
* device instance _930 m90 *1 579.32,795.86 nfet_05v0
XM_930 VSS n_I2206 n_I2027 VSS nfet_05v0 L=0.6U W=0.36U AS=0.0936P AD=0.0936P
+ PS=0.88U PD=0.88U
* device instance _931 m90 *1 578.2,795.86 nfet_05v0
XM_931 n_I2027 n_I2207 VSS VSS nfet_05v0 L=0.6U W=0.36U AS=0.0936P AD=0.0936P
+ PS=0.88U PD=0.88U
* device instance _932 m90 *1 577.08,795.86 nfet_05v0
XM_932 VSS n_I2236 n_I2027 VSS nfet_05v0 L=0.6U W=0.36U AS=0.0936P AD=0.1584P
+ PS=0.88U PD=1.6U
* device instance _933 m90 *1 505.35,806.01 pfet_05v0
XM_933 n_I2905 n_I2306 VDD_DEC VDD_DEC pfet_05v0 L=0.5U W=1.22U AS=0.5368P
+ AD=0.3172P PS=3.32U PD=1.74U
* device instance _934 m90 *1 504.33,806.01 pfet_05v0
XM_934 n_I2904 n_I2199 n_I2905 VDD_DEC pfet_05v0 L=0.5U W=1.22U AS=0.3172P
+ AD=0.3782P PS=1.74U PD=1.84U
* device instance _935 m90 *1 503.21,806.01 pfet_05v0
XM_935 n_I2903 n_I2248 n_I2904 VDD_DEC pfet_05v0 L=0.5U W=1.22U AS=0.3782P
+ AD=0.3782P PS=1.84U PD=1.84U
* device instance _936 m90 *1 502.09,806.01 pfet_05v0
XM_936 n_I2305 n_I2200 n_I2903 VDD_DEC pfet_05v0 L=0.5U W=1.22U AS=0.3782P
+ AD=0.5368P PS=1.84U PD=3.32U
* device instance _937 m90 *1 505.4,803.7 nfet_05v0
XM_937 n_I2305 n_I2306 VSS VSS nfet_05v0 L=0.6U W=0.36U AS=0.1584P AD=0.0936P
+ PS=1.6U PD=0.88U
* device instance _938 m90 *1 504.28,803.7 nfet_05v0
XM_938 VSS n_I2199 n_I2305 VSS nfet_05v0 L=0.6U W=0.36U AS=0.0936P AD=0.0936P
+ PS=0.88U PD=0.88U
* device instance _939 m90 *1 503.16,803.7 nfet_05v0
XM_939 n_I2305 n_I2248 VSS VSS nfet_05v0 L=0.6U W=0.36U AS=0.0936P AD=0.0936P
+ PS=0.88U PD=0.88U
* device instance _940 m90 *1 502.04,803.7 nfet_05v0
XM_940 VSS n_I2200 n_I2305 VSS nfet_05v0 L=0.6U W=0.36U AS=0.0936P AD=0.1584P
+ PS=0.88U PD=1.6U
* device instance _941 m90 *1 562.47,806.01 pfet_05v0
XM_941 n_I2908 n_I2357 VDD_DEC VDD_DEC pfet_05v0 L=0.5U W=1.22U AS=0.5368P
+ AD=0.3172P PS=3.32U PD=1.74U
* device instance _942 m90 *1 561.45,806.01 pfet_05v0
XM_942 n_I2907 n_I2202 n_I2908 VDD_DEC pfet_05v0 L=0.5U W=1.22U AS=0.3172P
+ AD=0.3782P PS=1.74U PD=1.84U
* device instance _943 m90 *1 560.33,806.01 pfet_05v0
XM_943 n_I2906 n_I2383 n_I2907 VDD_DEC pfet_05v0 L=0.5U W=1.22U AS=0.3782P
+ AD=0.3782P PS=1.84U PD=1.84U
* device instance _944 m90 *1 559.21,806.01 pfet_05v0
XM_944 n_I2130 n_I2280 n_I2906 VDD_DEC pfet_05v0 L=0.5U W=1.22U AS=0.3782P
+ AD=0.5368P PS=1.84U PD=3.32U
* device instance _945 m90 *1 562.52,803.7 nfet_05v0
XM_945 n_I2130 n_I2357 VSS VSS nfet_05v0 L=0.6U W=0.36U AS=0.1584P AD=0.0936P
+ PS=1.6U PD=0.88U
* device instance _946 m90 *1 561.4,803.7 nfet_05v0
XM_946 VSS n_I2202 n_I2130 VSS nfet_05v0 L=0.6U W=0.36U AS=0.0936P AD=0.0936P
+ PS=0.88U PD=0.88U
* device instance _947 m90 *1 560.28,803.7 nfet_05v0
XM_947 n_I2130 n_I2383 VSS VSS nfet_05v0 L=0.6U W=0.36U AS=0.0936P AD=0.0936P
+ PS=0.88U PD=0.88U
* device instance _948 m90 *1 559.16,803.7 nfet_05v0
XM_948 VSS n_I2280 n_I2130 VSS nfet_05v0 L=0.6U W=0.36U AS=0.0936P AD=0.1584P
+ PS=0.88U PD=1.6U
* device instance _949 m90 *1 496.39,798.17 pfet_05v0
XM_949 n_I2911 n_I2231 VDD_DEC VDD_DEC pfet_05v0 L=0.5U W=1.22U AS=0.5368P
+ AD=0.3172P PS=3.32U PD=1.74U
* device instance _950 m90 *1 495.37,798.17 pfet_05v0
XM_950 n_I2910 n_I2196 n_I2911 VDD_DEC pfet_05v0 L=0.5U W=1.22U AS=0.3172P
+ AD=0.3782P PS=1.74U PD=1.84U
* device instance _951 m90 *1 494.25,798.17 pfet_05v0
XM_951 n_I2909 n_I2248 n_I2910 VDD_DEC pfet_05v0 L=0.5U W=1.22U AS=0.3782P
+ AD=0.3782P PS=1.84U PD=1.84U
* device instance _952 m90 *1 493.13,798.17 pfet_05v0
XM_952 n_I2197 n_I2195 n_I2909 VDD_DEC pfet_05v0 L=0.5U W=1.22U AS=0.3782P
+ AD=0.5368P PS=1.84U PD=3.32U
* device instance _953 m90 *1 496.44,795.86 nfet_05v0
XM_953 n_I2197 n_I2231 VSS VSS nfet_05v0 L=0.6U W=0.36U AS=0.1584P AD=0.0936P
+ PS=1.6U PD=0.88U
* device instance _954 m90 *1 495.32,795.86 nfet_05v0
XM_954 VSS n_I2196 n_I2197 VSS nfet_05v0 L=0.6U W=0.36U AS=0.0936P AD=0.0936P
+ PS=0.88U PD=0.88U
* device instance _955 m90 *1 494.2,795.86 nfet_05v0
XM_955 n_I2197 n_I2248 VSS VSS nfet_05v0 L=0.6U W=0.36U AS=0.0936P AD=0.0936P
+ PS=0.88U PD=0.88U
* device instance _956 m90 *1 493.08,795.86 nfet_05v0
XM_956 VSS n_I2195 n_I2197 VSS nfet_05v0 L=0.6U W=0.36U AS=0.0936P AD=0.1584P
+ PS=0.88U PD=1.6U
* device instance _957 m90 *1 590.47,806.01 pfet_05v0
XM_957 n_I2914 n_I2274 VDD_DEC VDD_DEC pfet_05v0 L=0.5U W=1.22U AS=0.5368P
+ AD=0.3172P PS=3.32U PD=1.74U
* device instance _958 m90 *1 589.45,806.01 pfet_05v0
XM_958 n_I2913 n_I2206 n_I2914 VDD_DEC pfet_05v0 L=0.5U W=1.22U AS=0.3172P
+ AD=0.3782P PS=1.74U PD=1.84U
* device instance _959 m90 *1 588.33,806.01 pfet_05v0
XM_959 n_I2912 n_I2169 n_I2913 VDD_DEC pfet_05v0 L=0.5U W=1.22U AS=0.3782P
+ AD=0.3782P PS=1.84U PD=1.84U
* device instance _960 m90 *1 587.21,806.01 pfet_05v0
XM_960 n_I2026 n_I2280 n_I2912 VDD_DEC pfet_05v0 L=0.5U W=1.22U AS=0.3782P
+ AD=0.5368P PS=1.84U PD=3.32U
* device instance _961 m90 *1 590.52,803.7 nfet_05v0
XM_961 n_I2026 n_I2274 VSS VSS nfet_05v0 L=0.6U W=0.36U AS=0.1584P AD=0.0936P
+ PS=1.6U PD=0.88U
* device instance _962 m90 *1 589.4,803.7 nfet_05v0
XM_962 VSS n_I2206 n_I2026 VSS nfet_05v0 L=0.6U W=0.36U AS=0.0936P AD=0.0936P
+ PS=0.88U PD=0.88U
* device instance _963 m90 *1 588.28,803.7 nfet_05v0
XM_963 n_I2026 n_I2169 VSS VSS nfet_05v0 L=0.6U W=0.36U AS=0.0936P AD=0.0936P
+ PS=0.88U PD=0.88U
* device instance _964 m90 *1 587.16,803.7 nfet_05v0
XM_964 VSS n_I2280 n_I2026 VSS nfet_05v0 L=0.6U W=0.36U AS=0.0936P AD=0.1584P
+ PS=0.88U PD=1.6U
* device instance _965 m90 *1 570.87,806.01 pfet_05v0
XM_965 n_I2917 n_I2309 VDD_DEC VDD_DEC pfet_05v0 L=0.5U W=1.22U AS=0.5368P
+ AD=0.3172P PS=3.32U PD=1.74U
* device instance _966 m90 *1 569.85,806.01 pfet_05v0
XM_966 n_I2916 n_I2206 n_I2917 VDD_DEC pfet_05v0 L=0.5U W=1.22U AS=0.3172P
+ AD=0.3782P PS=1.74U PD=1.84U
* device instance _967 m90 *1 568.73,806.01 pfet_05v0
XM_967 n_I2915 n_I2169 n_I2916 VDD_DEC pfet_05v0 L=0.5U W=1.22U AS=0.3782P
+ AD=0.3782P PS=1.84U PD=1.84U
* device instance _968 m90 *1 567.61,806.01 pfet_05v0
XM_968 n_I2064 n_I2203 n_I2915 VDD_DEC pfet_05v0 L=0.5U W=1.22U AS=0.3782P
+ AD=0.5368P PS=1.84U PD=3.32U
* device instance _969 m90 *1 570.92,803.7 nfet_05v0
XM_969 n_I2064 n_I2309 VSS VSS nfet_05v0 L=0.6U W=0.36U AS=0.1584P AD=0.0936P
+ PS=1.6U PD=0.88U
* device instance _970 m90 *1 569.8,803.7 nfet_05v0
XM_970 VSS n_I2206 n_I2064 VSS nfet_05v0 L=0.6U W=0.36U AS=0.0936P AD=0.0936P
+ PS=0.88U PD=0.88U
* device instance _971 m90 *1 568.68,803.7 nfet_05v0
XM_971 n_I2064 n_I2169 VSS VSS nfet_05v0 L=0.6U W=0.36U AS=0.0936P AD=0.0936P
+ PS=0.88U PD=0.88U
* device instance _972 m90 *1 567.56,803.7 nfet_05v0
XM_972 VSS n_I2203 n_I2064 VSS nfet_05v0 L=0.6U W=0.36U AS=0.0936P AD=0.1584P
+ PS=0.88U PD=1.6U
* device instance _973 m90 *1 668.87,798.17 pfet_05v0
XM_973 n_I2920 n_I2251 VDD_DEC VDD_DEC pfet_05v0 L=0.5U W=1.22U AS=0.5368P
+ AD=0.3172P PS=3.32U PD=1.74U
* device instance _974 m90 *1 667.85,798.17 pfet_05v0
XM_974 n_I2919 n_I2214 n_I2920 VDD_DEC pfet_05v0 L=0.5U W=1.22U AS=0.3172P
+ AD=0.3782P PS=1.74U PD=1.84U
* device instance _975 m90 *1 666.73,798.17 pfet_05v0
XM_975 n_I2918 n_I2242 n_I2919 VDD_DEC pfet_05v0 L=0.5U W=1.22U AS=0.3782P
+ AD=0.3782P PS=1.84U PD=1.84U
* device instance _976 m90 *1 665.61,798.17 pfet_05v0
XM_976 n_I2259 n_I2139 n_I2918 VDD_DEC pfet_05v0 L=0.5U W=1.22U AS=0.3782P
+ AD=0.5368P PS=1.84U PD=3.32U
* device instance _977 m90 *1 668.92,795.86 nfet_05v0
XM_977 n_I2259 n_I2251 VSS VSS nfet_05v0 L=0.6U W=0.36U AS=0.1584P AD=0.0936P
+ PS=1.6U PD=0.88U
* device instance _978 m90 *1 667.8,795.86 nfet_05v0
XM_978 VSS n_I2214 n_I2259 VSS nfet_05v0 L=0.6U W=0.36U AS=0.0936P AD=0.0936P
+ PS=0.88U PD=0.88U
* device instance _979 m90 *1 666.68,795.86 nfet_05v0
XM_979 n_I2259 n_I2242 VSS VSS nfet_05v0 L=0.6U W=0.36U AS=0.0936P AD=0.0936P
+ PS=0.88U PD=0.88U
* device instance _980 m90 *1 665.56,795.86 nfet_05v0
XM_980 VSS n_I2139 n_I2259 VSS nfet_05v0 L=0.6U W=0.36U AS=0.0936P AD=0.1584P
+ PS=0.88U PD=1.6U
* device instance _981 m90 *1 577.03,821.69 pfet_05v0
XM_981 n_I2923 n_I2402 VDD_DEC VDD_DEC pfet_05v0 L=0.5U W=1.22U AS=0.5368P
+ AD=0.3172P PS=3.32U PD=1.74U
* device instance _982 m90 *1 576.01,821.69 pfet_05v0
XM_982 n_I2922 n_I2211 n_I2923 VDD_DEC pfet_05v0 L=0.5U W=1.22U AS=0.3172P
+ AD=0.3782P PS=1.74U PD=1.84U
* device instance _983 m90 *1 574.89,821.69 pfet_05v0
XM_983 n_I2921 n_I2210 n_I2922 VDD_DEC pfet_05v0 L=0.5U W=1.22U AS=0.3782P
+ AD=0.3782P PS=1.84U PD=1.84U
* device instance _984 m90 *1 573.77,821.69 pfet_05v0
XM_984 n_I2282 n_I2236 n_I2921 VDD_DEC pfet_05v0 L=0.5U W=1.22U AS=0.3782P
+ AD=0.5368P PS=1.84U PD=3.32U
* device instance _985 m90 *1 577.08,819.38 nfet_05v0
XM_985 n_I2282 n_I2402 VSS VSS nfet_05v0 L=0.6U W=0.36U AS=0.1584P AD=0.0936P
+ PS=1.6U PD=0.88U
* device instance _986 m90 *1 575.96,819.38 nfet_05v0
XM_986 VSS n_I2211 n_I2282 VSS nfet_05v0 L=0.6U W=0.36U AS=0.0936P AD=0.0936P
+ PS=0.88U PD=0.88U
* device instance _987 m90 *1 574.84,819.38 nfet_05v0
XM_987 n_I2282 n_I2210 VSS VSS nfet_05v0 L=0.6U W=0.36U AS=0.0936P AD=0.0936P
+ PS=0.88U PD=0.88U
* device instance _988 m90 *1 573.72,819.38 nfet_05v0
XM_988 VSS n_I2236 n_I2282 VSS nfet_05v0 L=0.6U W=0.36U AS=0.0936P AD=0.1584P
+ PS=0.88U PD=1.6U
* device instance _989 m90 *1 523.27,813.85 pfet_05v0
XM_989 n_I2926 n_I2380 VDD_DEC VDD_DEC pfet_05v0 L=0.5U W=1.22U AS=0.5368P
+ AD=0.3172P PS=3.32U PD=1.74U
* device instance _990 m90 *1 522.25,813.85 pfet_05v0
XM_990 n_I2925 n_I2199 n_I2926 VDD_DEC pfet_05v0 L=0.5U W=1.22U AS=0.3172P
+ AD=0.3782P PS=1.74U PD=1.84U
* device instance _991 m90 *1 521.13,813.85 pfet_05v0
XM_991 n_I2924 n_I2248 n_I2925 VDD_DEC pfet_05v0 L=0.5U W=1.22U AS=0.3782P
+ AD=0.3782P PS=1.84U PD=1.84U
* device instance _992 m90 *1 520.01,813.85 pfet_05v0
XM_992 n_I2053 n_I2200 n_I2924 VDD_DEC pfet_05v0 L=0.5U W=1.22U AS=0.3782P
+ AD=0.5368P PS=1.84U PD=3.32U
* device instance _993 m90 *1 523.32,811.54 nfet_05v0
XM_993 n_I2053 n_I2380 VSS VSS nfet_05v0 L=0.6U W=0.36U AS=0.1584P AD=0.0936P
+ PS=1.6U PD=0.88U
* device instance _994 m90 *1 522.2,811.54 nfet_05v0
XM_994 VSS n_I2199 n_I2053 VSS nfet_05v0 L=0.6U W=0.36U AS=0.0936P AD=0.0936P
+ PS=0.88U PD=0.88U
* device instance _995 m90 *1 521.08,811.54 nfet_05v0
XM_995 n_I2053 n_I2248 VSS VSS nfet_05v0 L=0.6U W=0.36U AS=0.0936P AD=0.0936P
+ PS=0.88U PD=0.88U
* device instance _996 m90 *1 519.96,811.54 nfet_05v0
XM_996 VSS n_I2200 n_I2053 VSS nfet_05v0 L=0.6U W=0.36U AS=0.0936P AD=0.1584P
+ PS=0.88U PD=1.6U
* device instance _997 m0 *1 593.53,807.91 pfet_05v0
XM_997 n_I2929 n_I2360 VDD_DEC VDD_DEC pfet_05v0 L=0.5U W=1.22U AS=0.5368P
+ AD=0.3172P PS=3.32U PD=1.74U
* device instance _998 m0 *1 594.55,807.91 pfet_05v0
XM_998 n_I2928 n_I2211 n_I2929 VDD_DEC pfet_05v0 L=0.5U W=1.22U AS=0.3172P
+ AD=0.3782P PS=1.74U PD=1.84U
* device instance _999 m0 *1 595.67,807.91 pfet_05v0
XM_999 n_I2927 n_I2242 n_I2928 VDD_DEC pfet_05v0 L=0.5U W=1.22U AS=0.3782P
+ AD=0.3782P PS=1.84U PD=1.84U
* device instance _1000 m0 *1 596.79,807.91 pfet_05v0
XM_1000 n_I2254 n_I2239 n_I2927 VDD_DEC pfet_05v0 L=0.5U W=1.22U AS=0.3782P
+ AD=0.5368P PS=1.84U PD=3.32U
* device instance _1001 m0 *1 593.48,810.22 nfet_05v0
XM_1001 n_I2254 n_I2360 VSS VSS nfet_05v0 L=0.6U W=0.36U AS=0.1584P AD=0.0936P
+ PS=1.6U PD=0.88U
* device instance _1002 m0 *1 594.6,810.22 nfet_05v0
XM_1002 VSS n_I2211 n_I2254 VSS nfet_05v0 L=0.6U W=0.36U AS=0.0936P AD=0.0936P
+ PS=0.88U PD=0.88U
* device instance _1003 m0 *1 595.72,810.22 nfet_05v0
XM_1003 n_I2254 n_I2242 VSS VSS nfet_05v0 L=0.6U W=0.36U AS=0.0936P AD=0.0936P
+ PS=0.88U PD=0.88U
* device instance _1004 m0 *1 596.84,810.22 nfet_05v0
XM_1004 VSS n_I2239 n_I2254 VSS nfet_05v0 L=0.6U W=0.36U AS=0.0936P AD=0.1584P
+ PS=0.88U PD=1.6U
* device instance _1005 m0 *1 545.37,831.43 pfet_05v0
XM_1005 n_I2932 n_I2165 VDD_DEC VDD_DEC pfet_05v0 L=0.5U W=1.22U AS=0.5368P
+ AD=0.3172P PS=3.32U PD=1.74U
* device instance _1006 m0 *1 546.39,831.43 pfet_05v0
XM_1006 n_I2931 n_I2416 n_I2932 VDD_DEC pfet_05v0 L=0.5U W=1.22U AS=0.3172P
+ AD=0.3782P PS=1.74U PD=1.84U
* device instance _1007 m0 *1 547.51,831.43 pfet_05v0
XM_1007 n_I2930 n_I2333 n_I2931 VDD_DEC pfet_05v0 L=0.5U W=1.22U AS=0.3782P
+ AD=0.3782P PS=1.84U PD=1.84U
* device instance _1008 m0 *1 548.63,831.43 pfet_05v0
XM_1008 n_I2278 n_I2359 n_I2930 VDD_DEC pfet_05v0 L=0.5U W=1.22U AS=0.3782P
+ AD=0.5368P PS=1.84U PD=3.32U
* device instance _1009 m0 *1 545.32,833.74 nfet_05v0
XM_1009 n_I2278 n_I2165 VSS VSS nfet_05v0 L=0.6U W=0.36U AS=0.1584P AD=0.0936P
+ PS=1.6U PD=0.88U
* device instance _1010 m0 *1 546.44,833.74 nfet_05v0
XM_1010 VSS n_I2416 n_I2278 VSS nfet_05v0 L=0.6U W=0.36U AS=0.0936P AD=0.0936P
+ PS=0.88U PD=0.88U
* device instance _1011 m0 *1 547.56,833.74 nfet_05v0
XM_1011 n_I2278 n_I2333 VSS VSS nfet_05v0 L=0.6U W=0.36U AS=0.0936P AD=0.0936P
+ PS=0.88U PD=0.88U
* device instance _1012 m0 *1 548.68,833.74 nfet_05v0
XM_1012 VSS n_I2359 n_I2278 VSS nfet_05v0 L=0.6U W=0.36U AS=0.0936P AD=0.1584P
+ PS=0.88U PD=1.6U
* device instance _1013 m0 *1 636.09,823.59 pfet_05v0
XM_1013 n_I2935 n_I2251 VDD_DEC VDD_DEC pfet_05v0 L=0.5U W=1.22U AS=0.5368P
+ AD=0.3172P PS=3.32U PD=1.74U
* device instance _1014 m0 *1 637.11,823.59 pfet_05v0
XM_1014 n_I2934 n_I2214 n_I2935 VDD_DEC pfet_05v0 L=0.5U W=1.22U AS=0.3172P
+ AD=0.3782P PS=1.74U PD=1.84U
* device instance _1015 m0 *1 638.23,823.59 pfet_05v0
XM_1015 n_I2933 n_I2341 n_I2934 VDD_DEC pfet_05v0 L=0.5U W=1.22U AS=0.3782P
+ AD=0.3782P PS=1.84U PD=1.84U
* device instance _1016 m0 *1 639.35,823.59 pfet_05v0
XM_1016 n_I2168 n_I2139 n_I2933 VDD_DEC pfet_05v0 L=0.5U W=1.22U AS=0.3782P
+ AD=0.5368P PS=1.84U PD=3.32U
* device instance _1017 m0 *1 636.04,825.9 nfet_05v0
XM_1017 n_I2168 n_I2251 VSS VSS nfet_05v0 L=0.6U W=0.36U AS=0.1584P AD=0.0936P
+ PS=1.6U PD=0.88U
* device instance _1018 m0 *1 637.16,825.9 nfet_05v0
XM_1018 VSS n_I2214 n_I2168 VSS nfet_05v0 L=0.6U W=0.36U AS=0.0936P AD=0.0936P
+ PS=0.88U PD=0.88U
* device instance _1019 m0 *1 638.28,825.9 nfet_05v0
XM_1019 n_I2168 n_I2341 VSS VSS nfet_05v0 L=0.6U W=0.36U AS=0.0936P AD=0.0936P
+ PS=0.88U PD=0.88U
* device instance _1020 m0 *1 639.4,825.9 nfet_05v0
XM_1020 VSS n_I2139 n_I2168 VSS nfet_05v0 L=0.6U W=0.36U AS=0.0936P AD=0.1584P
+ PS=0.88U PD=1.6U
* device instance _1021 m0 *1 628.81,815.75 pfet_05v0
XM_1021 n_I2938 n_I2357 VDD_DEC VDD_DEC pfet_05v0 L=0.5U W=1.22U AS=0.5368P
+ AD=0.3172P PS=3.32U PD=1.74U
* device instance _1022 m0 *1 629.83,815.75 pfet_05v0
XM_1022 n_I2937 n_I2214 n_I2938 VDD_DEC pfet_05v0 L=0.5U W=1.22U AS=0.3172P
+ AD=0.3782P PS=1.74U PD=1.84U
* device instance _1023 m0 *1 630.95,815.75 pfet_05v0
XM_1023 n_I2936 n_I2341 n_I2937 VDD_DEC pfet_05v0 L=0.5U W=1.22U AS=0.3782P
+ AD=0.3782P PS=1.84U PD=1.84U
* device instance _1024 m0 *1 632.07,815.75 pfet_05v0
XM_1024 n_I2343 n_I2139 n_I2936 VDD_DEC pfet_05v0 L=0.5U W=1.22U AS=0.3782P
+ AD=0.5368P PS=1.84U PD=3.32U
* device instance _1025 m0 *1 628.76,818.06 nfet_05v0
XM_1025 n_I2343 n_I2357 VSS VSS nfet_05v0 L=0.6U W=0.36U AS=0.1584P AD=0.0936P
+ PS=1.6U PD=0.88U
* device instance _1026 m0 *1 629.88,818.06 nfet_05v0
XM_1026 VSS n_I2214 n_I2343 VSS nfet_05v0 L=0.6U W=0.36U AS=0.0936P AD=0.0936P
+ PS=0.88U PD=0.88U
* device instance _1027 m0 *1 631,818.06 nfet_05v0
XM_1027 n_I2343 n_I2341 VSS VSS nfet_05v0 L=0.6U W=0.36U AS=0.0936P AD=0.0936P
+ PS=0.88U PD=0.88U
* device instance _1028 m0 *1 632.12,818.06 nfet_05v0
XM_1028 VSS n_I2139 n_I2343 VSS nfet_05v0 L=0.6U W=0.36U AS=0.0936P AD=0.1584P
+ PS=0.88U PD=1.6U
* device instance _1029 m0 *1 497.77,800.07 pfet_05v0
XM_1029 n_I2941 n_I2246 VDD_DEC VDD_DEC pfet_05v0 L=0.5U W=1.22U AS=0.5368P
+ AD=0.3172P PS=3.32U PD=1.74U
* device instance _1030 m0 *1 498.79,800.07 pfet_05v0
XM_1030 n_I2940 n_I2196 n_I2941 VDD_DEC pfet_05v0 L=0.5U W=1.22U AS=0.3172P
+ AD=0.3782P PS=1.74U PD=1.84U
* device instance _1031 m0 *1 499.91,800.07 pfet_05v0
XM_1031 n_I2939 n_I2248 n_I2940 VDD_DEC pfet_05v0 L=0.5U W=1.22U AS=0.3782P
+ AD=0.3782P PS=1.84U PD=1.84U
* device instance _1032 m0 *1 501.03,800.07 pfet_05v0
XM_1032 n_I2272 n_I2200 n_I2939 VDD_DEC pfet_05v0 L=0.5U W=1.22U AS=0.3782P
+ AD=0.5368P PS=1.84U PD=3.32U
* device instance _1033 m0 *1 497.72,802.38 nfet_05v0
XM_1033 n_I2272 n_I2246 VSS VSS nfet_05v0 L=0.6U W=0.36U AS=0.1584P AD=0.0936P
+ PS=1.6U PD=0.88U
* device instance _1034 m0 *1 498.84,802.38 nfet_05v0
XM_1034 VSS n_I2196 n_I2272 VSS nfet_05v0 L=0.6U W=0.36U AS=0.0936P AD=0.0936P
+ PS=0.88U PD=0.88U
* device instance _1035 m0 *1 499.96,802.38 nfet_05v0
XM_1035 n_I2272 n_I2248 VSS VSS nfet_05v0 L=0.6U W=0.36U AS=0.0936P AD=0.0936P
+ PS=0.88U PD=0.88U
* device instance _1036 m0 *1 501.08,802.38 nfet_05v0
XM_1036 VSS n_I2200 n_I2272 VSS nfet_05v0 L=0.6U W=0.36U AS=0.0936P AD=0.1584P
+ PS=0.88U PD=1.6U
* device instance _1037 m0 *1 503.37,800.07 pfet_05v0
XM_1037 n_I2944 n_I2231 VDD_DEC VDD_DEC pfet_05v0 L=0.5U W=1.22U AS=0.5368P
+ AD=0.3172P PS=3.32U PD=1.74U
* device instance _1038 m0 *1 504.39,800.07 pfet_05v0
XM_1038 n_I2943 n_I2199 n_I2944 VDD_DEC pfet_05v0 L=0.5U W=1.22U AS=0.3172P
+ AD=0.3782P PS=1.74U PD=1.84U
* device instance _1039 m0 *1 505.51,800.07 pfet_05v0
XM_1039 n_I2942 n_I2250 n_I2943 VDD_DEC pfet_05v0 L=0.5U W=1.22U AS=0.3782P
+ AD=0.3782P PS=1.84U PD=1.84U
* device instance _1040 m0 *1 506.63,800.07 pfet_05v0
XM_1040 n_I2273 n_I2200 n_I2942 VDD_DEC pfet_05v0 L=0.5U W=1.22U AS=0.3782P
+ AD=0.5368P PS=1.84U PD=3.32U
* device instance _1041 m0 *1 503.32,802.38 nfet_05v0
XM_1041 n_I2273 n_I2231 VSS VSS nfet_05v0 L=0.6U W=0.36U AS=0.1584P AD=0.0936P
+ PS=1.6U PD=0.88U
* device instance _1042 m0 *1 504.44,802.38 nfet_05v0
XM_1042 VSS n_I2199 n_I2273 VSS nfet_05v0 L=0.6U W=0.36U AS=0.0936P AD=0.0936P
+ PS=0.88U PD=0.88U
* device instance _1043 m0 *1 505.56,802.38 nfet_05v0
XM_1043 n_I2273 n_I2250 VSS VSS nfet_05v0 L=0.6U W=0.36U AS=0.0936P AD=0.0936P
+ PS=0.88U PD=0.88U
* device instance _1044 m0 *1 506.68,802.38 nfet_05v0
XM_1044 VSS n_I2200 n_I2273 VSS nfet_05v0 L=0.6U W=0.36U AS=0.0936P AD=0.1584P
+ PS=0.88U PD=1.6U
* device instance _1045 m0 *1 590.73,792.23 pfet_05v0
XM_1045 n_I2947 n_I2237 VDD_DEC VDD_DEC pfet_05v0 L=0.5U W=1.22U AS=0.5368P
+ AD=0.3172P PS=3.32U PD=1.74U
* device instance _1046 m0 *1 591.75,792.23 pfet_05v0
XM_1046 n_I2946 n_I2211 n_I2947 VDD_DEC pfet_05v0 L=0.5U W=1.22U AS=0.3172P
+ AD=0.3782P PS=1.74U PD=1.84U
* device instance _1047 m0 *1 592.87,792.23 pfet_05v0
XM_1047 n_I2945 n_I2210 n_I2946 VDD_DEC pfet_05v0 L=0.5U W=1.22U AS=0.3782P
+ AD=0.3782P PS=1.84U PD=1.84U
* device instance _1048 m0 *1 593.99,792.23 pfet_05v0
XM_1048 n_I2071 n_I2171 n_I2945 VDD_DEC pfet_05v0 L=0.5U W=1.22U AS=0.3782P
+ AD=0.5368P PS=1.84U PD=3.32U
* device instance _1049 m0 *1 590.68,794.54 nfet_05v0
XM_1049 n_I2071 n_I2237 VSS VSS nfet_05v0 L=0.6U W=0.36U AS=0.1584P AD=0.0936P
+ PS=1.6U PD=0.88U
* device instance _1050 m0 *1 591.8,794.54 nfet_05v0
XM_1050 VSS n_I2211 n_I2071 VSS nfet_05v0 L=0.6U W=0.36U AS=0.0936P AD=0.0936P
+ PS=0.88U PD=0.88U
* device instance _1051 m0 *1 592.92,794.54 nfet_05v0
XM_1051 n_I2071 n_I2210 VSS VSS nfet_05v0 L=0.6U W=0.36U AS=0.0936P AD=0.0936P
+ PS=0.88U PD=0.88U
* device instance _1052 m0 *1 594.04,794.54 nfet_05v0
XM_1052 VSS n_I2171 n_I2071 VSS nfet_05v0 L=0.6U W=0.36U AS=0.0936P AD=0.1584P
+ PS=0.88U PD=1.6U
* device instance _1053 m0 *1 630.49,823.59 pfet_05v0
XM_1053 n_I2950 n_I2208 VDD_DEC VDD_DEC pfet_05v0 L=0.5U W=1.22U AS=0.5368P
+ AD=0.3172P PS=3.32U PD=1.74U
* device instance _1054 m0 *1 631.51,823.59 pfet_05v0
XM_1054 n_I2949 n_I2140 n_I2950 VDD_DEC pfet_05v0 L=0.5U W=1.22U AS=0.3172P
+ AD=0.3782P PS=1.74U PD=1.84U
* device instance _1055 m0 *1 632.63,823.59 pfet_05v0
XM_1055 n_I2948 n_I2178 n_I2949 VDD_DEC pfet_05v0 L=0.5U W=1.22U AS=0.3782P
+ AD=0.3782P PS=1.84U PD=1.84U
* device instance _1056 m0 *1 633.75,823.59 pfet_05v0
XM_1056 n_I2215 n_I2138 n_I2948 VDD_DEC pfet_05v0 L=0.5U W=1.22U AS=0.3782P
+ AD=0.5368P PS=1.84U PD=3.32U
* device instance _1057 m0 *1 630.44,825.9 nfet_05v0
XM_1057 n_I2215 n_I2208 VSS VSS nfet_05v0 L=0.6U W=0.36U AS=0.1584P AD=0.0936P
+ PS=1.6U PD=0.88U
* device instance _1058 m0 *1 631.56,825.9 nfet_05v0
XM_1058 VSS n_I2140 n_I2215 VSS nfet_05v0 L=0.6U W=0.36U AS=0.0936P AD=0.0936P
+ PS=0.88U PD=0.88U
* device instance _1059 m0 *1 632.68,825.9 nfet_05v0
XM_1059 n_I2215 n_I2178 VSS VSS nfet_05v0 L=0.6U W=0.36U AS=0.0936P AD=0.0936P
+ PS=0.88U PD=0.88U
* device instance _1060 m0 *1 633.8,825.9 nfet_05v0
XM_1060 VSS n_I2138 n_I2215 VSS nfet_05v0 L=0.6U W=0.36U AS=0.0936P AD=0.1584P
+ PS=0.88U PD=1.6U
* device instance _1061 m0 *1 608.65,800.07 pfet_05v0
XM_1061 n_I2953 n_I2204 VDD_DEC VDD_DEC pfet_05v0 L=0.5U W=1.22U AS=0.5368P
+ AD=0.3172P PS=3.32U PD=1.74U
* device instance _1062 m0 *1 609.67,800.07 pfet_05v0
XM_1062 n_I2952 n_I2285 n_I2953 VDD_DEC pfet_05v0 L=0.5U W=1.22U AS=0.3172P
+ AD=0.3782P PS=1.74U PD=1.84U
* device instance _1063 m0 *1 610.79,800.07 pfet_05v0
XM_1063 n_I2951 n_I2242 n_I2952 VDD_DEC pfet_05v0 L=0.5U W=1.22U AS=0.3782P
+ AD=0.3782P PS=1.84U PD=1.84U
* device instance _1064 m0 *1 611.91,800.07 pfet_05v0
XM_1064 n_I2243 n_I2213 n_I2951 VDD_DEC pfet_05v0 L=0.5U W=1.22U AS=0.3782P
+ AD=0.5368P PS=1.84U PD=3.32U
* device instance _1065 m0 *1 608.6,802.38 nfet_05v0
XM_1065 n_I2243 n_I2204 VSS VSS nfet_05v0 L=0.6U W=0.36U AS=0.1584P AD=0.0936P
+ PS=1.6U PD=0.88U
* device instance _1066 m0 *1 609.72,802.38 nfet_05v0
XM_1066 VSS n_I2285 n_I2243 VSS nfet_05v0 L=0.6U W=0.36U AS=0.0936P AD=0.0936P
+ PS=0.88U PD=0.88U
* device instance _1067 m0 *1 610.84,802.38 nfet_05v0
XM_1067 n_I2243 n_I2242 VSS VSS nfet_05v0 L=0.6U W=0.36U AS=0.0936P AD=0.0936P
+ PS=0.88U PD=0.88U
* device instance _1068 m0 *1 611.96,802.38 nfet_05v0
XM_1068 VSS n_I2213 n_I2243 VSS nfet_05v0 L=0.6U W=0.36U AS=0.0936P AD=0.1584P
+ PS=0.88U PD=1.6U
* device instance _1069 m0 *1 587.37,800.07 pfet_05v0
XM_1069 n_I2956 n_I2274 VDD_DEC VDD_DEC pfet_05v0 L=0.5U W=1.22U AS=0.5368P
+ AD=0.3172P PS=3.32U PD=1.74U
* device instance _1070 m0 *1 588.39,800.07 pfet_05v0
XM_1070 n_I2955 n_I2172 n_I2956 VDD_DEC pfet_05v0 L=0.5U W=1.22U AS=0.3172P
+ AD=0.3782P PS=1.74U PD=1.84U
* device instance _1071 m0 *1 589.51,800.07 pfet_05v0
XM_1071 n_I2954 n_I2210 n_I2955 VDD_DEC pfet_05v0 L=0.5U W=1.22U AS=0.3782P
+ AD=0.3782P PS=1.84U PD=1.84U
* device instance _1072 m0 *1 590.63,800.07 pfet_05v0
XM_1072 n_I2253 n_I2171 n_I2954 VDD_DEC pfet_05v0 L=0.5U W=1.22U AS=0.3782P
+ AD=0.5368P PS=1.84U PD=3.32U
* device instance _1073 m0 *1 587.32,802.38 nfet_05v0
XM_1073 n_I2253 n_I2274 VSS VSS nfet_05v0 L=0.6U W=0.36U AS=0.1584P AD=0.0936P
+ PS=1.6U PD=0.88U
* device instance _1074 m0 *1 588.44,802.38 nfet_05v0
XM_1074 VSS n_I2172 n_I2253 VSS nfet_05v0 L=0.6U W=0.36U AS=0.0936P AD=0.0936P
+ PS=0.88U PD=0.88U
* device instance _1075 m0 *1 589.56,802.38 nfet_05v0
XM_1075 n_I2253 n_I2210 VSS VSS nfet_05v0 L=0.6U W=0.36U AS=0.0936P AD=0.0936P
+ PS=0.88U PD=0.88U
* device instance _1076 m0 *1 590.68,802.38 nfet_05v0
XM_1076 VSS n_I2171 n_I2253 VSS nfet_05v0 L=0.6U W=0.36U AS=0.0936P AD=0.1584P
+ PS=0.88U PD=1.6U
* device instance _1077 m0 *1 664.65,784.39 pfet_05v0
XM_1077 n_I2959 n_I2237 VDD_DEC VDD_DEC pfet_05v0 L=0.5U W=1.22U AS=0.5368P
+ AD=0.3172P PS=3.32U PD=1.74U
* device instance _1078 m0 *1 665.67,784.39 pfet_05v0
XM_1078 n_I2958 n_I2140 n_I2959 VDD_DEC pfet_05v0 L=0.5U W=1.22U AS=0.3172P
+ AD=0.3782P PS=1.74U PD=1.84U
* device instance _1079 m0 *1 666.79,784.39 pfet_05v0
XM_1079 n_I2957 n_I2287 n_I2958 VDD_DEC pfet_05v0 L=0.5U W=1.22U AS=0.3782P
+ AD=0.3782P PS=1.84U PD=1.84U
* device instance _1080 m0 *1 667.91,784.39 pfet_05v0
XM_1080 n_I2081 n_I2138 n_I2957 VDD_DEC pfet_05v0 L=0.5U W=1.22U AS=0.3782P
+ AD=0.5368P PS=1.84U PD=3.32U
* device instance _1081 m0 *1 664.6,786.7 nfet_05v0
XM_1081 n_I2081 n_I2237 VSS VSS nfet_05v0 L=0.6U W=0.36U AS=0.1584P AD=0.0936P
+ PS=1.6U PD=0.88U
* device instance _1082 m0 *1 665.72,786.7 nfet_05v0
XM_1082 VSS n_I2140 n_I2081 VSS nfet_05v0 L=0.6U W=0.36U AS=0.0936P AD=0.0936P
+ PS=0.88U PD=0.88U
* device instance _1083 m0 *1 666.84,786.7 nfet_05v0
XM_1083 n_I2081 n_I2287 VSS VSS nfet_05v0 L=0.6U W=0.36U AS=0.0936P AD=0.0936P
+ PS=0.88U PD=0.88U
* device instance _1084 m0 *1 667.96,786.7 nfet_05v0
XM_1084 VSS n_I2138 n_I2081 VSS nfet_05v0 L=0.6U W=0.36U AS=0.0936P AD=0.1584P
+ PS=0.88U PD=1.6U
* device instance _1085 m0 *1 575.05,807.91 pfet_05v0
XM_1085 n_I2962 n_I2237 VDD_DEC VDD_DEC pfet_05v0 L=0.5U W=1.22U AS=0.5368P
+ AD=0.3172P PS=3.32U PD=1.74U
* device instance _1086 m0 *1 576.07,807.91 pfet_05v0
XM_1086 n_I2961 n_I2206 n_I2962 VDD_DEC pfet_05v0 L=0.5U W=1.22U AS=0.3172P
+ AD=0.3782P PS=1.74U PD=1.84U
* device instance _1087 m0 *1 577.19,807.91 pfet_05v0
XM_1087 n_I2960 n_I2207 n_I2961 VDD_DEC pfet_05v0 L=0.5U W=1.22U AS=0.3782P
+ AD=0.3782P PS=1.84U PD=1.84U
* device instance _1088 m0 *1 578.31,807.91 pfet_05v0
XM_1088 n_I2170 n_I2236 n_I2960 VDD_DEC pfet_05v0 L=0.5U W=1.22U AS=0.3782P
+ AD=0.5368P PS=1.84U PD=3.32U
* device instance _1089 m0 *1 575,810.22 nfet_05v0
XM_1089 n_I2170 n_I2237 VSS VSS nfet_05v0 L=0.6U W=0.36U AS=0.1584P AD=0.0936P
+ PS=1.6U PD=0.88U
* device instance _1090 m0 *1 576.12,810.22 nfet_05v0
XM_1090 VSS n_I2206 n_I2170 VSS nfet_05v0 L=0.6U W=0.36U AS=0.0936P AD=0.0936P
+ PS=0.88U PD=0.88U
* device instance _1091 m0 *1 577.24,810.22 nfet_05v0
XM_1091 n_I2170 n_I2207 VSS VSS nfet_05v0 L=0.6U W=0.36U AS=0.0936P AD=0.0936P
+ PS=0.88U PD=0.88U
* device instance _1092 m0 *1 578.36,810.22 nfet_05v0
XM_1092 VSS n_I2236 n_I2170 VSS nfet_05v0 L=0.6U W=0.36U AS=0.0936P AD=0.1584P
+ PS=0.88U PD=1.6U
* device instance _1093 m0 *1 623.21,823.59 pfet_05v0
XM_1093 n_I2965 n_I2165 VDD_DEC VDD_DEC pfet_05v0 L=0.5U W=1.22U AS=0.5368P
+ AD=0.3172P PS=3.32U PD=1.74U
* device instance _1094 m0 *1 624.23,823.59 pfet_05v0
XM_1094 n_I2964 n_I2140 n_I2965 VDD_DEC pfet_05v0 L=0.5U W=1.22U AS=0.3172P
+ AD=0.3782P PS=1.74U PD=1.84U
* device instance _1095 m0 *1 625.35,823.59 pfet_05v0
XM_1095 n_I2963 n_I2287 n_I2964 VDD_DEC pfet_05v0 L=0.5U W=1.22U AS=0.3782P
+ AD=0.3782P PS=1.84U PD=1.84U
* device instance _1096 m0 *1 626.47,823.59 pfet_05v0
XM_1096 n_I2030 n_I2138 n_I2963 VDD_DEC pfet_05v0 L=0.5U W=1.22U AS=0.3782P
+ AD=0.5368P PS=1.84U PD=3.32U
* device instance _1097 m0 *1 623.16,825.9 nfet_05v0
XM_1097 n_I2030 n_I2165 VSS VSS nfet_05v0 L=0.6U W=0.36U AS=0.1584P AD=0.0936P
+ PS=1.6U PD=0.88U
* device instance _1098 m0 *1 624.28,825.9 nfet_05v0
XM_1098 VSS n_I2140 n_I2030 VSS nfet_05v0 L=0.6U W=0.36U AS=0.0936P AD=0.0936P
+ PS=0.88U PD=0.88U
* device instance _1099 m0 *1 625.4,825.9 nfet_05v0
XM_1099 n_I2030 n_I2287 VSS VSS nfet_05v0 L=0.6U W=0.36U AS=0.0936P AD=0.0936P
+ PS=0.88U PD=0.88U
* device instance _1100 m0 *1 626.52,825.9 nfet_05v0
XM_1100 VSS n_I2138 n_I2030 VSS nfet_05v0 L=0.6U W=0.36U AS=0.0936P AD=0.1584P
+ PS=0.88U PD=1.6U
* device instance _1101 m0 *1 580.65,807.91 pfet_05v0
XM_1101 n_I2968 n_I2360 VDD_DEC VDD_DEC pfet_05v0 L=0.5U W=1.22U AS=0.5368P
+ AD=0.3172P PS=3.32U PD=1.74U
* device instance _1102 m0 *1 581.67,807.91 pfet_05v0
XM_1102 n_I2967 n_I2172 n_I2968 VDD_DEC pfet_05v0 L=0.5U W=1.22U AS=0.3172P
+ AD=0.3782P PS=1.74U PD=1.84U
* device instance _1103 m0 *1 582.79,807.91 pfet_05v0
XM_1103 n_I2966 n_I2210 n_I2967 VDD_DEC pfet_05v0 L=0.5U W=1.22U AS=0.3782P
+ AD=0.3782P PS=1.84U PD=1.84U
* device instance _1104 m0 *1 583.91,807.91 pfet_05v0
XM_1104 n_I2066 n_I2171 n_I2966 VDD_DEC pfet_05v0 L=0.5U W=1.22U AS=0.3782P
+ AD=0.5368P PS=1.84U PD=3.32U
* device instance _1105 m0 *1 580.6,810.22 nfet_05v0
XM_1105 n_I2066 n_I2360 VSS VSS nfet_05v0 L=0.6U W=0.36U AS=0.1584P AD=0.0936P
+ PS=1.6U PD=0.88U
* device instance _1106 m0 *1 581.72,810.22 nfet_05v0
XM_1106 VSS n_I2172 n_I2066 VSS nfet_05v0 L=0.6U W=0.36U AS=0.0936P AD=0.0936P
+ PS=0.88U PD=0.88U
* device instance _1107 m0 *1 582.84,810.22 nfet_05v0
XM_1107 n_I2066 n_I2210 VSS VSS nfet_05v0 L=0.6U W=0.36U AS=0.0936P AD=0.0936P
+ PS=0.88U PD=0.88U
* device instance _1108 m0 *1 583.96,810.22 nfet_05v0
XM_1108 VSS n_I2171 n_I2066 VSS nfet_05v0 L=0.6U W=0.36U AS=0.0936P AD=0.1584P
+ PS=0.88U PD=1.6U
* device instance _1109 m0 *1 614.25,800.07 pfet_05v0
XM_1109 n_I2971 n_I2198 VDD_DEC VDD_DEC pfet_05v0 L=0.5U W=1.22U AS=0.5368P
+ AD=0.3172P PS=3.32U PD=1.74U
* device instance _1110 m0 *1 615.27,800.07 pfet_05v0
XM_1110 n_I2970 n_I2286 n_I2971 VDD_DEC pfet_05v0 L=0.5U W=1.22U AS=0.3172P
+ AD=0.3782P PS=1.74U PD=1.84U
* device instance _1111 m0 *1 616.39,800.07 pfet_05v0
XM_1111 n_I2969 n_I2287 n_I2970 VDD_DEC pfet_05v0 L=0.5U W=1.22U AS=0.3782P
+ AD=0.3782P PS=1.84U PD=1.84U
* device instance _1112 m0 *1 617.51,800.07 pfet_05v0
XM_1112 n_I2074 n_I2213 n_I2969 VDD_DEC pfet_05v0 L=0.5U W=1.22U AS=0.3782P
+ AD=0.5368P PS=1.84U PD=3.32U
* device instance _1113 m0 *1 614.2,802.38 nfet_05v0
XM_1113 n_I2074 n_I2198 VSS VSS nfet_05v0 L=0.6U W=0.36U AS=0.1584P AD=0.0936P
+ PS=1.6U PD=0.88U
* device instance _1114 m0 *1 615.32,802.38 nfet_05v0
XM_1114 VSS n_I2286 n_I2074 VSS nfet_05v0 L=0.6U W=0.36U AS=0.0936P AD=0.0936P
+ PS=0.88U PD=0.88U
* device instance _1115 m0 *1 616.44,802.38 nfet_05v0
XM_1115 n_I2074 n_I2287 VSS VSS nfet_05v0 L=0.6U W=0.36U AS=0.0936P AD=0.0936P
+ PS=0.88U PD=0.88U
* device instance _1116 m0 *1 617.56,802.38 nfet_05v0
XM_1116 VSS n_I2213 n_I2074 VSS nfet_05v0 L=0.6U W=0.36U AS=0.0936P AD=0.1584P
+ PS=0.88U PD=1.6U
* device instance _1117 r180 *1 554.63,831.43 pfet_05v0
XM_1117 n_I2974 n_I2274 VDD_DEC VDD_DEC pfet_05v0 L=0.5U W=1.22U AS=0.5368P
+ AD=0.3172P PS=3.32U PD=1.74U
* device instance _1118 r180 *1 553.61,831.43 pfet_05v0
XM_1118 n_I2973 n_I2416 n_I2974 VDD_DEC pfet_05v0 L=0.5U W=1.22U AS=0.3172P
+ AD=0.3782P PS=1.74U PD=1.84U
* device instance _1119 r180 *1 552.49,831.43 pfet_05v0
XM_1119 n_I2972 n_I2333 n_I2973 VDD_DEC pfet_05v0 L=0.5U W=1.22U AS=0.3782P
+ AD=0.3782P PS=1.84U PD=1.84U
* device instance _1120 r180 *1 551.37,831.43 pfet_05v0
XM_1120 n_I2205 n_I2359 n_I2972 VDD_DEC pfet_05v0 L=0.5U W=1.22U AS=0.3782P
+ AD=0.5368P PS=1.84U PD=3.32U
* device instance _1121 r180 *1 554.68,833.74 nfet_05v0
XM_1121 n_I2205 n_I2274 VSS VSS nfet_05v0 L=0.6U W=0.36U AS=0.1584P AD=0.0936P
+ PS=1.6U PD=0.88U
* device instance _1122 r180 *1 553.56,833.74 nfet_05v0
XM_1122 VSS n_I2416 n_I2205 VSS nfet_05v0 L=0.6U W=0.36U AS=0.0936P AD=0.0936P
+ PS=0.88U PD=0.88U
* device instance _1123 r180 *1 552.44,833.74 nfet_05v0
XM_1123 n_I2205 n_I2333 VSS VSS nfet_05v0 L=0.6U W=0.36U AS=0.0936P AD=0.0936P
+ PS=0.88U PD=0.88U
* device instance _1124 r180 *1 551.32,833.74 nfet_05v0
XM_1124 VSS n_I2359 n_I2205 VSS nfet_05v0 L=0.6U W=0.36U AS=0.0936P AD=0.1584P
+ PS=0.88U PD=1.6U
* device instance _1125 r180 *1 542.87,823.59 pfet_05v0
XM_1125 n_I2977 n_I2208 VDD_DEC VDD_DEC pfet_05v0 L=0.5U W=1.22U AS=0.5368P
+ AD=0.3172P PS=3.32U PD=1.74U
* device instance _1126 r180 *1 541.85,823.59 pfet_05v0
XM_1126 n_I2976 n_I2416 n_I2977 VDD_DEC pfet_05v0 L=0.5U W=1.22U AS=0.3172P
+ AD=0.3782P PS=1.74U PD=1.84U
* device instance _1127 r180 *1 540.73,823.59 pfet_05v0
XM_1127 n_I2975 n_I2333 n_I2976 VDD_DEC pfet_05v0 L=0.5U W=1.22U AS=0.3782P
+ AD=0.3782P PS=1.84U PD=1.84U
* device instance _1128 r180 *1 539.61,823.59 pfet_05v0
XM_1128 n_I2022 n_I2359 n_I2975 VDD_DEC pfet_05v0 L=0.5U W=1.22U AS=0.3782P
+ AD=0.5368P PS=1.84U PD=3.32U
* device instance _1129 r180 *1 542.92,825.9 nfet_05v0
XM_1129 n_I2022 n_I2208 VSS VSS nfet_05v0 L=0.6U W=0.36U AS=0.1584P AD=0.0936P
+ PS=1.6U PD=0.88U
* device instance _1130 r180 *1 541.8,825.9 nfet_05v0
XM_1130 VSS n_I2416 n_I2022 VSS nfet_05v0 L=0.6U W=0.36U AS=0.0936P AD=0.0936P
+ PS=0.88U PD=0.88U
* device instance _1131 r180 *1 540.68,825.9 nfet_05v0
XM_1131 n_I2022 n_I2333 VSS VSS nfet_05v0 L=0.6U W=0.36U AS=0.0936P AD=0.0936P
+ PS=0.88U PD=0.88U
* device instance _1132 r180 *1 539.56,825.9 nfet_05v0
XM_1132 VSS n_I2359 n_I2022 VSS nfet_05v0 L=0.6U W=0.36U AS=0.0936P AD=0.1584P
+ PS=0.88U PD=1.6U
* device instance _1133 r180 *1 495.83,800.07 pfet_05v0
XM_1133 n_I2980 n_I2330 VDD_DEC VDD_DEC pfet_05v0 L=0.5U W=1.22U AS=0.5368P
+ AD=0.3172P PS=3.32U PD=1.74U
* device instance _1134 r180 *1 494.81,800.07 pfet_05v0
XM_1134 n_I2979 n_I2196 n_I2980 VDD_DEC pfet_05v0 L=0.5U W=1.22U AS=0.3172P
+ AD=0.3782P PS=1.74U PD=1.84U
* device instance _1135 r180 *1 493.69,800.07 pfet_05v0
XM_1135 n_I2978 n_I2248 n_I2979 VDD_DEC pfet_05v0 L=0.5U W=1.22U AS=0.3782P
+ AD=0.3782P PS=1.84U PD=1.84U
* device instance _1136 r180 *1 492.57,800.07 pfet_05v0
XM_1136 n_I2052 n_I2195 n_I2978 VDD_DEC pfet_05v0 L=0.5U W=1.22U AS=0.3782P
+ AD=0.5368P PS=1.84U PD=3.32U
* device instance _1137 r180 *1 495.88,802.38 nfet_05v0
XM_1137 n_I2052 n_I2330 VSS VSS nfet_05v0 L=0.6U W=0.36U AS=0.1584P AD=0.0936P
+ PS=1.6U PD=0.88U
* device instance _1138 r180 *1 494.76,802.38 nfet_05v0
XM_1138 VSS n_I2196 n_I2052 VSS nfet_05v0 L=0.6U W=0.36U AS=0.0936P AD=0.0936P
+ PS=0.88U PD=0.88U
* device instance _1139 r180 *1 493.64,802.38 nfet_05v0
XM_1139 n_I2052 n_I2248 VSS VSS nfet_05v0 L=0.6U W=0.36U AS=0.0936P AD=0.0936P
+ PS=0.88U PD=0.88U
* device instance _1140 r180 *1 492.52,802.38 nfet_05v0
XM_1140 VSS n_I2195 n_I2052 VSS nfet_05v0 L=0.6U W=0.36U AS=0.0936P AD=0.1584P
+ PS=0.88U PD=1.6U
* device instance _1141 r180 *1 496.39,792.23 pfet_05v0
XM_1141 n_I2983 n_I2198 VDD_DEC VDD_DEC pfet_05v0 L=0.5U W=1.22U AS=0.5368P
+ AD=0.3172P PS=3.32U PD=1.74U
* device instance _1142 r180 *1 495.37,792.23 pfet_05v0
XM_1142 n_I2982 n_I2196 n_I2983 VDD_DEC pfet_05v0 L=0.5U W=1.22U AS=0.3172P
+ AD=0.3782P PS=1.74U PD=1.84U
* device instance _1143 r180 *1 494.25,792.23 pfet_05v0
XM_1143 n_I2981 n_I2248 n_I2982 VDD_DEC pfet_05v0 L=0.5U W=1.22U AS=0.3782P
+ AD=0.3782P PS=1.84U PD=1.84U
* device instance _1144 r180 *1 493.13,792.23 pfet_05v0
XM_1144 n_I2159 n_I2195 n_I2981 VDD_DEC pfet_05v0 L=0.5U W=1.22U AS=0.3782P
+ AD=0.5368P PS=1.84U PD=3.32U
* device instance _1145 r180 *1 496.44,794.54 nfet_05v0
XM_1145 n_I2159 n_I2198 VSS VSS nfet_05v0 L=0.6U W=0.36U AS=0.1584P AD=0.0936P
+ PS=1.6U PD=0.88U
* device instance _1146 r180 *1 495.32,794.54 nfet_05v0
XM_1146 VSS n_I2196 n_I2159 VSS nfet_05v0 L=0.6U W=0.36U AS=0.0936P AD=0.0936P
+ PS=0.88U PD=0.88U
* device instance _1147 r180 *1 494.2,794.54 nfet_05v0
XM_1147 n_I2159 n_I2248 VSS VSS nfet_05v0 L=0.6U W=0.36U AS=0.0936P AD=0.0936P
+ PS=0.88U PD=0.88U
* device instance _1148 r180 *1 493.08,794.54 nfet_05v0
XM_1148 VSS n_I2195 n_I2159 VSS nfet_05v0 L=0.6U W=0.36U AS=0.0936P AD=0.1584P
+ PS=0.88U PD=1.6U
* device instance _1149 r180 *1 573.67,792.23 pfet_05v0
XM_1149 n_I2986 n_I2204 VDD_DEC VDD_DEC pfet_05v0 L=0.5U W=1.22U AS=0.5368P
+ AD=0.3172P PS=3.32U PD=1.74U
* device instance _1150 r180 *1 572.65,792.23 pfet_05v0
XM_1150 n_I2985 n_I2206 n_I2986 VDD_DEC pfet_05v0 L=0.5U W=1.22U AS=0.3172P
+ AD=0.3782P PS=1.74U PD=1.84U
* device instance _1151 r180 *1 571.53,792.23 pfet_05v0
XM_1151 n_I2984 n_I2207 n_I2985 VDD_DEC pfet_05v0 L=0.5U W=1.22U AS=0.3782P
+ AD=0.3782P PS=1.84U PD=1.84U
* device instance _1152 r180 *1 570.41,792.23 pfet_05v0
XM_1152 n_I2132 n_I2280 n_I2984 VDD_DEC pfet_05v0 L=0.5U W=1.22U AS=0.3782P
+ AD=0.5368P PS=1.84U PD=3.32U
* device instance _1153 r180 *1 573.72,794.54 nfet_05v0
XM_1153 n_I2132 n_I2204 VSS VSS nfet_05v0 L=0.6U W=0.36U AS=0.1584P AD=0.0936P
+ PS=1.6U PD=0.88U
* device instance _1154 r180 *1 572.6,794.54 nfet_05v0
XM_1154 VSS n_I2206 n_I2132 VSS nfet_05v0 L=0.6U W=0.36U AS=0.0936P AD=0.0936P
+ PS=0.88U PD=0.88U
* device instance _1155 r180 *1 571.48,794.54 nfet_05v0
XM_1155 n_I2132 n_I2207 VSS VSS nfet_05v0 L=0.6U W=0.36U AS=0.0936P AD=0.0936P
+ PS=0.88U PD=0.88U
* device instance _1156 r180 *1 570.36,794.54 nfet_05v0
XM_1156 VSS n_I2280 n_I2132 VSS nfet_05v0 L=0.6U W=0.36U AS=0.0936P AD=0.1584P
+ PS=0.88U PD=1.6U
* device instance _1157 r180 *1 546.23,792.23 pfet_05v0
XM_1157 n_I2989 n_I2204 VDD_DEC VDD_DEC pfet_05v0 L=0.5U W=1.22U AS=0.5368P
+ AD=0.3172P PS=3.32U PD=1.74U
* device instance _1158 r180 *1 545.21,792.23 pfet_05v0
XM_1158 n_I2988 n_I2202 n_I2989 VDD_DEC pfet_05v0 L=0.5U W=1.22U AS=0.3172P
+ AD=0.3782P PS=1.74U PD=1.84U
* device instance _1159 r180 *1 544.09,792.23 pfet_05v0
XM_1159 n_I2987 n_I2333 n_I2988 VDD_DEC pfet_05v0 L=0.5U W=1.22U AS=0.3782P
+ AD=0.3782P PS=1.84U PD=1.84U
* device instance _1160 r180 *1 542.97,792.23 pfet_05v0
XM_1160 n_I2059 n_I2203 n_I2987 VDD_DEC pfet_05v0 L=0.5U W=1.22U AS=0.3782P
+ AD=0.5368P PS=1.84U PD=3.32U
* device instance _1161 r180 *1 546.28,794.54 nfet_05v0
XM_1161 n_I2059 n_I2204 VSS VSS nfet_05v0 L=0.6U W=0.36U AS=0.1584P AD=0.0936P
+ PS=1.6U PD=0.88U
* device instance _1162 r180 *1 545.16,794.54 nfet_05v0
XM_1162 VSS n_I2202 n_I2059 VSS nfet_05v0 L=0.6U W=0.36U AS=0.0936P AD=0.0936P
+ PS=0.88U PD=0.88U
* device instance _1163 r180 *1 544.04,794.54 nfet_05v0
XM_1163 n_I2059 n_I2333 VSS VSS nfet_05v0 L=0.6U W=0.36U AS=0.0936P AD=0.0936P
+ PS=0.88U PD=0.88U
* device instance _1164 r180 *1 542.92,794.54 nfet_05v0
XM_1164 VSS n_I2203 n_I2059 VSS nfet_05v0 L=0.6U W=0.36U AS=0.0936P AD=0.1584P
+ PS=0.88U PD=1.6U
* device instance _1165 r180 *1 546.23,815.75 pfet_05v0
XM_1165 n_I2992 n_I2198 VDD_DEC VDD_DEC pfet_05v0 L=0.5U W=1.22U AS=0.5368P
+ AD=0.3172P PS=3.32U PD=1.74U
* device instance _1166 r180 *1 545.21,815.75 pfet_05v0
XM_1166 n_I2991 n_I2202 n_I2992 VDD_DEC pfet_05v0 L=0.5U W=1.22U AS=0.3172P
+ AD=0.3782P PS=1.74U PD=1.84U
* device instance _1167 r180 *1 544.09,815.75 pfet_05v0
XM_1167 n_I2990 n_I2383 n_I2991 VDD_DEC pfet_05v0 L=0.5U W=1.22U AS=0.3782P
+ AD=0.3782P PS=1.84U PD=1.84U
* device instance _1168 r180 *1 542.97,815.75 pfet_05v0
XM_1168 n_I2235 n_I2280 n_I2990 VDD_DEC pfet_05v0 L=0.5U W=1.22U AS=0.3782P
+ AD=0.5368P PS=1.84U PD=3.32U
* device instance _1169 r180 *1 546.28,818.06 nfet_05v0
XM_1169 n_I2235 n_I2198 VSS VSS nfet_05v0 L=0.6U W=0.36U AS=0.1584P AD=0.0936P
+ PS=1.6U PD=0.88U
* device instance _1170 r180 *1 545.16,818.06 nfet_05v0
XM_1170 VSS n_I2202 n_I2235 VSS nfet_05v0 L=0.6U W=0.36U AS=0.0936P AD=0.0936P
+ PS=0.88U PD=0.88U
* device instance _1171 r180 *1 544.04,818.06 nfet_05v0
XM_1171 n_I2235 n_I2383 VSS VSS nfet_05v0 L=0.6U W=0.36U AS=0.0936P AD=0.0936P
+ PS=0.88U PD=0.88U
* device instance _1172 r180 *1 542.92,818.06 nfet_05v0
XM_1172 VSS n_I2280 n_I2235 VSS nfet_05v0 L=0.6U W=0.36U AS=0.0936P AD=0.1584P
+ PS=0.88U PD=1.6U
* device instance _1173 r180 *1 588.23,792.23 pfet_05v0
XM_1173 n_I2995 n_I2208 VDD_DEC VDD_DEC pfet_05v0 L=0.5U W=1.22U AS=0.5368P
+ AD=0.3172P PS=3.32U PD=1.74U
* device instance _1174 r180 *1 587.21,792.23 pfet_05v0
XM_1174 n_I2994 n_I2172 n_I2995 VDD_DEC pfet_05v0 L=0.5U W=1.22U AS=0.3172P
+ AD=0.3782P PS=1.74U PD=1.84U
* device instance _1175 r180 *1 586.09,792.23 pfet_05v0
XM_1175 n_I2993 n_I2210 n_I2994 VDD_DEC pfet_05v0 L=0.5U W=1.22U AS=0.3782P
+ AD=0.3782P PS=1.84U PD=1.84U
* device instance _1176 r180 *1 584.97,792.23 pfet_05v0
XM_1176 n_I2028 n_I2171 n_I2993 VDD_DEC pfet_05v0 L=0.5U W=1.22U AS=0.3782P
+ AD=0.5368P PS=1.84U PD=3.32U
* device instance _1177 r180 *1 588.28,794.54 nfet_05v0
XM_1177 n_I2028 n_I2208 VSS VSS nfet_05v0 L=0.6U W=0.36U AS=0.1584P AD=0.0936P
+ PS=1.6U PD=0.88U
* device instance _1178 r180 *1 587.16,794.54 nfet_05v0
XM_1178 VSS n_I2172 n_I2028 VSS nfet_05v0 L=0.6U W=0.36U AS=0.0936P AD=0.0936P
+ PS=0.88U PD=0.88U
* device instance _1179 r180 *1 586.04,794.54 nfet_05v0
XM_1179 n_I2028 n_I2210 VSS VSS nfet_05v0 L=0.6U W=0.36U AS=0.0936P AD=0.0936P
+ PS=0.88U PD=0.88U
* device instance _1180 r180 *1 584.92,794.54 nfet_05v0
XM_1180 VSS n_I2171 n_I2028 VSS nfet_05v0 L=0.6U W=0.36U AS=0.0936P AD=0.1584P
+ PS=0.88U PD=1.6U
* device instance _1181 r180 *1 524.95,807.91 pfet_05v0
XM_1181 n_I2998 n_I2306 VDD_DEC VDD_DEC pfet_05v0 L=0.5U W=1.22U AS=0.5368P
+ AD=0.3172P PS=3.32U PD=1.74U
* device instance _1182 r180 *1 523.93,807.91 pfet_05v0
XM_1182 n_I2997 n_I2332 n_I2998 VDD_DEC pfet_05v0 L=0.5U W=1.22U AS=0.3172P
+ AD=0.3782P PS=1.74U PD=1.84U
* device instance _1183 r180 *1 522.81,807.91 pfet_05v0
XM_1183 n_I2996 n_I2250 n_I2997 VDD_DEC pfet_05v0 L=0.5U W=1.22U AS=0.3782P
+ AD=0.3782P PS=1.84U PD=1.84U
* device instance _1184 r180 *1 521.69,807.91 pfet_05v0
XM_1184 n_I2126 n_I2331 n_I2996 VDD_DEC pfet_05v0 L=0.5U W=1.22U AS=0.3782P
+ AD=0.5368P PS=1.84U PD=3.32U
* device instance _1185 r180 *1 525,810.22 nfet_05v0
XM_1185 n_I2126 n_I2306 VSS VSS nfet_05v0 L=0.6U W=0.36U AS=0.1584P AD=0.0936P
+ PS=1.6U PD=0.88U
* device instance _1186 r180 *1 523.88,810.22 nfet_05v0
XM_1186 VSS n_I2332 n_I2126 VSS nfet_05v0 L=0.6U W=0.36U AS=0.0936P AD=0.0936P
+ PS=0.88U PD=0.88U
* device instance _1187 r180 *1 522.76,810.22 nfet_05v0
XM_1187 n_I2126 n_I2250 VSS VSS nfet_05v0 L=0.6U W=0.36U AS=0.0936P AD=0.0936P
+ PS=0.88U PD=0.88U
* device instance _1188 r180 *1 521.64,810.22 nfet_05v0
XM_1188 VSS n_I2331 n_I2126 VSS nfet_05v0 L=0.6U W=0.36U AS=0.0936P AD=0.1584P
+ PS=0.88U PD=1.6U
* device instance _1189 r180 *1 519.35,807.91 pfet_05v0
XM_1189 n_I3001 n_I2274 VDD_DEC VDD_DEC pfet_05v0 L=0.5U W=1.22U AS=0.5368P
+ AD=0.3172P PS=3.32U PD=1.74U
* device instance _1190 r180 *1 518.33,807.91 pfet_05v0
XM_1190 n_I3000 n_I2332 n_I3001 VDD_DEC pfet_05v0 L=0.5U W=1.22U AS=0.3172P
+ AD=0.3782P PS=1.74U PD=1.84U
* device instance _1191 r180 *1 517.21,807.91 pfet_05v0
XM_1191 n_I2999 n_I2250 n_I3000 VDD_DEC pfet_05v0 L=0.5U W=1.22U AS=0.3782P
+ AD=0.3782P PS=1.84U PD=1.84U
* device instance _1192 r180 *1 516.09,807.91 pfet_05v0
XM_1192 n_I2161 n_I2331 n_I2999 VDD_DEC pfet_05v0 L=0.5U W=1.22U AS=0.3782P
+ AD=0.5368P PS=1.84U PD=3.32U
* device instance _1193 r180 *1 519.4,810.22 nfet_05v0
XM_1193 n_I2161 n_I2274 VSS VSS nfet_05v0 L=0.6U W=0.36U AS=0.1584P AD=0.0936P
+ PS=1.6U PD=0.88U
* device instance _1194 r180 *1 518.28,810.22 nfet_05v0
XM_1194 VSS n_I2332 n_I2161 VSS nfet_05v0 L=0.6U W=0.36U AS=0.0936P AD=0.0936P
+ PS=0.88U PD=0.88U
* device instance _1195 r180 *1 517.16,810.22 nfet_05v0
XM_1195 n_I2161 n_I2250 VSS VSS nfet_05v0 L=0.6U W=0.36U AS=0.0936P AD=0.0936P
+ PS=0.88U PD=0.88U
* device instance _1196 r180 *1 516.04,810.22 nfet_05v0
XM_1196 VSS n_I2331 n_I2161 VSS nfet_05v0 L=0.6U W=0.36U AS=0.0936P AD=0.1584P
+ PS=0.88U PD=1.6U
* device instance _1197 r180 *1 501.43,807.91 pfet_05v0
XM_1197 n_I3004 n_I2362 VDD_DEC VDD_DEC pfet_05v0 L=0.5U W=1.22U AS=0.5368P
+ AD=0.3172P PS=3.32U PD=1.74U
* device instance _1198 r180 *1 500.41,807.91 pfet_05v0
XM_1198 n_I3003 n_I2196 n_I3004 VDD_DEC pfet_05v0 L=0.5U W=1.22U AS=0.3172P
+ AD=0.3782P PS=1.74U PD=1.84U
* device instance _1199 r180 *1 499.29,807.91 pfet_05v0
XM_1199 n_I3002 n_I2248 n_I3003 VDD_DEC pfet_05v0 L=0.5U W=1.22U AS=0.3782P
+ AD=0.3782P PS=1.84U PD=1.84U
* device instance _1200 r180 *1 498.17,807.91 pfet_05v0
XM_1200 n_I2247 n_I2195 n_I3002 VDD_DEC pfet_05v0 L=0.5U W=1.22U AS=0.3782P
+ AD=0.5368P PS=1.84U PD=3.32U
* device instance _1201 r180 *1 501.48,810.22 nfet_05v0
XM_1201 n_I2247 n_I2362 VSS VSS nfet_05v0 L=0.6U W=0.36U AS=0.1584P AD=0.0936P
+ PS=1.6U PD=0.88U
* device instance _1202 r180 *1 500.36,810.22 nfet_05v0
XM_1202 VSS n_I2196 n_I2247 VSS nfet_05v0 L=0.6U W=0.36U AS=0.0936P AD=0.0936P
+ PS=0.88U PD=0.88U
* device instance _1203 r180 *1 499.24,810.22 nfet_05v0
XM_1203 n_I2247 n_I2248 VSS VSS nfet_05v0 L=0.6U W=0.36U AS=0.0936P AD=0.0936P
+ PS=0.88U PD=0.88U
* device instance _1204 r180 *1 498.12,810.22 nfet_05v0
XM_1204 VSS n_I2195 n_I2247 VSS nfet_05v0 L=0.6U W=0.36U AS=0.0936P AD=0.1584P
+ PS=0.88U PD=1.6U
* device instance _1205 r180 *1 524.95,815.75 pfet_05v0
XM_1205 n_I3007 n_I2357 VDD_DEC VDD_DEC pfet_05v0 L=0.5U W=1.22U AS=0.5368P
+ AD=0.3172P PS=3.32U PD=1.74U
* device instance _1206 r180 *1 523.93,815.75 pfet_05v0
XM_1206 n_I3006 n_I2332 n_I3007 VDD_DEC pfet_05v0 L=0.5U W=1.22U AS=0.3172P
+ AD=0.3782P PS=1.74U PD=1.84U
* device instance _1207 r180 *1 522.81,815.75 pfet_05v0
XM_1207 n_I3005 n_I2248 n_I3006 VDD_DEC pfet_05v0 L=0.5U W=1.22U AS=0.3782P
+ AD=0.3782P PS=1.84U PD=1.84U
* device instance _1208 r180 *1 521.69,815.75 pfet_05v0
XM_1208 n_I2232 n_I2331 n_I3005 VDD_DEC pfet_05v0 L=0.5U W=1.22U AS=0.3782P
+ AD=0.5368P PS=1.84U PD=3.32U
* device instance _1209 r180 *1 525,818.06 nfet_05v0
XM_1209 n_I2232 n_I2357 VSS VSS nfet_05v0 L=0.6U W=0.36U AS=0.1584P AD=0.0936P
+ PS=1.6U PD=0.88U
* device instance _1210 r180 *1 523.88,818.06 nfet_05v0
XM_1210 VSS n_I2332 n_I2232 VSS nfet_05v0 L=0.6U W=0.36U AS=0.0936P AD=0.0936P
+ PS=0.88U PD=0.88U
* device instance _1211 r180 *1 522.76,818.06 nfet_05v0
XM_1211 n_I2232 n_I2248 VSS VSS nfet_05v0 L=0.6U W=0.36U AS=0.0936P AD=0.0936P
+ PS=0.88U PD=0.88U
* device instance _1212 r180 *1 521.64,818.06 nfet_05v0
XM_1212 VSS n_I2331 n_I2232 VSS nfet_05v0 L=0.6U W=0.36U AS=0.0936P AD=0.1584P
+ PS=0.88U PD=1.6U
* device instance _1213 r180 *1 560.23,823.59 pfet_05v0
XM_1213 n_I3010 n_I2237 VDD_DEC VDD_DEC pfet_05v0 L=0.5U W=1.22U AS=0.5368P
+ AD=0.3172P PS=3.32U PD=1.74U
* device instance _1214 r180 *1 559.21,823.59 pfet_05v0
XM_1214 n_I3009 n_I2416 n_I3010 VDD_DEC pfet_05v0 L=0.5U W=1.22U AS=0.3172P
+ AD=0.3782P PS=1.74U PD=1.84U
* device instance _1215 r180 *1 558.09,823.59 pfet_05v0
XM_1215 n_I3008 n_I2333 n_I3009 VDD_DEC pfet_05v0 L=0.5U W=1.22U AS=0.3782P
+ AD=0.3782P PS=1.84U PD=1.84U
* device instance _1216 r180 *1 556.97,823.59 pfet_05v0
XM_1216 n_I2060 n_I2203 n_I3008 VDD_DEC pfet_05v0 L=0.5U W=1.22U AS=0.3782P
+ AD=0.5368P PS=1.84U PD=3.32U
* device instance _1217 r180 *1 560.28,825.9 nfet_05v0
XM_1217 n_I2060 n_I2237 VSS VSS nfet_05v0 L=0.6U W=0.36U AS=0.1584P AD=0.0936P
+ PS=1.6U PD=0.88U
* device instance _1218 r180 *1 559.16,825.9 nfet_05v0
XM_1218 VSS n_I2416 n_I2060 VSS nfet_05v0 L=0.6U W=0.36U AS=0.0936P AD=0.0936P
+ PS=0.88U PD=0.88U
* device instance _1219 r180 *1 558.04,825.9 nfet_05v0
XM_1219 n_I2060 n_I2333 VSS VSS nfet_05v0 L=0.6U W=0.36U AS=0.0936P AD=0.0936P
+ PS=0.88U PD=0.88U
* device instance _1220 r180 *1 556.92,825.9 nfet_05v0
XM_1220 VSS n_I2203 n_I2060 VSS nfet_05v0 L=0.6U W=0.36U AS=0.0936P AD=0.1584P
+ PS=0.88U PD=1.6U
* device instance _1221 r180 *1 537.27,823.59 pfet_05v0
XM_1221 n_I3013 n_I2323 VDD_DEC VDD_DEC pfet_05v0 L=0.5U W=1.22U AS=0.5368P
+ AD=0.3172P PS=3.32U PD=1.74U
* device instance _1222 r180 *1 536.25,823.59 pfet_05v0
XM_1222 n_I3012 n_I2332 n_I3013 VDD_DEC pfet_05v0 L=0.5U W=1.22U AS=0.3172P
+ AD=0.3782P PS=1.74U PD=1.84U
* device instance _1223 r180 *1 535.13,823.59 pfet_05v0
XM_1223 n_I3011 n_I2169 n_I3012 VDD_DEC pfet_05v0 L=0.5U W=1.22U AS=0.3782P
+ AD=0.3782P PS=1.84U PD=1.84U
* device instance _1224 r180 *1 534.01,823.59 pfet_05v0
XM_1224 n_I2057 n_I2359 n_I3011 VDD_DEC pfet_05v0 L=0.5U W=1.22U AS=0.3782P
+ AD=0.5368P PS=1.84U PD=3.32U
* device instance _1225 r180 *1 537.32,825.9 nfet_05v0
XM_1225 n_I2057 n_I2323 VSS VSS nfet_05v0 L=0.6U W=0.36U AS=0.1584P AD=0.0936P
+ PS=1.6U PD=0.88U
* device instance _1226 r180 *1 536.2,825.9 nfet_05v0
XM_1226 VSS n_I2332 n_I2057 VSS nfet_05v0 L=0.6U W=0.36U AS=0.0936P AD=0.0936P
+ PS=0.88U PD=0.88U
* device instance _1227 r180 *1 535.08,825.9 nfet_05v0
XM_1227 n_I2057 n_I2169 VSS VSS nfet_05v0 L=0.6U W=0.36U AS=0.0936P AD=0.0936P
+ PS=0.88U PD=0.88U
* device instance _1228 r180 *1 533.96,825.9 nfet_05v0
XM_1228 VSS n_I2359 n_I2057 VSS nfet_05v0 L=0.6U W=0.36U AS=0.0936P AD=0.1584P
+ PS=0.88U PD=1.6U
* device instance _1229 r180 *1 583.75,800.07 pfet_05v0
XM_1229 n_I3016 n_I2198 VDD_DEC VDD_DEC pfet_05v0 L=0.5U W=1.22U AS=0.5368P
+ AD=0.3172P PS=3.32U PD=1.74U
* device instance _1230 r180 *1 582.73,800.07 pfet_05v0
XM_1230 n_I3015 n_I2211 n_I3016 VDD_DEC pfet_05v0 L=0.5U W=1.22U AS=0.3172P
+ AD=0.3782P PS=1.74U PD=1.84U
* device instance _1231 r180 *1 581.61,800.07 pfet_05v0
XM_1231 n_I3014 n_I2284 n_I3015 VDD_DEC pfet_05v0 L=0.5U W=1.22U AS=0.3782P
+ AD=0.3782P PS=1.84U PD=1.84U
* device instance _1232 r180 *1 580.49,800.07 pfet_05v0
XM_1232 n_I2134 n_I2171 n_I3014 VDD_DEC pfet_05v0 L=0.5U W=1.22U AS=0.3782P
+ AD=0.5368P PS=1.84U PD=3.32U
* device instance _1233 r180 *1 583.8,802.38 nfet_05v0
XM_1233 n_I2134 n_I2198 VSS VSS nfet_05v0 L=0.6U W=0.36U AS=0.1584P AD=0.0936P
+ PS=1.6U PD=0.88U
* device instance _1234 r180 *1 582.68,802.38 nfet_05v0
XM_1234 VSS n_I2211 n_I2134 VSS nfet_05v0 L=0.6U W=0.36U AS=0.0936P AD=0.0936P
+ PS=0.88U PD=0.88U
* device instance _1235 r180 *1 581.56,802.38 nfet_05v0
XM_1235 n_I2134 n_I2284 VSS VSS nfet_05v0 L=0.6U W=0.36U AS=0.0936P AD=0.0936P
+ PS=0.88U PD=0.88U
* device instance _1236 r180 *1 580.44,802.38 nfet_05v0
XM_1236 VSS n_I2171 n_I2134 VSS nfet_05v0 L=0.6U W=0.36U AS=0.0936P AD=0.1584P
+ PS=0.88U PD=1.6U
* device instance _1237 r0 *1 665.21,790.33 pfet_05v0
XM_1237 n_I3019 n_I2204 VDD_DEC VDD_DEC pfet_05v0 L=0.5U W=1.22U AS=0.5368P
+ AD=0.3172P PS=3.32U PD=1.74U
* device instance _1238 r0 *1 666.23,790.33 pfet_05v0
XM_1238 n_I3018 n_I2176 n_I3019 VDD_DEC pfet_05v0 L=0.5U W=1.22U AS=0.3172P
+ AD=0.3782P PS=1.74U PD=1.84U
* device instance _1239 r0 *1 667.35,790.33 pfet_05v0
XM_1239 n_I3017 n_I2178 n_I3018 VDD_DEC pfet_05v0 L=0.5U W=1.22U AS=0.3782P
+ AD=0.3782P PS=1.84U PD=1.84U
* device instance _1240 r0 *1 668.47,790.33 pfet_05v0
XM_1240 n_I2289 n_I2177 n_I3017 VDD_DEC pfet_05v0 L=0.5U W=1.22U AS=0.3782P
+ AD=0.5368P PS=1.84U PD=3.32U
* device instance _1241 r0 *1 665.16,788.02 nfet_05v0
XM_1241 n_I2289 n_I2204 VSS VSS nfet_05v0 L=0.6U W=0.36U AS=0.1584P AD=0.0936P
+ PS=1.6U PD=0.88U
* device instance _1242 r0 *1 666.28,788.02 nfet_05v0
XM_1242 VSS n_I2176 n_I2289 VSS nfet_05v0 L=0.6U W=0.36U AS=0.0936P AD=0.0936P
+ PS=0.88U PD=0.88U
* device instance _1243 r0 *1 667.4,788.02 nfet_05v0
XM_1243 n_I2289 n_I2178 VSS VSS nfet_05v0 L=0.6U W=0.36U AS=0.0936P AD=0.0936P
+ PS=0.88U PD=0.88U
* device instance _1244 r0 *1 668.52,788.02 nfet_05v0
XM_1244 VSS n_I2177 n_I2289 VSS nfet_05v0 L=0.6U W=0.36U AS=0.0936P AD=0.1584P
+ PS=0.88U PD=1.6U
* device instance _1245 r0 *1 613.69,806.01 pfet_05v0
XM_1245 n_I3022 n_I2251 VDD_DEC VDD_DEC pfet_05v0 L=0.5U W=1.22U AS=0.5368P
+ AD=0.3172P PS=3.32U PD=1.74U
* device instance _1246 r0 *1 614.71,806.01 pfet_05v0
XM_1246 n_I3021 n_I2285 n_I3022 VDD_DEC pfet_05v0 L=0.5U W=1.22U AS=0.3172P
+ AD=0.3782P PS=1.74U PD=1.84U
* device instance _1247 r0 *1 615.83,806.01 pfet_05v0
XM_1247 n_I3020 n_I2178 n_I3021 VDD_DEC pfet_05v0 L=0.5U W=1.22U AS=0.3782P
+ AD=0.3782P PS=1.84U PD=1.84U
* device instance _1248 r0 *1 616.95,806.01 pfet_05v0
XM_1248 n_I2167 n_I2213 n_I3020 VDD_DEC pfet_05v0 L=0.5U W=1.22U AS=0.3782P
+ AD=0.5368P PS=1.84U PD=3.32U
* device instance _1249 r0 *1 613.64,803.7 nfet_05v0
XM_1249 n_I2167 n_I2251 VSS VSS nfet_05v0 L=0.6U W=0.36U AS=0.1584P AD=0.0936P
+ PS=1.6U PD=0.88U
* device instance _1250 r0 *1 614.76,803.7 nfet_05v0
XM_1250 VSS n_I2285 n_I2167 VSS nfet_05v0 L=0.6U W=0.36U AS=0.0936P AD=0.0936P
+ PS=0.88U PD=0.88U
* device instance _1251 r0 *1 615.88,803.7 nfet_05v0
XM_1251 n_I2167 n_I2178 VSS VSS nfet_05v0 L=0.6U W=0.36U AS=0.0936P AD=0.0936P
+ PS=0.88U PD=0.88U
* device instance _1252 r0 *1 617,803.7 nfet_05v0
XM_1252 VSS n_I2213 n_I2167 VSS nfet_05v0 L=0.6U W=0.36U AS=0.0936P AD=0.1584P
+ PS=0.88U PD=1.6U
* device instance _1253 r0 *1 540.89,829.53 pfet_05v0
XM_1253 n_I3025 n_I2360 VDD_DEC VDD_DEC pfet_05v0 L=0.5U W=1.22U AS=0.5368P
+ AD=0.3172P PS=3.32U PD=1.74U
* device instance _1254 r0 *1 541.91,829.53 pfet_05v0
XM_1254 n_I3024 n_I2416 n_I3025 VDD_DEC pfet_05v0 L=0.5U W=1.22U AS=0.3172P
+ AD=0.3782P PS=1.74U PD=1.84U
* device instance _1255 r0 *1 543.03,829.53 pfet_05v0
XM_1255 n_I3023 n_I2333 n_I3024 VDD_DEC pfet_05v0 L=0.5U W=1.22U AS=0.3782P
+ AD=0.3782P PS=1.84U PD=1.84U
* device instance _1256 r0 *1 544.15,829.53 pfet_05v0
XM_1256 n_I2310 n_I2359 n_I3023 VDD_DEC pfet_05v0 L=0.5U W=1.22U AS=0.3782P
+ AD=0.5368P PS=1.84U PD=3.32U
* device instance _1257 r0 *1 540.84,827.22 nfet_05v0
XM_1257 n_I2310 n_I2360 VSS VSS nfet_05v0 L=0.6U W=0.36U AS=0.1584P AD=0.0936P
+ PS=1.6U PD=0.88U
* device instance _1258 r0 *1 541.96,827.22 nfet_05v0
XM_1258 VSS n_I2416 n_I2310 VSS nfet_05v0 L=0.6U W=0.36U AS=0.0936P AD=0.0936P
+ PS=0.88U PD=0.88U
* device instance _1259 r0 *1 543.08,827.22 nfet_05v0
XM_1259 n_I2310 n_I2333 VSS VSS nfet_05v0 L=0.6U W=0.36U AS=0.0936P AD=0.0936P
+ PS=0.88U PD=0.88U
* device instance _1260 r0 *1 544.2,827.22 nfet_05v0
XM_1260 VSS n_I2359 n_I2310 VSS nfet_05v0 L=0.6U W=0.36U AS=0.0936P AD=0.1584P
+ PS=0.88U PD=1.6U
* device instance _1261 r0 *1 619.29,806.01 pfet_05v0
XM_1261 n_I3028 n_I2208 VDD_DEC VDD_DEC pfet_05v0 L=0.5U W=1.22U AS=0.5368P
+ AD=0.3172P PS=3.32U PD=1.74U
* device instance _1262 r0 *1 620.31,806.01 pfet_05v0
XM_1262 n_I3027 n_I2286 n_I3028 VDD_DEC pfet_05v0 L=0.5U W=1.22U AS=0.3172P
+ AD=0.3782P PS=1.74U PD=1.84U
* device instance _1263 r0 *1 621.43,806.01 pfet_05v0
XM_1263 n_I3026 n_I2287 n_I3027 VDD_DEC pfet_05v0 L=0.5U W=1.22U AS=0.3782P
+ AD=0.3782P PS=1.84U PD=1.84U
* device instance _1264 r0 *1 622.55,806.01 pfet_05v0
XM_1264 n_I2256 n_I2213 n_I3026 VDD_DEC pfet_05v0 L=0.5U W=1.22U AS=0.3782P
+ AD=0.5368P PS=1.84U PD=3.32U
* device instance _1265 r0 *1 619.24,803.7 nfet_05v0
XM_1265 n_I2256 n_I2208 VSS VSS nfet_05v0 L=0.6U W=0.36U AS=0.1584P AD=0.0936P
+ PS=1.6U PD=0.88U
* device instance _1266 r0 *1 620.36,803.7 nfet_05v0
XM_1266 VSS n_I2286 n_I2256 VSS nfet_05v0 L=0.6U W=0.36U AS=0.0936P AD=0.0936P
+ PS=0.88U PD=0.88U
* device instance _1267 r0 *1 621.48,803.7 nfet_05v0
XM_1267 n_I2256 n_I2287 VSS VSS nfet_05v0 L=0.6U W=0.36U AS=0.0936P AD=0.0936P
+ PS=0.88U PD=0.88U
* device instance _1268 r0 *1 622.6,803.7 nfet_05v0
XM_1268 VSS n_I2213 n_I2256 VSS nfet_05v0 L=0.6U W=0.36U AS=0.0936P AD=0.1584P
+ PS=0.88U PD=1.6U
* device instance _1269 r0 *1 656.81,806.01 pfet_05v0
XM_1269 n_I3031 n_I2309 VDD_DEC VDD_DEC pfet_05v0 L=0.5U W=1.22U AS=0.5368P
+ AD=0.3172P PS=3.32U PD=1.74U
* device instance _1270 r0 *1 657.83,806.01 pfet_05v0
XM_1270 n_I3030 n_I2214 n_I3031 VDD_DEC pfet_05v0 L=0.5U W=1.22U AS=0.3172P
+ AD=0.3782P PS=1.74U PD=1.84U
* device instance _1271 r0 *1 658.95,806.01 pfet_05v0
XM_1271 n_I3029 n_I2178 n_I3030 VDD_DEC pfet_05v0 L=0.5U W=1.22U AS=0.3782P
+ AD=0.3782P PS=1.84U PD=1.84U
* device instance _1272 r0 *1 660.07,806.01 pfet_05v0
XM_1272 n_I2328 n_I2177 n_I3029 VDD_DEC pfet_05v0 L=0.5U W=1.22U AS=0.3782P
+ AD=0.5368P PS=1.84U PD=3.32U
* device instance _1273 r0 *1 656.76,803.7 nfet_05v0
XM_1273 n_I2328 n_I2309 VSS VSS nfet_05v0 L=0.6U W=0.36U AS=0.1584P AD=0.0936P
+ PS=1.6U PD=0.88U
* device instance _1274 r0 *1 657.88,803.7 nfet_05v0
XM_1274 VSS n_I2214 n_I2328 VSS nfet_05v0 L=0.6U W=0.36U AS=0.0936P AD=0.0936P
+ PS=0.88U PD=0.88U
* device instance _1275 r0 *1 659,803.7 nfet_05v0
XM_1275 n_I2328 n_I2178 VSS VSS nfet_05v0 L=0.6U W=0.36U AS=0.0936P AD=0.0936P
+ PS=0.88U PD=0.88U
* device instance _1276 r0 *1 660.12,803.7 nfet_05v0
XM_1276 VSS n_I2177 n_I2328 VSS nfet_05v0 L=0.6U W=0.36U AS=0.0936P AD=0.1584P
+ PS=0.88U PD=1.6U
* device instance _1277 r0 *1 665.21,806.01 pfet_05v0
XM_1277 n_I3034 n_I2274 VDD_DEC VDD_DEC pfet_05v0 L=0.5U W=1.22U AS=0.5368P
+ AD=0.3172P PS=3.32U PD=1.74U
* device instance _1278 r0 *1 666.23,806.01 pfet_05v0
XM_1278 n_I3033 n_I2140 n_I3034 VDD_DEC pfet_05v0 L=0.5U W=1.22U AS=0.3172P
+ AD=0.3782P PS=1.74U PD=1.84U
* device instance _1279 r0 *1 667.35,806.01 pfet_05v0
XM_1279 n_I3032 n_I2287 n_I3033 VDD_DEC pfet_05v0 L=0.5U W=1.22U AS=0.3782P
+ AD=0.3782P PS=1.84U PD=1.84U
* device instance _1280 r0 *1 668.47,806.01 pfet_05v0
XM_1280 n_I2079 n_I2138 n_I3032 VDD_DEC pfet_05v0 L=0.5U W=1.22U AS=0.3782P
+ AD=0.5368P PS=1.84U PD=3.32U
* device instance _1281 r0 *1 665.16,803.7 nfet_05v0
XM_1281 n_I2079 n_I2274 VSS VSS nfet_05v0 L=0.6U W=0.36U AS=0.1584P AD=0.0936P
+ PS=1.6U PD=0.88U
* device instance _1282 r0 *1 666.28,803.7 nfet_05v0
XM_1282 VSS n_I2140 n_I2079 VSS nfet_05v0 L=0.6U W=0.36U AS=0.0936P AD=0.0936P
+ PS=0.88U PD=0.88U
* device instance _1283 r0 *1 667.4,803.7 nfet_05v0
XM_1283 n_I2079 n_I2287 VSS VSS nfet_05v0 L=0.6U W=0.36U AS=0.0936P AD=0.0936P
+ PS=0.88U PD=0.88U
* device instance _1284 r0 *1 668.52,803.7 nfet_05v0
XM_1284 VSS n_I2138 n_I2079 VSS nfet_05v0 L=0.6U W=0.36U AS=0.0936P AD=0.1584P
+ PS=0.88U PD=1.6U
* device instance _1285 r0 *1 586.81,813.85 pfet_05v0
XM_1285 n_I3037 n_I2402 VDD_DEC VDD_DEC pfet_05v0 L=0.5U W=1.22U AS=0.5368P
+ AD=0.3172P PS=3.32U PD=1.74U
* device instance _1286 r0 *1 587.83,813.85 pfet_05v0
XM_1286 n_I3036 n_I2211 n_I3037 VDD_DEC pfet_05v0 L=0.5U W=1.22U AS=0.3172P
+ AD=0.3782P PS=1.74U PD=1.84U
* device instance _1287 r0 *1 588.95,813.85 pfet_05v0
XM_1287 n_I3035 n_I2284 n_I3036 VDD_DEC pfet_05v0 L=0.5U W=1.22U AS=0.3782P
+ AD=0.3782P PS=1.84U PD=1.84U
* device instance _1288 r0 *1 590.07,813.85 pfet_05v0
XM_1288 n_I2238 n_I2252 n_I3035 VDD_DEC pfet_05v0 L=0.5U W=1.22U AS=0.3782P
+ AD=0.5368P PS=1.84U PD=3.32U
* device instance _1289 r0 *1 586.76,811.54 nfet_05v0
XM_1289 n_I2238 n_I2402 VSS VSS nfet_05v0 L=0.6U W=0.36U AS=0.1584P AD=0.0936P
+ PS=1.6U PD=0.88U
* device instance _1290 r0 *1 587.88,811.54 nfet_05v0
XM_1290 VSS n_I2211 n_I2238 VSS nfet_05v0 L=0.6U W=0.36U AS=0.0936P AD=0.0936P
+ PS=0.88U PD=0.88U
* device instance _1291 r0 *1 589,811.54 nfet_05v0
XM_1291 n_I2238 n_I2284 VSS VSS nfet_05v0 L=0.6U W=0.36U AS=0.0936P AD=0.0936P
+ PS=0.88U PD=0.88U
* device instance _1292 r0 *1 590.12,811.54 nfet_05v0
XM_1292 VSS n_I2252 n_I2238 VSS nfet_05v0 L=0.6U W=0.36U AS=0.0936P AD=0.1584P
+ PS=0.88U PD=1.6U
* device instance _1293 r0 *1 540.89,790.33 pfet_05v0
XM_1293 n_I3040 n_I2165 VDD_DEC VDD_DEC pfet_05v0 L=0.5U W=1.22U AS=0.5368P
+ AD=0.3172P PS=3.32U PD=1.74U
* device instance _1294 r0 *1 541.91,790.33 pfet_05v0
XM_1294 n_I3039 n_I2202 n_I3040 VDD_DEC pfet_05v0 L=0.5U W=1.22U AS=0.3172P
+ AD=0.3782P PS=1.74U PD=1.84U
* device instance _1295 r0 *1 543.03,790.33 pfet_05v0
XM_1295 n_I3038 n_I2169 n_I3039 VDD_DEC pfet_05v0 L=0.5U W=1.22U AS=0.3782P
+ AD=0.3782P PS=1.84U PD=1.84U
* device instance _1296 r0 *1 544.15,790.33 pfet_05v0
XM_1296 n_I2025 n_I2203 n_I3038 VDD_DEC pfet_05v0 L=0.5U W=1.22U AS=0.3782P
+ AD=0.5368P PS=1.84U PD=3.32U
* device instance _1297 r0 *1 540.84,788.02 nfet_05v0
XM_1297 n_I2025 n_I2165 VSS VSS nfet_05v0 L=0.6U W=0.36U AS=0.1584P AD=0.0936P
+ PS=1.6U PD=0.88U
* device instance _1298 r0 *1 541.96,788.02 nfet_05v0
XM_1298 VSS n_I2202 n_I2025 VSS nfet_05v0 L=0.6U W=0.36U AS=0.0936P AD=0.0936P
+ PS=0.88U PD=0.88U
* device instance _1299 r0 *1 543.08,788.02 nfet_05v0
XM_1299 n_I2025 n_I2169 VSS VSS nfet_05v0 L=0.6U W=0.36U AS=0.0936P AD=0.0936P
+ PS=0.88U PD=0.88U
* device instance _1300 r0 *1 544.2,788.02 nfet_05v0
XM_1300 VSS n_I2203 n_I2025 VSS nfet_05v0 L=0.6U W=0.36U AS=0.0936P AD=0.1584P
+ PS=0.88U PD=1.6U
* device instance _1301 r0 *1 594.09,813.85 pfet_05v0
XM_1301 n_I3043 n_I2357 VDD_DEC VDD_DEC pfet_05v0 L=0.5U W=1.22U AS=0.5368P
+ AD=0.3172P PS=3.32U PD=1.74U
* device instance _1302 r0 *1 595.11,813.85 pfet_05v0
XM_1302 n_I3042 n_I2288 n_I3043 VDD_DEC pfet_05v0 L=0.5U W=1.22U AS=0.3172P
+ AD=0.3782P PS=1.74U PD=1.84U
* device instance _1303 r0 *1 596.23,813.85 pfet_05v0
XM_1303 n_I3041 n_I2284 n_I3042 VDD_DEC pfet_05v0 L=0.5U W=1.22U AS=0.3782P
+ AD=0.3782P PS=1.84U PD=1.84U
* device instance _1304 r0 *1 597.35,813.85 pfet_05v0
XM_1304 n_I2102 n_I2252 n_I3041 VDD_DEC pfet_05v0 L=0.5U W=1.22U AS=0.3782P
+ AD=0.5368P PS=1.84U PD=3.32U
* device instance _1305 r0 *1 594.04,811.54 nfet_05v0
XM_1305 n_I2102 n_I2357 VSS VSS nfet_05v0 L=0.6U W=0.36U AS=0.1584P AD=0.0936P
+ PS=1.6U PD=0.88U
* device instance _1306 r0 *1 595.16,811.54 nfet_05v0
XM_1306 VSS n_I2288 n_I2102 VSS nfet_05v0 L=0.6U W=0.36U AS=0.0936P AD=0.0936P
+ PS=0.88U PD=0.88U
* device instance _1307 r0 *1 596.28,811.54 nfet_05v0
XM_1307 n_I2102 n_I2284 VSS VSS nfet_05v0 L=0.6U W=0.36U AS=0.0936P AD=0.0936P
+ PS=0.88U PD=0.88U
* device instance _1308 r0 *1 597.4,811.54 nfet_05v0
XM_1308 VSS n_I2252 n_I2102 VSS nfet_05v0 L=0.6U W=0.36U AS=0.0936P AD=0.1584P
+ PS=0.88U PD=1.6U
* device instance _1309 r0 *1 604.17,806.01 pfet_05v0
XM_1309 n_I3046 n_I2309 VDD_DEC VDD_DEC pfet_05v0 L=0.5U W=1.22U AS=0.5368P
+ AD=0.3172P PS=3.32U PD=1.74U
* device instance _1310 r0 *1 605.19,806.01 pfet_05v0
XM_1310 n_I3045 n_I2240 n_I3046 VDD_DEC pfet_05v0 L=0.5U W=1.22U AS=0.3172P
+ AD=0.3782P PS=1.74U PD=1.84U
* device instance _1311 r0 *1 606.31,806.01 pfet_05v0
XM_1311 n_I3044 n_I2242 n_I3045 VDD_DEC pfet_05v0 L=0.5U W=1.22U AS=0.3782P
+ AD=0.3782P PS=1.84U PD=1.84U
* device instance _1312 r0 *1 607.43,806.01 pfet_05v0
XM_1312 n_I2136 n_I2239 n_I3044 VDD_DEC pfet_05v0 L=0.5U W=1.22U AS=0.3782P
+ AD=0.5368P PS=1.84U PD=3.32U
* device instance _1313 r0 *1 604.12,803.7 nfet_05v0
XM_1313 n_I2136 n_I2309 VSS VSS nfet_05v0 L=0.6U W=0.36U AS=0.1584P AD=0.0936P
+ PS=1.6U PD=0.88U
* device instance _1314 r0 *1 605.24,803.7 nfet_05v0
XM_1314 VSS n_I2240 n_I2136 VSS nfet_05v0 L=0.6U W=0.36U AS=0.0936P AD=0.0936P
+ PS=0.88U PD=0.88U
* device instance _1315 r0 *1 606.36,803.7 nfet_05v0
XM_1315 n_I2136 n_I2242 VSS VSS nfet_05v0 L=0.6U W=0.36U AS=0.0936P AD=0.0936P
+ PS=0.88U PD=0.88U
* device instance _1316 r0 *1 607.48,803.7 nfet_05v0
XM_1316 VSS n_I2239 n_I2136 VSS nfet_05v0 L=0.6U W=0.36U AS=0.0936P AD=0.1584P
+ PS=0.88U PD=1.6U
* device instance _1317 r0 *1 619.29,821.69 pfet_05v0
XM_1317 n_I3049 n_I2360 VDD_DEC VDD_DEC pfet_05v0 L=0.5U W=1.22U AS=0.5368P
+ AD=0.3172P PS=3.32U PD=1.74U
* device instance _1318 r0 *1 620.31,821.69 pfet_05v0
XM_1318 n_I3048 n_I2286 n_I3049 VDD_DEC pfet_05v0 L=0.5U W=1.22U AS=0.3172P
+ AD=0.3782P PS=1.74U PD=1.84U
* device instance _1319 r0 *1 621.43,821.69 pfet_05v0
XM_1319 n_I3047 n_I2287 n_I3048 VDD_DEC pfet_05v0 L=0.5U W=1.22U AS=0.3782P
+ AD=0.3782P PS=1.84U PD=1.84U
* device instance _1320 r0 *1 622.55,821.69 pfet_05v0
XM_1320 n_I2325 n_I2213 n_I3047 VDD_DEC pfet_05v0 L=0.5U W=1.22U AS=0.3782P
+ AD=0.5368P PS=1.84U PD=3.32U
* device instance _1321 r0 *1 619.24,819.38 nfet_05v0
XM_1321 n_I2325 n_I2360 VSS VSS nfet_05v0 L=0.6U W=0.36U AS=0.1584P AD=0.0936P
+ PS=1.6U PD=0.88U
* device instance _1322 r0 *1 620.36,819.38 nfet_05v0
XM_1322 VSS n_I2286 n_I2325 VSS nfet_05v0 L=0.6U W=0.36U AS=0.0936P AD=0.0936P
+ PS=0.88U PD=0.88U
* device instance _1323 r0 *1 621.48,819.38 nfet_05v0
XM_1323 n_I2325 n_I2287 VSS VSS nfet_05v0 L=0.6U W=0.36U AS=0.0936P AD=0.0936P
+ PS=0.88U PD=0.88U
* device instance _1324 r0 *1 622.6,819.38 nfet_05v0
XM_1324 VSS n_I2213 n_I2325 VSS nfet_05v0 L=0.6U W=0.36U AS=0.0936P AD=0.1584P
+ PS=0.88U PD=1.6U
* device instance _1325 r0 *1 535.29,813.85 pfet_05v0
XM_1325 n_I3052 n_I2251 VDD_DEC VDD_DEC pfet_05v0 L=0.5U W=1.22U AS=0.5368P
+ AD=0.3172P PS=3.32U PD=1.74U
* device instance _1326 r0 *1 536.31,813.85 pfet_05v0
XM_1326 n_I3051 n_I2332 n_I3052 VDD_DEC pfet_05v0 L=0.5U W=1.22U AS=0.3172P
+ AD=0.3782P PS=1.74U PD=1.84U
* device instance _1327 r0 *1 537.43,813.85 pfet_05v0
XM_1327 n_I3050 n_I2169 n_I3051 VDD_DEC pfet_05v0 L=0.5U W=1.22U AS=0.3782P
+ AD=0.3782P PS=1.84U PD=1.84U
* device instance _1328 r0 *1 538.55,813.85 pfet_05v0
XM_1328 n_I2276 n_I2280 n_I3050 VDD_DEC pfet_05v0 L=0.5U W=1.22U AS=0.3782P
+ AD=0.5368P PS=1.84U PD=3.32U
* device instance _1329 r0 *1 535.24,811.54 nfet_05v0
XM_1329 n_I2276 n_I2251 VSS VSS nfet_05v0 L=0.6U W=0.36U AS=0.1584P AD=0.0936P
+ PS=1.6U PD=0.88U
* device instance _1330 r0 *1 536.36,811.54 nfet_05v0
XM_1330 VSS n_I2332 n_I2276 VSS nfet_05v0 L=0.6U W=0.36U AS=0.0936P AD=0.0936P
+ PS=0.88U PD=0.88U
* device instance _1331 r0 *1 537.48,811.54 nfet_05v0
XM_1331 n_I2276 n_I2169 VSS VSS nfet_05v0 L=0.6U W=0.36U AS=0.0936P AD=0.0936P
+ PS=0.88U PD=0.88U
* device instance _1332 r0 *1 538.6,811.54 nfet_05v0
XM_1332 VSS n_I2280 n_I2276 VSS nfet_05v0 L=0.6U W=0.36U AS=0.0936P AD=0.1584P
+ PS=0.88U PD=1.6U
* device instance _1333 r0 *1 626.01,821.69 pfet_05v0
XM_1333 n_I3055 n_I2309 VDD_DEC VDD_DEC pfet_05v0 L=0.5U W=1.22U AS=0.5368P
+ AD=0.3172P PS=3.32U PD=1.74U
* device instance _1334 r0 *1 627.03,821.69 pfet_05v0
XM_1334 n_I3054 n_I2140 n_I3055 VDD_DEC pfet_05v0 L=0.5U W=1.22U AS=0.3172P
+ AD=0.3782P PS=1.74U PD=1.84U
* device instance _1335 r0 *1 628.15,821.69 pfet_05v0
XM_1335 n_I3053 n_I2287 n_I3054 VDD_DEC pfet_05v0 L=0.5U W=1.22U AS=0.3782P
+ AD=0.3782P PS=1.84U PD=1.84U
* device instance _1336 r0 *1 629.27,821.69 pfet_05v0
XM_1336 n_I2312 n_I2138 n_I3053 VDD_DEC pfet_05v0 L=0.5U W=1.22U AS=0.3782P
+ AD=0.5368P PS=1.84U PD=3.32U
* device instance _1337 r0 *1 625.96,819.38 nfet_05v0
XM_1337 n_I2312 n_I2309 VSS VSS nfet_05v0 L=0.6U W=0.36U AS=0.1584P AD=0.0936P
+ PS=1.6U PD=0.88U
* device instance _1338 r0 *1 627.08,819.38 nfet_05v0
XM_1338 VSS n_I2140 n_I2312 VSS nfet_05v0 L=0.6U W=0.36U AS=0.0936P AD=0.0936P
+ PS=0.88U PD=0.88U
* device instance _1339 r0 *1 628.2,819.38 nfet_05v0
XM_1339 n_I2312 n_I2287 VSS VSS nfet_05v0 L=0.6U W=0.36U AS=0.0936P AD=0.0936P
+ PS=0.88U PD=0.88U
* device instance _1340 r0 *1 629.32,819.38 nfet_05v0
XM_1340 VSS n_I2138 n_I2312 VSS nfet_05v0 L=0.6U W=0.36U AS=0.0936P AD=0.1584P
+ PS=0.88U PD=1.6U
* device instance _1341 r0 *1 610.89,821.69 pfet_05v0
XM_1341 n_I3058 n_I2274 VDD_DEC VDD_DEC pfet_05v0 L=0.5U W=1.22U AS=0.5368P
+ AD=0.3172P PS=3.32U PD=1.74U
* device instance _1342 r0 *1 611.91,821.69 pfet_05v0
XM_1342 n_I3057 n_I2240 n_I3058 VDD_DEC pfet_05v0 L=0.5U W=1.22U AS=0.3172P
+ AD=0.3782P PS=1.74U PD=1.84U
* device instance _1343 r0 *1 613.03,821.69 pfet_05v0
XM_1343 n_I3056 n_I2242 n_I3057 VDD_DEC pfet_05v0 L=0.5U W=1.22U AS=0.3782P
+ AD=0.3782P PS=1.84U PD=1.84U
* device instance _1344 r0 *1 614.15,821.69 pfet_05v0
XM_1344 n_I2031 n_I2239 n_I3056 VDD_DEC pfet_05v0 L=0.5U W=1.22U AS=0.3782P
+ AD=0.5368P PS=1.84U PD=3.32U
* device instance _1345 r0 *1 610.84,819.38 nfet_05v0
XM_1345 n_I2031 n_I2274 VSS VSS nfet_05v0 L=0.6U W=0.36U AS=0.1584P AD=0.0936P
+ PS=1.6U PD=0.88U
* device instance _1346 r0 *1 611.96,819.38 nfet_05v0
XM_1346 VSS n_I2240 n_I2031 VSS nfet_05v0 L=0.6U W=0.36U AS=0.0936P AD=0.0936P
+ PS=0.88U PD=0.88U
* device instance _1347 r0 *1 613.08,819.38 nfet_05v0
XM_1347 n_I2031 n_I2242 VSS VSS nfet_05v0 L=0.6U W=0.36U AS=0.0936P AD=0.0936P
+ PS=0.88U PD=0.88U
* device instance _1348 r0 *1 614.2,819.38 nfet_05v0
XM_1348 VSS n_I2239 n_I2031 VSS nfet_05v0 L=0.6U W=0.36U AS=0.0936P AD=0.1584P
+ PS=0.88U PD=1.6U
* device instance _1349 r0 *1 619.29,798.17 pfet_05v0
XM_1349 n_I3061 n_I2237 VDD_DEC VDD_DEC pfet_05v0 L=0.5U W=1.22U AS=0.5368P
+ AD=0.3172P PS=3.32U PD=1.74U
* device instance _1350 r0 *1 620.31,798.17 pfet_05v0
XM_1350 n_I3060 n_I2240 n_I3061 VDD_DEC pfet_05v0 L=0.5U W=1.22U AS=0.3172P
+ AD=0.3782P PS=1.74U PD=1.84U
* device instance _1351 r0 *1 621.43,798.17 pfet_05v0
XM_1351 n_I3059 n_I2178 n_I3060 VDD_DEC pfet_05v0 L=0.5U W=1.22U AS=0.3782P
+ AD=0.3782P PS=1.84U PD=1.84U
* device instance _1352 r0 *1 622.55,798.17 pfet_05v0
XM_1352 n_I2075 n_I2239 n_I3059 VDD_DEC pfet_05v0 L=0.5U W=1.22U AS=0.3782P
+ AD=0.5368P PS=1.84U PD=3.32U
* device instance _1353 r0 *1 619.24,795.86 nfet_05v0
XM_1353 n_I2075 n_I2237 VSS VSS nfet_05v0 L=0.6U W=0.36U AS=0.1584P AD=0.0936P
+ PS=1.6U PD=0.88U
* device instance _1354 r0 *1 620.36,795.86 nfet_05v0
XM_1354 VSS n_I2240 n_I2075 VSS nfet_05v0 L=0.6U W=0.36U AS=0.0936P AD=0.0936P
+ PS=0.88U PD=0.88U
* device instance _1355 r0 *1 621.48,795.86 nfet_05v0
XM_1355 n_I2075 n_I2178 VSS VSS nfet_05v0 L=0.6U W=0.36U AS=0.0936P AD=0.0936P
+ PS=0.88U PD=0.88U
* device instance _1356 r0 *1 622.6,795.86 nfet_05v0
XM_1356 VSS n_I2239 n_I2075 VSS nfet_05v0 L=0.6U W=0.36U AS=0.0936P AD=0.1584P
+ PS=0.88U PD=1.6U
* device instance _1357 r0 *1 599.13,798.17 pfet_05v0
XM_1357 n_I3064 n_I2208 VDD_DEC VDD_DEC pfet_05v0 L=0.5U W=1.22U AS=0.5368P
+ AD=0.3172P PS=3.32U PD=1.74U
* device instance _1358 r0 *1 600.15,798.17 pfet_05v0
XM_1358 n_I3063 n_I2211 n_I3064 VDD_DEC pfet_05v0 L=0.5U W=1.22U AS=0.3172P
+ AD=0.3782P PS=1.74U PD=1.84U
* device instance _1359 r0 *1 601.27,798.17 pfet_05v0
XM_1359 n_I3062 n_I2242 n_I3063 VDD_DEC pfet_05v0 L=0.5U W=1.22U AS=0.3782P
+ AD=0.3782P PS=1.84U PD=1.84U
* device instance _1360 r0 *1 602.39,798.17 pfet_05v0
XM_1360 n_I2212 n_I2239 n_I3062 VDD_DEC pfet_05v0 L=0.5U W=1.22U AS=0.3782P
+ AD=0.5368P PS=1.84U PD=3.32U
* device instance _1361 r0 *1 599.08,795.86 nfet_05v0
XM_1361 n_I2212 n_I2208 VSS VSS nfet_05v0 L=0.6U W=0.36U AS=0.1584P AD=0.0936P
+ PS=1.6U PD=0.88U
* device instance _1362 r0 *1 600.2,795.86 nfet_05v0
XM_1362 VSS n_I2211 n_I2212 VSS nfet_05v0 L=0.6U W=0.36U AS=0.0936P AD=0.0936P
+ PS=0.88U PD=0.88U
* device instance _1363 r0 *1 601.32,795.86 nfet_05v0
XM_1363 n_I2212 n_I2242 VSS VSS nfet_05v0 L=0.6U W=0.36U AS=0.0936P AD=0.0936P
+ PS=0.88U PD=0.88U
* device instance _1364 r0 *1 602.44,795.86 nfet_05v0
XM_1364 VSS n_I2239 n_I2212 VSS nfet_05v0 L=0.6U W=0.36U AS=0.0936P AD=0.1584P
+ PS=0.88U PD=1.6U
* device instance _1365 r0 *1 604.73,798.17 pfet_05v0
XM_1365 n_I3067 n_I2165 VDD_DEC VDD_DEC pfet_05v0 L=0.5U W=1.22U AS=0.5368P
+ AD=0.3172P PS=3.32U PD=1.74U
* device instance _1366 r0 *1 605.75,798.17 pfet_05v0
XM_1366 n_I3066 n_I2240 n_I3067 VDD_DEC pfet_05v0 L=0.5U W=1.22U AS=0.3172P
+ AD=0.3782P PS=1.74U PD=1.84U
* device instance _1367 r0 *1 606.87,798.17 pfet_05v0
XM_1367 n_I3065 n_I2242 n_I3066 VDD_DEC pfet_05v0 L=0.5U W=1.22U AS=0.3782P
+ AD=0.3782P PS=1.84U PD=1.84U
* device instance _1368 r0 *1 607.99,798.17 pfet_05v0
XM_1368 n_I2241 n_I2239 n_I3065 VDD_DEC pfet_05v0 L=0.5U W=1.22U AS=0.3782P
+ AD=0.5368P PS=1.84U PD=3.32U
* device instance _1369 r0 *1 604.68,795.86 nfet_05v0
XM_1369 n_I2241 n_I2165 VSS VSS nfet_05v0 L=0.6U W=0.36U AS=0.1584P AD=0.0936P
+ PS=1.6U PD=0.88U
* device instance _1370 r0 *1 605.8,795.86 nfet_05v0
XM_1370 VSS n_I2240 n_I2241 VSS nfet_05v0 L=0.6U W=0.36U AS=0.0936P AD=0.0936P
+ PS=0.88U PD=0.88U
* device instance _1371 r0 *1 606.92,795.86 nfet_05v0
XM_1371 n_I2241 n_I2242 VSS VSS nfet_05v0 L=0.6U W=0.36U AS=0.0936P AD=0.0936P
+ PS=0.88U PD=0.88U
* device instance _1372 r0 *1 608.04,795.86 nfet_05v0
XM_1372 VSS n_I2239 n_I2241 VSS nfet_05v0 L=0.6U W=0.36U AS=0.0936P AD=0.1584P
+ PS=0.88U PD=1.6U
* device instance _1373 r0 *1 592.41,798.17 pfet_05v0
XM_1373 n_I3070 n_I2204 VDD_DEC VDD_DEC pfet_05v0 L=0.5U W=1.22U AS=0.5368P
+ AD=0.3172P PS=3.32U PD=1.74U
* device instance _1374 r0 *1 593.43,798.17 pfet_05v0
XM_1374 n_I3069 n_I2172 n_I3070 VDD_DEC pfet_05v0 L=0.5U W=1.22U AS=0.3172P
+ AD=0.3782P PS=1.74U PD=1.84U
* device instance _1375 r0 *1 594.55,798.17 pfet_05v0
XM_1375 n_I3068 n_I2210 n_I3069 VDD_DEC pfet_05v0 L=0.5U W=1.22U AS=0.3782P
+ AD=0.3782P PS=1.84U PD=1.84U
* device instance _1376 r0 *1 595.67,798.17 pfet_05v0
XM_1376 n_I2166 n_I2252 n_I3068 VDD_DEC pfet_05v0 L=0.5U W=1.22U AS=0.3782P
+ AD=0.5368P PS=1.84U PD=3.32U
* device instance _1377 r0 *1 592.36,795.86 nfet_05v0
XM_1377 n_I2166 n_I2204 VSS VSS nfet_05v0 L=0.6U W=0.36U AS=0.1584P AD=0.0936P
+ PS=1.6U PD=0.88U
* device instance _1378 r0 *1 593.48,795.86 nfet_05v0
XM_1378 VSS n_I2172 n_I2166 VSS nfet_05v0 L=0.6U W=0.36U AS=0.0936P AD=0.0936P
+ PS=0.88U PD=0.88U
* device instance _1379 r0 *1 594.6,795.86 nfet_05v0
XM_1379 n_I2166 n_I2210 VSS VSS nfet_05v0 L=0.6U W=0.36U AS=0.0936P AD=0.0936P
+ PS=0.88U PD=0.88U
* device instance _1380 r0 *1 595.72,795.86 nfet_05v0
XM_1380 VSS n_I2252 n_I2166 VSS nfet_05v0 L=0.6U W=0.36U AS=0.0936P AD=0.1584P
+ PS=0.88U PD=1.6U
* device instance _1381 r0 *1 586.81,798.17 pfet_05v0
XM_1381 n_I3073 n_I2309 VDD_DEC VDD_DEC pfet_05v0 L=0.5U W=1.22U AS=0.5368P
+ AD=0.3172P PS=3.32U PD=1.74U
* device instance _1382 r0 *1 587.83,798.17 pfet_05v0
XM_1382 n_I3072 n_I2172 n_I3073 VDD_DEC pfet_05v0 L=0.5U W=1.22U AS=0.3172P
+ AD=0.3782P PS=1.74U PD=1.84U
* device instance _1383 r0 *1 588.95,798.17 pfet_05v0
XM_1383 n_I3071 n_I2210 n_I3072 VDD_DEC pfet_05v0 L=0.5U W=1.22U AS=0.3782P
+ AD=0.3782P PS=1.84U PD=1.84U
* device instance _1384 r0 *1 590.07,798.17 pfet_05v0
XM_1384 n_I2029 n_I2252 n_I3071 VDD_DEC pfet_05v0 L=0.5U W=1.22U AS=0.3782P
+ AD=0.5368P PS=1.84U PD=3.32U
* device instance _1385 r0 *1 586.76,795.86 nfet_05v0
XM_1385 n_I2029 n_I2309 VSS VSS nfet_05v0 L=0.6U W=0.36U AS=0.1584P AD=0.0936P
+ PS=1.6U PD=0.88U
* device instance _1386 r0 *1 587.88,795.86 nfet_05v0
XM_1386 VSS n_I2172 n_I2029 VSS nfet_05v0 L=0.6U W=0.36U AS=0.0936P AD=0.0936P
+ PS=0.88U PD=0.88U
* device instance _1387 r0 *1 589,795.86 nfet_05v0
XM_1387 n_I2029 n_I2210 VSS VSS nfet_05v0 L=0.6U W=0.36U AS=0.0936P AD=0.0936P
+ PS=0.88U PD=0.88U
* device instance _1388 r0 *1 590.12,795.86 nfet_05v0
XM_1388 VSS n_I2252 n_I2029 VSS nfet_05v0 L=0.6U W=0.36U AS=0.0936P AD=0.1584P
+ PS=0.88U PD=1.6U
* device instance _1389 r0 *1 510.09,813.85 pfet_05v0
XM_1389 n_I3076 n_I2362 VDD_DEC VDD_DEC pfet_05v0 L=0.5U W=1.22U AS=0.5368P
+ AD=0.3172P PS=3.32U PD=1.74U
* device instance _1390 r0 *1 511.11,813.85 pfet_05v0
XM_1390 n_I3075 n_I2196 n_I3076 VDD_DEC pfet_05v0 L=0.5U W=1.22U AS=0.3172P
+ AD=0.3782P PS=1.74U PD=1.84U
* device instance _1391 r0 *1 512.23,813.85 pfet_05v0
XM_1391 n_I3074 n_I2250 n_I3075 VDD_DEC pfet_05v0 L=0.5U W=1.22U AS=0.3782P
+ AD=0.3782P PS=1.84U PD=1.84U
* device instance _1392 r0 *1 513.35,813.85 pfet_05v0
XM_1392 n_I2125 n_I2195 n_I3074 VDD_DEC pfet_05v0 L=0.5U W=1.22U AS=0.3782P
+ AD=0.5368P PS=1.84U PD=3.32U
* device instance _1393 r0 *1 510.04,811.54 nfet_05v0
XM_1393 n_I2125 n_I2362 VSS VSS nfet_05v0 L=0.6U W=0.36U AS=0.1584P AD=0.0936P
+ PS=1.6U PD=0.88U
* device instance _1394 r0 *1 511.16,811.54 nfet_05v0
XM_1394 VSS n_I2196 n_I2125 VSS nfet_05v0 L=0.6U W=0.36U AS=0.0936P AD=0.0936P
+ PS=0.88U PD=0.88U
* device instance _1395 r0 *1 512.28,811.54 nfet_05v0
XM_1395 n_I2125 n_I2250 VSS VSS nfet_05v0 L=0.6U W=0.36U AS=0.0936P AD=0.0936P
+ PS=0.88U PD=0.88U
* device instance _1396 r0 *1 513.4,811.54 nfet_05v0
XM_1396 VSS n_I2195 n_I2125 VSS nfet_05v0 L=0.6U W=0.36U AS=0.0936P AD=0.1584P
+ PS=0.88U PD=1.6U
* device instance _1397 r0 *1 631.61,821.69 pfet_05v0
XM_1397 n_I3079 n_I2204 VDD_DEC VDD_DEC pfet_05v0 L=0.5U W=1.22U AS=0.5368P
+ AD=0.3172P PS=3.32U PD=1.74U
* device instance _1398 r0 *1 632.63,821.69 pfet_05v0
XM_1398 n_I3078 n_I2214 n_I3079 VDD_DEC pfet_05v0 L=0.5U W=1.22U AS=0.3172P
+ AD=0.3782P PS=1.74U PD=1.84U
* device instance _1399 r0 *1 633.75,821.69 pfet_05v0
XM_1399 n_I3077 n_I2287 n_I3078 VDD_DEC pfet_05v0 L=0.5U W=1.22U AS=0.3782P
+ AD=0.3782P PS=1.84U PD=1.84U
* device instance _1400 r0 *1 634.87,821.69 pfet_05v0
XM_1400 n_I2077 n_I2138 n_I3077 VDD_DEC pfet_05v0 L=0.5U W=1.22U AS=0.3782P
+ AD=0.5368P PS=1.84U PD=3.32U
* device instance _1401 r0 *1 631.56,819.38 nfet_05v0
XM_1401 n_I2077 n_I2204 VSS VSS nfet_05v0 L=0.6U W=0.36U AS=0.1584P AD=0.0936P
+ PS=1.6U PD=0.88U
* device instance _1402 r0 *1 632.68,819.38 nfet_05v0
XM_1402 VSS n_I2214 n_I2077 VSS nfet_05v0 L=0.6U W=0.36U AS=0.0936P AD=0.0936P
+ PS=0.88U PD=0.88U
* device instance _1403 r0 *1 633.8,819.38 nfet_05v0
XM_1403 n_I2077 n_I2287 VSS VSS nfet_05v0 L=0.6U W=0.36U AS=0.0936P AD=0.0936P
+ PS=0.88U PD=0.88U
* device instance _1404 r0 *1 634.92,819.38 nfet_05v0
XM_1404 VSS n_I2138 n_I2077 VSS nfet_05v0 L=0.6U W=0.36U AS=0.0936P AD=0.1584P
+ PS=0.88U PD=1.6U
* device instance _1405 r0 *1 496.09,806.01 pfet_05v0
XM_1405 n_I3082 n_I2323 VDD_DEC VDD_DEC pfet_05v0 L=0.5U W=1.22U AS=0.5368P
+ AD=0.3172P PS=3.32U PD=1.74U
* device instance _1406 r0 *1 497.11,806.01 pfet_05v0
XM_1406 n_I3081 n_I2196 n_I3082 VDD_DEC pfet_05v0 L=0.5U W=1.22U AS=0.3172P
+ AD=0.3782P PS=1.74U PD=1.84U
* device instance _1407 r0 *1 498.23,806.01 pfet_05v0
XM_1407 n_I3080 n_I2248 n_I3081 VDD_DEC pfet_05v0 L=0.5U W=1.22U AS=0.3782P
+ AD=0.3782P PS=1.84U PD=1.84U
* device instance _1408 r0 *1 499.35,806.01 pfet_05v0
XM_1408 n_I2271 n_I2195 n_I3080 VDD_DEC pfet_05v0 L=0.5U W=1.22U AS=0.3782P
+ AD=0.5368P PS=1.84U PD=3.32U
* device instance _1409 r0 *1 496.04,803.7 nfet_05v0
XM_1409 n_I2271 n_I2323 VSS VSS nfet_05v0 L=0.6U W=0.36U AS=0.1584P AD=0.0936P
+ PS=1.6U PD=0.88U
* device instance _1410 r0 *1 497.16,803.7 nfet_05v0
XM_1410 VSS n_I2196 n_I2271 VSS nfet_05v0 L=0.6U W=0.36U AS=0.0936P AD=0.0936P
+ PS=0.88U PD=0.88U
* device instance _1411 r0 *1 498.28,803.7 nfet_05v0
XM_1411 n_I2271 n_I2248 VSS VSS nfet_05v0 L=0.6U W=0.36U AS=0.0936P AD=0.0936P
+ PS=0.88U PD=0.88U
* device instance _1412 r0 *1 499.4,803.7 nfet_05v0
XM_1412 VSS n_I2195 n_I2271 VSS nfet_05v0 L=0.6U W=0.36U AS=0.0936P AD=0.1584P
+ PS=0.88U PD=1.6U
* device instance _1413 r0 *1 547.61,821.69 pfet_05v0
XM_1413 n_I3085 n_I2384 VDD_DEC VDD_DEC pfet_05v0 L=0.5U W=1.22U AS=0.5368P
+ AD=0.3172P PS=3.32U PD=1.74U
* device instance _1414 r0 *1 548.63,821.69 pfet_05v0
XM_1414 n_I3084 n_I2354 n_I3085 VDD_DEC pfet_05v0 L=0.5U W=1.22U AS=0.3172P
+ AD=0.3782P PS=1.74U PD=1.84U
* device instance _1415 r0 *1 549.75,821.69 pfet_05v0
XM_1415 n_I3083 n_I2322 n_I3084 VDD_DEC pfet_05v0 L=0.5U W=1.22U AS=0.3782P
+ AD=0.3782P PS=1.84U PD=1.84U
* device instance _1416 r0 *1 550.87,821.69 pfet_05v0
XM_1416 n_I2335 n_I2353 n_I3083 VDD_DEC pfet_05v0 L=0.5U W=1.22U AS=0.3782P
+ AD=0.5368P PS=1.84U PD=3.32U
* device instance _1417 r0 *1 547.56,819.38 nfet_05v0
XM_1417 n_I2335 n_I2384 VSS VSS nfet_05v0 L=0.6U W=0.36U AS=0.1584P AD=0.0936P
+ PS=1.6U PD=0.88U
* device instance _1418 r0 *1 548.68,819.38 nfet_05v0
XM_1418 VSS n_I2354 n_I2335 VSS nfet_05v0 L=0.6U W=0.36U AS=0.0936P AD=0.0936P
+ PS=0.88U PD=0.88U
* device instance _1419 r0 *1 549.8,819.38 nfet_05v0
XM_1419 n_I2335 n_I2322 VSS VSS nfet_05v0 L=0.6U W=0.36U AS=0.0936P AD=0.0936P
+ PS=0.88U PD=0.88U
* device instance _1420 r0 *1 550.92,819.38 nfet_05v0
XM_1420 VSS n_I2353 n_I2335 VSS nfet_05v0 L=0.6U W=0.36U AS=0.0936P AD=0.1584P
+ PS=0.88U PD=1.6U
* device instance _1421 r0 *1 522.41,821.69 pfet_05v0
XM_1421 n_I3088 n_I2330 VDD_DEC VDD_DEC pfet_05v0 L=0.5U W=1.22U AS=0.5368P
+ AD=0.3172P PS=3.32U PD=1.74U
* device instance _1422 r0 *1 523.43,821.69 pfet_05v0
XM_1422 n_I3087 n_I2199 n_I3088 VDD_DEC pfet_05v0 L=0.5U W=1.22U AS=0.3172P
+ AD=0.3782P PS=1.74U PD=1.84U
* device instance _1423 r0 *1 524.55,821.69 pfet_05v0
XM_1423 n_I3086 n_I2250 n_I3087 VDD_DEC pfet_05v0 L=0.5U W=1.22U AS=0.3782P
+ AD=0.3782P PS=1.84U PD=1.84U
* device instance _1424 r0 *1 525.67,821.69 pfet_05v0
XM_1424 n_I2055 n_I2200 n_I3086 VDD_DEC pfet_05v0 L=0.5U W=1.22U AS=0.3782P
+ AD=0.5368P PS=1.84U PD=3.32U
* device instance _1425 r0 *1 522.36,819.38 nfet_05v0
XM_1425 n_I2055 n_I2330 VSS VSS nfet_05v0 L=0.6U W=0.36U AS=0.1584P AD=0.0936P
+ PS=1.6U PD=0.88U
* device instance _1426 r0 *1 523.48,819.38 nfet_05v0
XM_1426 VSS n_I2199 n_I2055 VSS nfet_05v0 L=0.6U W=0.36U AS=0.0936P AD=0.0936P
+ PS=0.88U PD=0.88U
* device instance _1427 r0 *1 524.6,819.38 nfet_05v0
XM_1427 n_I2055 n_I2250 VSS VSS nfet_05v0 L=0.6U W=0.36U AS=0.0936P AD=0.0936P
+ PS=0.88U PD=0.88U
* device instance _1428 r0 *1 525.72,819.38 nfet_05v0
XM_1428 VSS n_I2200 n_I2055 VSS nfet_05v0 L=0.6U W=0.36U AS=0.0936P AD=0.1584P
+ PS=0.88U PD=1.6U
* device instance _1429 r0 *1 528.01,821.69 pfet_05v0
XM_1429 n_I3091 n_I2246 VDD_DEC VDD_DEC pfet_05v0 L=0.5U W=1.22U AS=0.5368P
+ AD=0.3172P PS=3.32U PD=1.74U
* device instance _1430 r0 *1 529.03,821.69 pfet_05v0
XM_1430 n_I3090 n_I2199 n_I3091 VDD_DEC pfet_05v0 L=0.5U W=1.22U AS=0.3172P
+ AD=0.3782P PS=1.74U PD=1.84U
* device instance _1431 r0 *1 530.15,821.69 pfet_05v0
XM_1431 n_I3089 n_I2250 n_I3090 VDD_DEC pfet_05v0 L=0.5U W=1.22U AS=0.3782P
+ AD=0.3782P PS=1.84U PD=1.84U
* device instance _1432 r0 *1 531.27,821.69 pfet_05v0
XM_1432 n_I2275 n_I2200 n_I3089 VDD_DEC pfet_05v0 L=0.5U W=1.22U AS=0.3782P
+ AD=0.5368P PS=1.84U PD=3.32U
* device instance _1433 r0 *1 527.96,819.38 nfet_05v0
XM_1433 n_I2275 n_I2246 VSS VSS nfet_05v0 L=0.6U W=0.36U AS=0.1584P AD=0.0936P
+ PS=1.6U PD=0.88U
* device instance _1434 r0 *1 529.08,819.38 nfet_05v0
XM_1434 VSS n_I2199 n_I2275 VSS nfet_05v0 L=0.6U W=0.36U AS=0.0936P AD=0.0936P
+ PS=0.88U PD=0.88U
* device instance _1435 r0 *1 530.2,819.38 nfet_05v0
XM_1435 n_I2275 n_I2250 VSS VSS nfet_05v0 L=0.6U W=0.36U AS=0.0936P AD=0.0936P
+ PS=0.88U PD=0.88U
* device instance _1436 r0 *1 531.32,819.38 nfet_05v0
XM_1436 VSS n_I2200 n_I2275 VSS nfet_05v0 L=0.6U W=0.36U AS=0.0936P AD=0.1584P
+ PS=0.88U PD=1.6U
* device instance _1437 r0 *1 639.45,829.53 pfet_05v0
XM_1437 n_I3094 n_I2165 VDD_DEC VDD_DEC pfet_05v0 L=0.5U W=1.22U AS=0.5368P
+ AD=0.3172P PS=3.32U PD=1.74U
* device instance _1438 r0 *1 640.47,829.53 pfet_05v0
XM_1438 n_I3093 n_I2176 n_I3094 VDD_DEC pfet_05v0 L=0.5U W=1.22U AS=0.3172P
+ AD=0.3782P PS=1.74U PD=1.84U
* device instance _1439 r0 *1 641.59,829.53 pfet_05v0
XM_1439 n_I3092 n_I2178 n_I3093 VDD_DEC pfet_05v0 L=0.5U W=1.22U AS=0.3782P
+ AD=0.3782P PS=1.84U PD=1.84U
* device instance _1440 r0 *1 642.71,829.53 pfet_05v0
XM_1440 n_I2425 n_I2177 n_I3092 VDD_DEC pfet_05v0 L=0.5U W=1.22U AS=0.3782P
+ AD=0.5368P PS=1.84U PD=3.32U
* device instance _1441 r0 *1 639.4,827.22 nfet_05v0
XM_1441 n_I2425 n_I2165 VSS VSS nfet_05v0 L=0.6U W=0.36U AS=0.1584P AD=0.0936P
+ PS=1.6U PD=0.88U
* device instance _1442 r0 *1 640.52,827.22 nfet_05v0
XM_1442 VSS n_I2176 n_I2425 VSS nfet_05v0 L=0.6U W=0.36U AS=0.0936P AD=0.0936P
+ PS=0.88U PD=0.88U
* device instance _1443 r0 *1 641.64,827.22 nfet_05v0
XM_1443 n_I2425 n_I2178 VSS VSS nfet_05v0 L=0.6U W=0.36U AS=0.0936P AD=0.0936P
+ PS=0.88U PD=0.88U
* device instance _1444 r0 *1 642.76,827.22 nfet_05v0
XM_1444 VSS n_I2177 n_I2425 VSS nfet_05v0 L=0.6U W=0.36U AS=0.0936P AD=0.1584P
+ PS=0.88U PD=1.6U
* device instance _1445 r0 *1 594.65,806.01 pfet_05v0
XM_1445 n_I3097 n_I2251 VDD_DEC VDD_DEC pfet_05v0 L=0.5U W=1.22U AS=0.5368P
+ AD=0.3172P PS=3.32U PD=1.74U
* device instance _1446 r0 *1 595.67,806.01 pfet_05v0
XM_1446 n_I3096 n_I2288 n_I3097 VDD_DEC pfet_05v0 L=0.5U W=1.22U AS=0.3172P
+ AD=0.3782P PS=1.74U PD=1.84U
* device instance _1447 r0 *1 596.79,806.01 pfet_05v0
XM_1447 n_I3095 n_I2284 n_I3096 VDD_DEC pfet_05v0 L=0.5U W=1.22U AS=0.3782P
+ AD=0.3782P PS=1.84U PD=1.84U
* device instance _1448 r0 *1 597.91,806.01 pfet_05v0
XM_1448 n_I2070 n_I2252 n_I3095 VDD_DEC pfet_05v0 L=0.5U W=1.22U AS=0.3782P
+ AD=0.5368P PS=1.84U PD=3.32U
* device instance _1449 r0 *1 594.6,803.7 nfet_05v0
XM_1449 n_I2070 n_I2251 VSS VSS nfet_05v0 L=0.6U W=0.36U AS=0.1584P AD=0.0936P
+ PS=1.6U PD=0.88U
* device instance _1450 r0 *1 595.72,803.7 nfet_05v0
XM_1450 VSS n_I2288 n_I2070 VSS nfet_05v0 L=0.6U W=0.36U AS=0.0936P AD=0.0936P
+ PS=0.88U PD=0.88U
* device instance _1451 r0 *1 596.84,803.7 nfet_05v0
XM_1451 n_I2070 n_I2284 VSS VSS nfet_05v0 L=0.6U W=0.36U AS=0.0936P AD=0.0936P
+ PS=0.88U PD=0.88U
* device instance _1452 r0 *1 597.96,803.7 nfet_05v0
XM_1452 VSS n_I2252 n_I2070 VSS nfet_05v0 L=0.6U W=0.36U AS=0.0936P AD=0.1584P
+ PS=0.88U PD=1.6U
* device instance _1453 r0 *1 657.37,821.69 pfet_05v0
XM_1453 n_I3100 n_I2274 VDD_DEC VDD_DEC pfet_05v0 L=0.5U W=1.22U AS=0.5368P
+ AD=0.3172P PS=3.32U PD=1.74U
* device instance _1454 r0 *1 658.39,821.69 pfet_05v0
XM_1454 n_I3099 n_I2176 n_I3100 VDD_DEC pfet_05v0 L=0.5U W=1.22U AS=0.3172P
+ AD=0.3782P PS=1.74U PD=1.84U
* device instance _1455 r0 *1 659.51,821.69 pfet_05v0
XM_1455 n_I3098 n_I2178 n_I3099 VDD_DEC pfet_05v0 L=0.5U W=1.22U AS=0.3782P
+ AD=0.3782P PS=1.84U PD=1.84U
* device instance _1456 r0 *1 660.63,821.69 pfet_05v0
XM_1456 n_I2386 n_I2177 n_I3098 VDD_DEC pfet_05v0 L=0.5U W=1.22U AS=0.3782P
+ AD=0.5368P PS=1.84U PD=3.32U
* device instance _1457 r0 *1 657.32,819.38 nfet_05v0
XM_1457 n_I2386 n_I2274 VSS VSS nfet_05v0 L=0.6U W=0.36U AS=0.1584P AD=0.0936P
+ PS=1.6U PD=0.88U
* device instance _1458 r0 *1 658.44,819.38 nfet_05v0
XM_1458 VSS n_I2176 n_I2386 VSS nfet_05v0 L=0.6U W=0.36U AS=0.0936P AD=0.0936P
+ PS=0.88U PD=0.88U
* device instance _1459 r0 *1 659.56,819.38 nfet_05v0
XM_1459 n_I2386 n_I2178 VSS VSS nfet_05v0 L=0.6U W=0.36U AS=0.0936P AD=0.0936P
+ PS=0.88U PD=0.88U
* device instance _1460 r0 *1 660.68,819.38 nfet_05v0
XM_1460 VSS n_I2177 n_I2386 VSS nfet_05v0 L=0.6U W=0.36U AS=0.0936P AD=0.1584P
+ PS=0.88U PD=1.6U
* device instance _1461 r0 *1 665.21,782.49 pfet_05v0
XM_1461 n_I3103 n_I2360 VDD_DEC VDD_DEC pfet_05v0 L=0.5U W=1.22U AS=0.5368P
+ AD=0.3172P PS=3.32U PD=1.74U
* device instance _1462 r0 *1 666.23,782.49 pfet_05v0
XM_1462 n_I3102 n_I2140 n_I3103 VDD_DEC pfet_05v0 L=0.5U W=1.22U AS=0.3172P
+ AD=0.3782P PS=1.74U PD=1.84U
* device instance _1463 r0 *1 667.35,782.49 pfet_05v0
XM_1463 n_I3101 n_I2178 n_I3102 VDD_DEC pfet_05v0 L=0.5U W=1.22U AS=0.3782P
+ AD=0.3782P PS=1.84U PD=1.84U
* device instance _1464 r0 *1 668.47,782.49 pfet_05v0
XM_1464 n_I2080 n_I2138 n_I3101 VDD_DEC pfet_05v0 L=0.5U W=1.22U AS=0.3782P
+ AD=0.5368P PS=1.84U PD=3.32U
* device instance _1465 r0 *1 665.16,780.18 nfet_05v0
XM_1465 n_I2080 n_I2360 VSS VSS nfet_05v0 L=0.6U W=0.36U AS=0.1584P AD=0.0936P
+ PS=1.6U PD=0.88U
* device instance _1466 r0 *1 666.28,780.18 nfet_05v0
XM_1466 VSS n_I2140 n_I2080 VSS nfet_05v0 L=0.6U W=0.36U AS=0.0936P AD=0.0936P
+ PS=0.88U PD=0.88U
* device instance _1467 r0 *1 667.4,780.18 nfet_05v0
XM_1467 n_I2080 n_I2178 VSS VSS nfet_05v0 L=0.6U W=0.36U AS=0.0936P AD=0.0936P
+ PS=0.88U PD=0.88U
* device instance _1468 r0 *1 668.52,780.18 nfet_05v0
XM_1468 VSS n_I2138 n_I2080 VSS nfet_05v0 L=0.6U W=0.36U AS=0.0936P AD=0.1584P
+ PS=0.88U PD=1.6U
* device instance _1469 m0 *1 488.96,784.39 pfet_05v0
XM_1469 VDD_DEC n_I3105 n_I3104 VDD_DEC pfet_05v0 L=1U W=1.22U AS=0.5368P
+ AD=0.5368P PS=3.32U PD=3.32U
* device instance _1470 m0 *1 488.96,786.61 nfet_05v0
XM_1470 n_I3105 n_I3104 VSS VSS nfet_05v0 L=1U W=0.82U AS=0.3608P AD=0.3608P
+ PS=2.52U PD=2.52U
* device instance _1471 m0 *1 488.96,776.55 pfet_05v0
XM_1471 VDD_DEC n_I3107 n_I3106 VDD_DEC pfet_05v0 L=1U W=1.22U AS=0.5368P
+ AD=0.5368P PS=3.32U PD=3.32U
* device instance _1472 m0 *1 488.96,778.77 nfet_05v0
XM_1472 n_I3107 n_I3106 VSS VSS nfet_05v0 L=1U W=0.82U AS=0.3608P AD=0.3608P
+ PS=2.52U PD=2.52U
* device instance _1473 m0 *1 642.4,784.39 pfet_05v0
XM_1473 VDD_DEC n_I3109 n_I3108 VDD_DEC pfet_05v0 L=1U W=1.22U AS=0.5368P
+ AD=0.5368P PS=3.32U PD=3.32U
* device instance _1474 m0 *1 642.4,786.61 nfet_05v0
XM_1474 n_I3109 n_I3108 VSS VSS nfet_05v0 L=1U W=0.82U AS=0.3608P AD=0.3608P
+ PS=2.52U PD=2.52U
* device instance _1475 m0 *1 626.16,815.75 pfet_05v0
XM_1475 VDD_DEC n_I3111 n_I3110 VDD_DEC pfet_05v0 L=1U W=1.22U AS=0.5368P
+ AD=0.5368P PS=3.32U PD=3.32U
* device instance _1476 m0 *1 626.16,817.97 nfet_05v0
XM_1476 n_I3111 n_I3110 VSS VSS nfet_05v0 L=1U W=0.82U AS=0.3608P AD=0.3608P
+ PS=2.52U PD=2.52U
* device instance _1477 m0 *1 580.24,823.59 pfet_05v0
XM_1477 VDD_DEC n_I3113 n_I3112 VDD_DEC pfet_05v0 L=1U W=1.22U AS=0.5368P
+ AD=0.5368P PS=3.32U PD=3.32U
* device instance _1478 m0 *1 580.24,825.81 nfet_05v0
XM_1478 n_I3113 n_I3112 VSS VSS nfet_05v0 L=1U W=0.82U AS=0.3608P AD=0.3608P
+ PS=2.52U PD=2.52U
* device instance _1479 m0 *1 642.4,831.43 pfet_05v0
XM_1479 VDD_DEC n_I3115 n_I3114 VDD_DEC pfet_05v0 L=1U W=1.22U AS=0.5368P
+ AD=0.5368P PS=3.32U PD=3.32U
* device instance _1480 m0 *1 642.4,833.65 nfet_05v0
XM_1480 n_I3115 n_I3114 VSS VSS nfet_05v0 L=1U W=0.82U AS=0.3608P AD=0.3608P
+ PS=2.52U PD=2.52U
* device instance _1481 m0 *1 615.52,792.23 pfet_05v0
XM_1481 VDD_DEC n_I3117 n_I3116 VDD_DEC pfet_05v0 L=1U W=1.22U AS=0.5368P
+ AD=0.5368P PS=3.32U PD=3.32U
* device instance _1482 m0 *1 615.52,794.45 nfet_05v0
XM_1482 n_I3117 n_I3116 VSS VSS nfet_05v0 L=1U W=0.82U AS=0.3608P AD=0.3608P
+ PS=2.52U PD=2.52U
* device instance _1483 m0 *1 540.48,815.75 pfet_05v0
XM_1483 VDD_DEC n_I3119 n_I3118 VDD_DEC pfet_05v0 L=1U W=1.22U AS=0.5368P
+ AD=0.5368P PS=3.32U PD=3.32U
* device instance _1484 m0 *1 540.48,817.97 nfet_05v0
XM_1484 n_I3119 n_I3118 VSS VSS nfet_05v0 L=1U W=0.82U AS=0.3608P AD=0.3608P
+ PS=2.52U PD=2.52U
* device instance _1485 m0 *1 590.88,807.91 pfet_05v0
XM_1485 VDD_DEC n_I3121 n_I3120 VDD_DEC pfet_05v0 L=1U W=1.22U AS=0.5368P
+ AD=0.5368P PS=3.32U PD=3.32U
* device instance _1486 m0 *1 590.88,810.13 nfet_05v0
XM_1486 n_I3121 n_I3120 VSS VSS nfet_05v0 L=1U W=0.82U AS=0.3608P AD=0.3608P
+ PS=2.52U PD=2.52U
* device instance _1487 m0 *1 615.52,807.91 pfet_05v0
XM_1487 VDD_DEC n_I3123 n_I3122 VDD_DEC pfet_05v0 L=1U W=1.22U AS=0.5368P
+ AD=0.5368P PS=3.32U PD=3.32U
* device instance _1488 m0 *1 615.52,810.13 nfet_05v0
XM_1488 n_I3123 n_I3122 VSS VSS nfet_05v0 L=1U W=0.82U AS=0.3608P AD=0.3608P
+ PS=2.52U PD=2.52U
* device instance _1489 m0 *1 509.12,815.75 pfet_05v0
XM_1489 VDD_DEC n_I3125 n_I3124 VDD_DEC pfet_05v0 L=1U W=1.22U AS=0.5368P
+ AD=0.5368P PS=3.32U PD=3.32U
* device instance _1490 m0 *1 509.12,817.97 nfet_05v0
XM_1490 n_I3125 n_I3124 VSS VSS nfet_05v0 L=1U W=0.82U AS=0.3608P AD=0.3608P
+ PS=2.52U PD=2.52U
* device instance _1491 m0 *1 670.4,784.39 pfet_05v0
XM_1491 VDD_DEC n_I3127 n_I3126 VDD_DEC pfet_05v0 L=1U W=1.22U AS=0.5368P
+ AD=0.5368P PS=3.32U PD=3.32U
* device instance _1492 m0 *1 670.4,786.61 nfet_05v0
XM_1492 n_I3127 n_I3126 VSS VSS nfet_05v0 L=1U W=0.82U AS=0.3608P AD=0.3608P
+ PS=2.52U PD=2.52U
* device instance _1493 m0 *1 620.56,823.59 pfet_05v0
XM_1493 VDD_DEC n_I3129 n_I3128 VDD_DEC pfet_05v0 L=1U W=1.22U AS=0.5368P
+ AD=0.5368P PS=3.32U PD=3.32U
* device instance _1494 m0 *1 620.56,825.81 nfet_05v0
XM_1494 n_I3129 n_I3128 VSS VSS nfet_05v0 L=1U W=0.82U AS=0.3608P AD=0.3608P
+ PS=2.52U PD=2.52U
* device instance _1495 m0 *1 567.36,792.23 pfet_05v0
XM_1495 VDD_DEC n_I3131 n_I3130 VDD_DEC pfet_05v0 L=1U W=1.22U AS=0.5368P
+ AD=0.5368P PS=3.32U PD=3.32U
* device instance _1496 m0 *1 567.36,794.45 nfet_05v0
XM_1496 n_I3131 n_I3130 VSS VSS nfet_05v0 L=1U W=0.82U AS=0.3608P AD=0.3608P
+ PS=2.52U PD=2.52U
* device instance _1497 m0 *1 603.2,831.43 pfet_05v0
XM_1497 VDD_DEC n_I3133 n_I3132 VDD_DEC pfet_05v0 L=1U W=1.22U AS=0.5368P
+ AD=0.5368P PS=3.32U PD=3.32U
* device instance _1498 m0 *1 603.2,833.65 nfet_05v0
XM_1498 n_I3133 n_I3132 VSS VSS nfet_05v0 L=1U W=0.82U AS=0.3608P AD=0.3608P
+ PS=2.52U PD=2.52U
* device instance _1499 m0 *1 606.56,800.07 pfet_05v0
XM_1499 VDD_DEC n_I3135 n_I3134 VDD_DEC pfet_05v0 L=1U W=1.22U AS=0.5368P
+ AD=0.5368P PS=3.32U PD=3.32U
* device instance _1500 m0 *1 606.56,802.29 nfet_05v0
XM_1500 n_I3135 n_I3134 VSS VSS nfet_05v0 L=1U W=0.82U AS=0.3608P AD=0.3608P
+ PS=2.52U PD=2.52U
* device instance _1501 m0 *1 602.08,800.07 pfet_05v0
XM_1501 VDD_DEC n_I3137 n_I3136 VDD_DEC pfet_05v0 L=1U W=1.22U AS=0.5368P
+ AD=0.5368P PS=3.32U PD=3.32U
* device instance _1502 m0 *1 602.08,802.29 nfet_05v0
XM_1502 n_I3137 n_I3136 VSS VSS nfet_05v0 L=1U W=0.82U AS=0.3608P AD=0.3608P
+ PS=2.52U PD=2.52U
* device instance _1503 m0 *1 488.96,792.23 pfet_05v0
XM_1503 VDD_DEC n_I3139 n_I3138 VDD_DEC pfet_05v0 L=1U W=1.22U AS=0.5368P
+ AD=0.5368P PS=3.32U PD=3.32U
* device instance _1504 m0 *1 488.96,794.45 nfet_05v0
XM_1504 n_I3139 n_I3138 VSS VSS nfet_05v0 L=1U W=0.82U AS=0.3608P AD=0.3608P
+ PS=2.52U PD=2.52U
* device instance _1505 m0 *1 488.96,800.07 pfet_05v0
XM_1505 VDD_DEC n_I3141 n_I3140 VDD_DEC pfet_05v0 L=1U W=1.22U AS=0.5368P
+ AD=0.5368P PS=3.32U PD=3.32U
* device instance _1506 m0 *1 488.96,802.29 nfet_05v0
XM_1506 n_I3141 n_I3140 VSS VSS nfet_05v0 L=1U W=0.82U AS=0.3608P AD=0.3608P
+ PS=2.52U PD=2.52U
* device instance _1507 m0 *1 543.28,831.43 pfet_05v0
XM_1507 VDD_DEC n_I3143 n_I3142 VDD_DEC pfet_05v0 L=1U W=1.22U AS=0.5368P
+ AD=0.5368P PS=3.32U PD=3.32U
* device instance _1508 m0 *1 543.28,833.65 nfet_05v0
XM_1508 n_I3143 n_I3142 VSS VSS nfet_05v0 L=1U W=0.82U AS=0.3608P AD=0.3608P
+ PS=2.52U PD=2.52U
* device instance _1509 m0 *1 528.16,800.07 pfet_05v0
XM_1509 VDD_DEC n_I3145 n_I3144 VDD_DEC pfet_05v0 L=1U W=1.22U AS=0.5368P
+ AD=0.5368P PS=3.32U PD=3.32U
* device instance _1510 m0 *1 528.16,802.29 nfet_05v0
XM_1510 n_I3145 n_I3144 VSS VSS nfet_05v0 L=1U W=0.82U AS=0.3608P AD=0.3608P
+ PS=2.52U PD=2.52U
* device instance _1511 m0 *1 642.4,776.55 pfet_05v0
XM_1511 VDD_DEC n_I3147 n_I3146 VDD_DEC pfet_05v0 L=1U W=1.22U AS=0.5368P
+ AD=0.5368P PS=3.32U PD=3.32U
* device instance _1512 m0 *1 642.4,778.77 nfet_05v0
XM_1512 n_I3147 n_I3146 VSS VSS nfet_05v0 L=1U W=0.82U AS=0.3608P AD=0.3608P
+ PS=2.52U PD=2.52U
* device instance _1513 m0 *1 528.16,776.55 pfet_05v0
XM_1513 VDD_DEC n_I3149 n_I3148 VDD_DEC pfet_05v0 L=1U W=1.22U AS=0.5368P
+ AD=0.5368P PS=3.32U PD=3.32U
* device instance _1514 m0 *1 528.16,778.77 nfet_05v0
XM_1514 n_I3149 n_I3148 VSS VSS nfet_05v0 L=1U W=0.82U AS=0.3608P AD=0.3608P
+ PS=2.52U PD=2.52U
* device instance _1515 m0 *1 506.88,831.43 pfet_05v0
XM_1515 VDD_DEC n_I3151 n_I3150 VDD_DEC pfet_05v0 L=1U W=1.22U AS=0.5368P
+ AD=0.5368P PS=3.32U PD=3.32U
* device instance _1516 m0 *1 506.88,833.65 nfet_05v0
XM_1516 n_I3151 n_I3150 VSS VSS nfet_05v0 L=1U W=0.82U AS=0.3608P AD=0.3608P
+ PS=2.52U PD=2.52U
* device instance _1517 m0 *1 528.16,784.39 pfet_05v0
XM_1517 VDD_DEC n_I3153 n_I3152 VDD_DEC pfet_05v0 L=1U W=1.22U AS=0.5368P
+ AD=0.5368P PS=3.32U PD=3.32U
* device instance _1518 m0 *1 528.16,786.61 nfet_05v0
XM_1518 n_I3153 n_I3152 VSS VSS nfet_05v0 L=1U W=0.82U AS=0.3608P AD=0.3608P
+ PS=2.52U PD=2.52U
* device instance _1519 m0 *1 524.8,823.59 pfet_05v0
XM_1519 VDD_DEC n_I3155 n_I3154 VDD_DEC pfet_05v0 L=1U W=1.22U AS=0.5368P
+ AD=0.5368P PS=3.32U PD=3.32U
* device instance _1520 m0 *1 524.8,825.81 nfet_05v0
XM_1520 n_I3155 n_I3154 VSS VSS nfet_05v0 L=1U W=0.82U AS=0.3608P AD=0.3608P
+ PS=2.52U PD=2.52U
* device instance _1521 r0 *1 670.96,806.01 pfet_05v0
XM_1521 VDD_DEC n_I3157 n_I3156 VDD_DEC pfet_05v0 L=1U W=1.22U AS=0.5368P
+ AD=0.5368P PS=3.32U PD=3.32U
* device instance _1522 r0 *1 670.96,803.79 nfet_05v0
XM_1522 n_I3157 n_I3156 VSS VSS nfet_05v0 L=1U W=0.82U AS=0.3608P AD=0.3608P
+ PS=2.52U PD=2.52U
* device instance _1523 r0 *1 592.56,806.01 pfet_05v0
XM_1523 VDD_DEC n_I3159 n_I3158 VDD_DEC pfet_05v0 L=1U W=1.22U AS=0.5368P
+ AD=0.5368P PS=3.32U PD=3.32U
* device instance _1524 r0 *1 592.56,803.79 nfet_05v0
XM_1524 n_I3159 n_I3158 VSS VSS nfet_05v0 L=1U W=0.82U AS=0.3608P AD=0.3608P
+ PS=2.52U PD=2.52U
* device instance _1525 r0 *1 669.84,813.85 pfet_05v0
XM_1525 VDD_DEC n_I3161 n_I3160 VDD_DEC pfet_05v0 L=1U W=1.22U AS=0.5368P
+ AD=0.5368P PS=3.32U PD=3.32U
* device instance _1526 r0 *1 669.84,811.63 nfet_05v0
XM_1526 n_I3161 n_I3160 VSS VSS nfet_05v0 L=1U W=0.82U AS=0.3608P AD=0.3608P
+ PS=2.52U PD=2.52U
* device instance _1527 r0 *1 600.4,806.01 pfet_05v0
XM_1527 VDD_DEC n_I3163 n_I3162 VDD_DEC pfet_05v0 L=1U W=1.22U AS=0.5368P
+ AD=0.5368P PS=3.32U PD=3.32U
* device instance _1528 r0 *1 600.4,803.79 nfet_05v0
XM_1528 n_I3163 n_I3162 VSS VSS nfet_05v0 L=1U W=0.82U AS=0.3608P AD=0.3608P
+ PS=2.52U PD=2.52U
* device instance _1529 r0 *1 493.44,821.69 pfet_05v0
XM_1529 VDD_DEC n_I3165 n_I3164 VDD_DEC pfet_05v0 L=1U W=1.22U AS=0.5368P
+ AD=0.5368P PS=3.32U PD=3.32U
* device instance _1530 r0 *1 493.44,819.47 nfet_05v0
XM_1530 n_I3165 n_I3164 VSS VSS nfet_05v0 L=1U W=0.82U AS=0.3608P AD=0.3608P
+ PS=2.52U PD=2.52U
* device instance _1531 r0 *1 564.56,806.01 pfet_05v0
XM_1531 VDD_DEC n_I3167 n_I3166 VDD_DEC pfet_05v0 L=1U W=1.22U AS=0.5368P
+ AD=0.5368P PS=3.32U PD=3.32U
* device instance _1532 r0 *1 564.56,803.79 nfet_05v0
XM_1532 n_I3167 n_I3166 VSS VSS nfet_05v0 L=1U W=0.82U AS=0.3608P AD=0.3608P
+ PS=2.52U PD=2.52U
* device instance _1533 r0 *1 622.24,813.85 pfet_05v0
XM_1533 VDD_DEC n_I3169 n_I3168 VDD_DEC pfet_05v0 L=1U W=1.22U AS=0.5368P
+ AD=0.5368P PS=3.32U PD=3.32U
* device instance _1534 r0 *1 622.24,811.63 nfet_05v0
XM_1534 n_I3169 n_I3168 VSS VSS nfet_05v0 L=1U W=0.82U AS=0.3608P AD=0.3608P
+ PS=2.52U PD=2.52U
* device instance _1535 r0 *1 660.32,837.37 pfet_05v0
XM_1535 VDD_DEC n_I3171 n_I3170 VDD_DEC pfet_05v0 L=1U W=1.22U AS=0.5368P
+ AD=0.5368P PS=3.32U PD=3.32U
* device instance _1536 r0 *1 660.32,835.15 nfet_05v0
XM_1536 n_I3171 n_I3170 VSS VSS nfet_05v0 L=1U W=0.82U AS=0.3608P AD=0.3608P
+ PS=2.52U PD=2.52U
* device instance _1537 r0 *1 669.84,829.53 pfet_05v0
XM_1537 VDD_DEC n_I3173 n_I3172 VDD_DEC pfet_05v0 L=1U W=1.22U AS=0.5368P
+ AD=0.5368P PS=3.32U PD=3.32U
* device instance _1538 r0 *1 669.84,827.31 nfet_05v0
XM_1538 n_I3173 n_I3172 VSS VSS nfet_05v0 L=1U W=0.82U AS=0.3608P AD=0.3608P
+ PS=2.52U PD=2.52U
* device instance _1539 r0 *1 616.64,821.69 pfet_05v0
XM_1539 VDD_DEC n_I3175 n_I3174 VDD_DEC pfet_05v0 L=1U W=1.22U AS=0.5368P
+ AD=0.5368P PS=3.32U PD=3.32U
* device instance _1540 r0 *1 616.64,819.47 nfet_05v0
XM_1540 n_I3175 n_I3174 VSS VSS nfet_05v0 L=1U W=0.82U AS=0.3608P AD=0.3608P
+ PS=2.52U PD=2.52U
* device instance _1541 r0 *1 618.32,837.37 pfet_05v0
XM_1541 VDD_DEC n_I3177 n_I3176 VDD_DEC pfet_05v0 L=1U W=1.22U AS=0.5368P
+ AD=0.5368P PS=3.32U PD=3.32U
* device instance _1542 r0 *1 618.32,835.15 nfet_05v0
XM_1542 n_I3177 n_I3176 VSS VSS nfet_05v0 L=1U W=0.82U AS=0.3608P AD=0.3608P
+ PS=2.52U PD=2.52U
* device instance _1543 r0 *1 590.32,821.69 pfet_05v0
XM_1543 VDD_DEC n_I3179 n_I3178 VDD_DEC pfet_05v0 L=1U W=1.22U AS=0.5368P
+ AD=0.5368P PS=3.32U PD=3.32U
* device instance _1544 r0 *1 590.32,819.47 nfet_05v0
XM_1544 n_I3179 n_I3178 VSS VSS nfet_05v0 L=1U W=0.82U AS=0.3608P AD=0.3608P
+ PS=2.52U PD=2.52U
* device instance _1545 r0 *1 621.68,829.53 pfet_05v0
XM_1545 VDD_DEC n_I3181 n_I3180 VDD_DEC pfet_05v0 L=1U W=1.22U AS=0.5368P
+ AD=0.5368P PS=3.32U PD=3.32U
* device instance _1546 r0 *1 621.68,827.31 nfet_05v0
XM_1546 n_I3181 n_I3180 VSS VSS nfet_05v0 L=1U W=0.82U AS=0.3608P AD=0.3608P
+ PS=2.52U PD=2.52U
* device instance _1547 r0 *1 614.96,829.53 pfet_05v0
XM_1547 VDD_DEC n_I3183 n_I3182 VDD_DEC pfet_05v0 L=1U W=1.22U AS=0.5368P
+ AD=0.5368P PS=3.32U PD=3.32U
* device instance _1548 r0 *1 614.96,827.31 nfet_05v0
XM_1548 n_I3183 n_I3182 VSS VSS nfet_05v0 L=1U W=0.82U AS=0.3608P AD=0.3608P
+ PS=2.52U PD=2.52U
* device instance _1549 r0 *1 669.84,821.69 pfet_05v0
XM_1549 VDD_DEC n_I3185 n_I3184 VDD_DEC pfet_05v0 L=1U W=1.22U AS=0.5368P
+ AD=0.5368P PS=3.32U PD=3.32U
* device instance _1550 r0 *1 669.84,819.47 nfet_05v0
XM_1550 n_I3185 n_I3184 VSS VSS nfet_05v0 L=1U W=0.82U AS=0.3608P AD=0.3608P
+ PS=2.52U PD=2.52U
* device instance _1551 r0 *1 556.72,806.01 pfet_05v0
XM_1551 VDD_DEC n_I3187 n_I3186 VDD_DEC pfet_05v0 L=1U W=1.22U AS=0.5368P
+ AD=0.5368P PS=3.32U PD=3.32U
* device instance _1552 r0 *1 556.72,803.79 nfet_05v0
XM_1552 n_I3187 n_I3186 VSS VSS nfet_05v0 L=1U W=0.82U AS=0.3608P AD=0.3608P
+ PS=2.52U PD=2.52U
* device instance _1553 r0 *1 547.76,790.33 pfet_05v0
XM_1553 VDD_DEC n_I3189 n_I3188 VDD_DEC pfet_05v0 L=1U W=1.22U AS=0.5368P
+ AD=0.5368P PS=3.32U PD=3.32U
* device instance _1554 r0 *1 547.76,788.11 nfet_05v0
XM_1554 n_I3189 n_I3188 VSS VSS nfet_05v0 L=1U W=0.82U AS=0.3608P AD=0.3608P
+ PS=2.52U PD=2.52U
* device instance _1555 r0 *1 586.96,782.49 pfet_05v0
XM_1555 VDD_DEC n_I3191 n_I3190 VDD_DEC pfet_05v0 L=1U W=1.22U AS=0.5368P
+ AD=0.5368P PS=3.32U PD=3.32U
* device instance _1556 r0 *1 586.96,780.27 nfet_05v0
XM_1556 n_I3191 n_I3190 VSS VSS nfet_05v0 L=1U W=0.82U AS=0.3608P AD=0.3608P
+ PS=2.52U PD=2.52U
* device instance _1557 r0 *1 582.48,798.17 pfet_05v0
XM_1557 VDD_DEC n_I3193 n_I3192 VDD_DEC pfet_05v0 L=1U W=1.22U AS=0.5368P
+ AD=0.5368P PS=3.32U PD=3.32U
* device instance _1558 r0 *1 582.48,795.95 nfet_05v0
XM_1558 n_I3193 n_I3192 VSS VSS nfet_05v0 L=1U W=0.82U AS=0.3608P AD=0.3608P
+ PS=2.52U PD=2.52U
* device instance _1559 r0 *1 670.96,798.17 pfet_05v0
XM_1559 VDD_DEC n_I3195 n_I3194 VDD_DEC pfet_05v0 L=1U W=1.22U AS=0.5368P
+ AD=0.5368P PS=3.32U PD=3.32U
* device instance _1560 r0 *1 670.96,795.95 nfet_05v0
XM_1560 n_I3195 n_I3194 VSS VSS nfet_05v0 L=1U W=0.82U AS=0.3608P AD=0.3608P
+ PS=2.52U PD=2.52U
* device instance _1561 r0 *1 669.28,774.65 pfet_05v0
XM_1561 VDD_DEC n_I3197 n_I3196 VDD_DEC pfet_05v0 L=1U W=1.22U AS=0.5368P
+ AD=0.5368P PS=3.32U PD=3.32U
* device instance _1562 r0 *1 669.28,772.43 nfet_05v0
XM_1562 n_I3197 n_I3196 VSS VSS nfet_05v0 L=1U W=0.82U AS=0.3608P AD=0.3608P
+ PS=2.52U PD=2.52U
* device instance _1563 r0 *1 662,782.49 pfet_05v0
XM_1563 VDD_DEC n_I3199 n_I3198 VDD_DEC pfet_05v0 L=1U W=1.22U AS=0.5368P
+ AD=0.5368P PS=3.32U PD=3.32U
* device instance _1564 r0 *1 662,780.27 nfet_05v0
XM_1564 n_I3199 n_I3198 VSS VSS nfet_05v0 L=1U W=0.82U AS=0.3608P AD=0.3608P
+ PS=2.52U PD=2.52U
* device instance _1565 r0 *1 508.56,829.53 pfet_05v0
XM_1565 VDD_DEC n_I3201 n_I3200 VDD_DEC pfet_05v0 L=1U W=1.22U AS=0.5368P
+ AD=0.5368P PS=3.32U PD=3.32U
* device instance _1566 r0 *1 508.56,827.31 nfet_05v0
XM_1566 n_I3201 n_I3200 VSS VSS nfet_05v0 L=1U W=0.82U AS=0.3608P AD=0.3608P
+ PS=2.52U PD=2.52U
* device instance _1567 r0 *1 493.44,837.37 pfet_05v0
XM_1567 VDD_DEC n_I3203 n_I3202 VDD_DEC pfet_05v0 L=1U W=1.22U AS=0.5368P
+ AD=0.5368P PS=3.32U PD=3.32U
* device instance _1568 r0 *1 493.44,835.15 nfet_05v0
XM_1568 n_I3203 n_I3202 VSS VSS nfet_05v0 L=1U W=0.82U AS=0.3608P AD=0.3608P
+ PS=2.52U PD=2.52U
* device instance _1569 r0 *1 592.56,790.33 pfet_05v0
XM_1569 VDD_DEC n_I3205 n_I3204 VDD_DEC pfet_05v0 L=1U W=1.22U AS=0.5368P
+ AD=0.5368P PS=3.32U PD=3.32U
* device instance _1570 r0 *1 592.56,788.11 nfet_05v0
XM_1570 n_I3205 n_I3204 VSS VSS nfet_05v0 L=1U W=0.82U AS=0.3608P AD=0.3608P
+ PS=2.52U PD=2.52U
* device instance _1571 r0 *1 508.56,790.33 pfet_05v0
XM_1571 VDD_DEC n_I3207 n_I3206 VDD_DEC pfet_05v0 L=1U W=1.22U AS=0.5368P
+ AD=0.5368P PS=3.32U PD=3.32U
* device instance _1572 r0 *1 508.56,788.11 nfet_05v0
XM_1572 n_I3207 n_I3206 VSS VSS nfet_05v0 L=1U W=0.82U AS=0.3608P AD=0.3608P
+ PS=2.52U PD=2.52U
* device instance _1573 r0 *1 644.08,790.33 pfet_05v0
XM_1573 VDD_DEC n_I3209 n_I3208 VDD_DEC pfet_05v0 L=1U W=1.22U AS=0.5368P
+ AD=0.5368P PS=3.32U PD=3.32U
* device instance _1574 r0 *1 644.08,788.11 nfet_05v0
XM_1574 n_I3209 n_I3208 VSS VSS nfet_05v0 L=1U W=0.82U AS=0.3608P AD=0.3608P
+ PS=2.52U PD=2.52U
* device instance _1575 r0 *1 508.56,782.49 pfet_05v0
XM_1575 VDD_DEC n_I3211 n_I3210 VDD_DEC pfet_05v0 L=1U W=1.22U AS=0.5368P
+ AD=0.5368P PS=3.32U PD=3.32U
* device instance _1576 r0 *1 508.56,780.27 nfet_05v0
XM_1576 n_I3211 n_I3210 VSS VSS nfet_05v0 L=1U W=0.82U AS=0.3608P AD=0.3608P
+ PS=2.52U PD=2.52U
* device instance _1577 r0 *1 550.56,837.37 pfet_05v0
XM_1577 VDD_DEC n_I3213 n_I3212 VDD_DEC pfet_05v0 L=1U W=1.22U AS=0.5368P
+ AD=0.5368P PS=3.32U PD=3.32U
* device instance _1578 r0 *1 550.56,835.15 nfet_05v0
XM_1578 n_I3213 n_I3212 VSS VSS nfet_05v0 L=1U W=0.82U AS=0.3608P AD=0.3608P
+ PS=2.52U PD=2.52U
* device instance _1579 r0 *1 488.96,798.17 pfet_05v0
XM_1579 VDD_DEC n_I3215 n_I3214 VDD_DEC pfet_05v0 L=1U W=1.22U AS=0.5368P
+ AD=0.5368P PS=3.32U PD=3.32U
* device instance _1580 r0 *1 488.96,795.95 nfet_05v0
XM_1580 n_I3215 n_I3214 VSS VSS nfet_05v0 L=1U W=0.82U AS=0.3608P AD=0.3608P
+ PS=2.52U PD=2.52U
* device instance _1581 r0 *1 670.96,782.49 pfet_05v0
XM_1581 VDD_DEC n_I3217 n_I3216 VDD_DEC pfet_05v0 L=1U W=1.22U AS=0.5368P
+ AD=0.5368P PS=3.32U PD=3.32U
* device instance _1582 r0 *1 670.96,780.27 nfet_05v0
XM_1582 n_I3217 n_I3216 VSS VSS nfet_05v0 L=1U W=0.82U AS=0.3608P AD=0.3608P
+ PS=2.52U PD=2.52U
* device instance _1583 r0 *1 571.28,829.53 pfet_05v0
XM_1583 VDD_DEC n_I3219 n_I3218 VDD_DEC pfet_05v0 L=1U W=1.22U AS=0.5368P
+ AD=0.5368P PS=3.32U PD=3.32U
* device instance _1584 r0 *1 571.28,827.31 nfet_05v0
XM_1584 n_I3219 n_I3218 VSS VSS nfet_05v0 L=1U W=0.82U AS=0.3608P AD=0.3608P
+ PS=2.52U PD=2.52U
* device instance _1585 r0 *1 547.76,782.49 pfet_05v0
XM_1585 VDD_DEC n_I3221 n_I3220 VDD_DEC pfet_05v0 L=1U W=1.22U AS=0.5368P
+ AD=0.5368P PS=3.32U PD=3.32U
* device instance _1586 r0 *1 547.76,780.27 nfet_05v0
XM_1586 n_I3221 n_I3220 VSS VSS nfet_05v0 L=1U W=0.82U AS=0.3608P AD=0.3608P
+ PS=2.52U PD=2.52U
* device instance _1587 r0 *1 571.28,821.69 pfet_05v0
XM_1587 VDD_DEC n_I3223 n_I3222 VDD_DEC pfet_05v0 L=1U W=1.22U AS=0.5368P
+ AD=0.5368P PS=3.32U PD=3.32U
* device instance _1588 r0 *1 571.28,819.47 nfet_05v0
XM_1588 n_I3223 n_I3222 VSS VSS nfet_05v0 L=1U W=0.82U AS=0.3608P AD=0.3608P
+ PS=2.52U PD=2.52U
* device instance _1589 r0 *1 670.96,790.33 pfet_05v0
XM_1589 VDD_DEC n_I3225 n_I3224 VDD_DEC pfet_05v0 L=1U W=1.22U AS=0.5368P
+ AD=0.5368P PS=3.32U PD=3.32U
* device instance _1590 r0 *1 670.96,788.11 nfet_05v0
XM_1590 n_I3225 n_I3224 VSS VSS nfet_05v0 L=1U W=0.82U AS=0.3608P AD=0.3608P
+ PS=2.52U PD=2.52U
* device instance _1591 r0 *1 544.4,821.69 pfet_05v0
XM_1591 VDD_DEC n_I3227 n_I3226 VDD_DEC pfet_05v0 L=1U W=1.22U AS=0.5368P
+ AD=0.5368P PS=3.32U PD=3.32U
* device instance _1592 r0 *1 544.4,819.47 nfet_05v0
XM_1592 n_I3227 n_I3226 VSS VSS nfet_05v0 L=1U W=0.82U AS=0.3608P AD=0.3608P
+ PS=2.52U PD=2.52U
* device instance _1593 r0 *1 584.16,774.65 pfet_05v0
XM_1593 VDD_DEC n_I3229 n_I3228 VDD_DEC pfet_05v0 L=1U W=1.22U AS=0.5368P
+ AD=0.5368P PS=3.32U PD=3.32U
* device instance _1594 r0 *1 584.16,772.43 nfet_05v0
XM_1594 n_I3229 n_I3228 VSS VSS nfet_05v0 L=1U W=0.82U AS=0.3608P AD=0.3608P
+ PS=2.52U PD=2.52U
* device instance _1595 r0 *1 502.745,798.49 pfet_05v0
XM_1595 n_I3236 n_I3231 n_I3232 VDD_DEC pfet_05v0 L=0.5U W=0.36U AS=0.3456P
+ AD=0.0612P PS=2.64U PD=0.7U
* device instance _1596 r0 *1 503.585,798.49 pfet_05v0
XM_1596 n_I3236 n_I3231 VDD_DEC VDD_DEC pfet_05v0 L=0.5U W=0.36U AS=0.379P
+ AD=0.0612P PS=2.37U PD=0.7U
* device instance _1597 r0 *1 505.235,798.17 pfet_05v0
XM_1597 n_266 n_I3232 VDD_DEC VDD_DEC pfet_05v0 L=0.5U W=1.22U AS=0.379P
+ AD=0.5368P PS=2.37U PD=3.32U
* device instance _1598 r0 *1 498.505,798.6 pfet_05v0
XM_1598 VDD_DEC n_I2247 n_I3230 VDD_DEC pfet_05v0 L=0.5U W=0.36U AS=0.3852P
+ AD=0.1116P PS=2.86U PD=0.98U
* device instance _1599 r0 *1 499.625,798.6 pfet_05v0
XM_1599 n_I3235 n_I3230 VDD_DEC VDD_DEC pfet_05v0 L=0.5U W=0.36U AS=0.1116P
+ AD=0.0612P PS=0.98U PD=0.7U
* device instance _1600 r0 *1 500.465,798.6 pfet_05v0
XM_1600 n_I3235 n_I3230 n_I3231 VDD_DEC pfet_05v0 L=0.5U W=0.36U AS=0.3852P
+ AD=0.0612P PS=2.86U PD=0.7U
* device instance _1601 r0 *1 502.795,795.722 nfet_05v0
XM_1601 n_I3234 n_I3231 n_I3232 VSS nfet_05v0 L=0.6U W=0.365U AS=0.3705P
+ AD=0.0438P PS=2.77U PD=0.605U
* device instance _1602 r0 *1 503.635,795.722 nfet_05v0
XM_1602 VSS n_I3231 n_I3234 VSS nfet_05v0 L=0.6U W=0.365U AS=0.0438P
+ AD=0.282625P PS=0.605U PD=1.87U
* device instance _1603 r0 *1 505.285,795.95 nfet_05v0
XM_1603 n_266 n_I3232 VSS VSS nfet_05v0 L=0.6U W=0.82U AS=0.282625P AD=0.3608P
+ PS=1.87U PD=2.52U
* device instance _1604 r0 *1 498.555,795.72 nfet_05v0
XM_1604 VSS n_I2247 n_I3230 VSS nfet_05v0 L=0.6U W=0.36U AS=0.333P AD=0.0936P
+ PS=2.57U PD=0.88U
* device instance _1605 r0 *1 499.675,795.72 nfet_05v0
XM_1605 n_I3233 n_I3230 VSS VSS nfet_05v0 L=0.6U W=0.36U AS=0.0936P AD=0.0432P
+ PS=0.88U PD=0.6U
* device instance _1606 r0 *1 500.515,795.72 nfet_05v0
XM_1606 n_I3231 n_I3230 n_I3233 VSS nfet_05v0 L=0.6U W=0.36U AS=0.0432P
+ AD=0.369P PS=0.6U PD=2.77U
* device instance _1607 r0 *1 515.065,806.33 pfet_05v0
XM_1607 n_I3243 n_I3238 n_I3239 VDD_DEC pfet_05v0 L=0.5U W=0.36U AS=0.3456P
+ AD=0.0612P PS=2.64U PD=0.7U
* device instance _1608 r0 *1 515.905,806.33 pfet_05v0
XM_1608 n_I3243 n_I3238 VDD_DEC VDD_DEC pfet_05v0 L=0.5U W=0.36U AS=0.379P
+ AD=0.0612P PS=2.37U PD=0.7U
* device instance _1609 r0 *1 517.555,806.01 pfet_05v0
XM_1609 n_269 n_I3239 VDD_DEC VDD_DEC pfet_05v0 L=0.5U W=1.22U AS=0.379P
+ AD=0.5368P PS=2.37U PD=3.32U
* device instance _1610 r0 *1 510.825,806.44 pfet_05v0
XM_1610 VDD_DEC n_I2307 n_I3237 VDD_DEC pfet_05v0 L=0.5U W=0.36U AS=0.3852P
+ AD=0.1116P PS=2.86U PD=0.98U
* device instance _1611 r0 *1 511.945,806.44 pfet_05v0
XM_1611 n_I3242 n_I3237 VDD_DEC VDD_DEC pfet_05v0 L=0.5U W=0.36U AS=0.1116P
+ AD=0.0612P PS=0.98U PD=0.7U
* device instance _1612 r0 *1 512.785,806.44 pfet_05v0
XM_1612 n_I3242 n_I3237 n_I3238 VDD_DEC pfet_05v0 L=0.5U W=0.36U AS=0.3852P
+ AD=0.0612P PS=2.86U PD=0.7U
* device instance _1613 r0 *1 515.115,803.562 nfet_05v0
XM_1613 n_I3241 n_I3238 n_I3239 VSS nfet_05v0 L=0.6U W=0.365U AS=0.3705P
+ AD=0.0438P PS=2.77U PD=0.605U
* device instance _1614 r0 *1 515.955,803.562 nfet_05v0
XM_1614 VSS n_I3238 n_I3241 VSS nfet_05v0 L=0.6U W=0.365U AS=0.0438P
+ AD=0.282625P PS=0.605U PD=1.87U
* device instance _1615 r0 *1 517.605,803.79 nfet_05v0
XM_1615 n_269 n_I3239 VSS VSS nfet_05v0 L=0.6U W=0.82U AS=0.282625P AD=0.3608P
+ PS=1.87U PD=2.52U
* device instance _1616 r0 *1 510.875,803.56 nfet_05v0
XM_1616 VSS n_I2307 n_I3237 VSS nfet_05v0 L=0.6U W=0.36U AS=0.333P AD=0.0936P
+ PS=2.57U PD=0.88U
* device instance _1617 r0 *1 511.995,803.56 nfet_05v0
XM_1617 n_I3240 n_I3237 VSS VSS nfet_05v0 L=0.6U W=0.36U AS=0.0936P AD=0.0432P
+ PS=0.88U PD=0.6U
* device instance _1618 r0 *1 512.835,803.56 nfet_05v0
XM_1618 n_I3238 n_I3237 n_I3240 VSS nfet_05v0 L=0.6U W=0.36U AS=0.0432P
+ AD=0.369P PS=0.6U PD=2.77U
* device instance _1619 m0 *1 513.385,799.75 pfet_05v0
XM_1619 n_I3250 n_I3245 n_I3246 VDD_DEC pfet_05v0 L=0.5U W=0.36U AS=0.3456P
+ AD=0.0612P PS=2.64U PD=0.7U
* device instance _1620 m0 *1 514.225,799.75 pfet_05v0
XM_1620 n_I3250 n_I3245 VDD_DEC VDD_DEC pfet_05v0 L=0.5U W=0.36U AS=0.379P
+ AD=0.0612P PS=2.37U PD=0.7U
* device instance _1621 m0 *1 515.875,800.07 pfet_05v0
XM_1621 n_271 n_I3246 VDD_DEC VDD_DEC pfet_05v0 L=0.5U W=1.22U AS=0.379P
+ AD=0.5368P PS=2.37U PD=3.32U
* device instance _1622 m0 *1 509.145,799.64 pfet_05v0
XM_1622 VDD_DEC n_I2272 n_I3244 VDD_DEC pfet_05v0 L=0.5U W=0.36U AS=0.3852P
+ AD=0.1116P PS=2.86U PD=0.98U
* device instance _1623 m0 *1 510.265,799.64 pfet_05v0
XM_1623 n_I3249 n_I3244 VDD_DEC VDD_DEC pfet_05v0 L=0.5U W=0.36U AS=0.1116P
+ AD=0.0612P PS=0.98U PD=0.7U
* device instance _1624 m0 *1 511.105,799.64 pfet_05v0
XM_1624 n_I3249 n_I3244 n_I3245 VDD_DEC pfet_05v0 L=0.5U W=0.36U AS=0.3852P
+ AD=0.0612P PS=2.86U PD=0.7U
* device instance _1625 m0 *1 513.435,802.518 nfet_05v0
XM_1625 n_I3248 n_I3245 n_I3246 VSS nfet_05v0 L=0.6U W=0.365U AS=0.3705P
+ AD=0.0438P PS=2.77U PD=0.605U
* device instance _1626 m0 *1 514.275,802.518 nfet_05v0
XM_1626 VSS n_I3245 n_I3248 VSS nfet_05v0 L=0.6U W=0.365U AS=0.0438P
+ AD=0.282625P PS=0.605U PD=1.87U
* device instance _1627 m0 *1 515.925,802.29 nfet_05v0
XM_1627 n_271 n_I3246 VSS VSS nfet_05v0 L=0.6U W=0.82U AS=0.282625P AD=0.3608P
+ PS=1.87U PD=2.52U
* device instance _1628 m0 *1 509.195,802.52 nfet_05v0
XM_1628 VSS n_I2272 n_I3244 VSS nfet_05v0 L=0.6U W=0.36U AS=0.333P AD=0.0936P
+ PS=2.57U PD=0.88U
* device instance _1629 m0 *1 510.315,802.52 nfet_05v0
XM_1629 n_I3247 n_I3244 VSS VSS nfet_05v0 L=0.6U W=0.36U AS=0.0936P AD=0.0432P
+ PS=0.88U PD=0.6U
* device instance _1630 m0 *1 511.155,802.52 nfet_05v0
XM_1630 n_I3245 n_I3244 n_I3247 VSS nfet_05v0 L=0.6U W=0.36U AS=0.0432P
+ AD=0.369P PS=0.6U PD=2.77U
* device instance _1631 m90 *1 522.215,806.33 pfet_05v0
XM_1631 n_I3257 n_I3252 n_I3253 VDD_DEC pfet_05v0 L=0.5U W=0.36U AS=0.3456P
+ AD=0.0612P PS=2.64U PD=0.7U
* device instance _1632 m90 *1 521.375,806.33 pfet_05v0
XM_1632 n_I3257 n_I3252 VDD_DEC VDD_DEC pfet_05v0 L=0.5U W=0.36U AS=0.379P
+ AD=0.0612P PS=2.37U PD=0.7U
* device instance _1633 m90 *1 519.725,806.01 pfet_05v0
XM_1633 n_275 n_I3253 VDD_DEC VDD_DEC pfet_05v0 L=0.5U W=1.22U AS=0.379P
+ AD=0.5368P PS=2.37U PD=3.32U
* device instance _1634 m90 *1 526.455,806.44 pfet_05v0
XM_1634 VDD_DEC n_I2305 n_I3251 VDD_DEC pfet_05v0 L=0.5U W=0.36U AS=0.3852P
+ AD=0.1116P PS=2.86U PD=0.98U
* device instance _1635 m90 *1 525.335,806.44 pfet_05v0
XM_1635 n_I3256 n_I3251 VDD_DEC VDD_DEC pfet_05v0 L=0.5U W=0.36U AS=0.1116P
+ AD=0.0612P PS=0.98U PD=0.7U
* device instance _1636 m90 *1 524.495,806.44 pfet_05v0
XM_1636 n_I3256 n_I3251 n_I3252 VDD_DEC pfet_05v0 L=0.5U W=0.36U AS=0.3852P
+ AD=0.0612P PS=2.86U PD=0.7U
* device instance _1637 m90 *1 522.165,803.562 nfet_05v0
XM_1637 n_I3255 n_I3252 n_I3253 VSS nfet_05v0 L=0.6U W=0.365U AS=0.3705P
+ AD=0.0438P PS=2.77U PD=0.605U
* device instance _1638 m90 *1 521.325,803.562 nfet_05v0
XM_1638 VSS n_I3252 n_I3255 VSS nfet_05v0 L=0.6U W=0.365U AS=0.0438P
+ AD=0.282625P PS=0.605U PD=1.87U
* device instance _1639 m90 *1 519.675,803.79 nfet_05v0
XM_1639 n_275 n_I3253 VSS VSS nfet_05v0 L=0.6U W=0.82U AS=0.282625P AD=0.3608P
+ PS=1.87U PD=2.52U
* device instance _1640 m90 *1 526.405,803.56 nfet_05v0
XM_1640 VSS n_I2305 n_I3251 VSS nfet_05v0 L=0.6U W=0.36U AS=0.333P AD=0.0936P
+ PS=2.57U PD=0.88U
* device instance _1641 m90 *1 525.285,803.56 nfet_05v0
XM_1641 n_I3254 n_I3251 VSS VSS nfet_05v0 L=0.6U W=0.36U AS=0.0936P AD=0.0432P
+ PS=0.88U PD=0.6U
* device instance _1642 m90 *1 524.445,803.56 nfet_05v0
XM_1642 n_I3252 n_I3251 n_I3254 VSS nfet_05v0 L=0.6U W=0.36U AS=0.0432P
+ AD=0.369P PS=0.6U PD=2.77U
* device instance _1643 m0 *1 522.345,799.75 pfet_05v0
XM_1643 n_I3264 n_I3259 n_I3260 VDD_DEC pfet_05v0 L=0.5U W=0.36U AS=0.3456P
+ AD=0.0612P PS=2.64U PD=0.7U
* device instance _1644 m0 *1 523.185,799.75 pfet_05v0
XM_1644 n_I3264 n_I3259 VDD_DEC VDD_DEC pfet_05v0 L=0.5U W=0.36U AS=0.379P
+ AD=0.0612P PS=2.37U PD=0.7U
* device instance _1645 m0 *1 524.835,800.07 pfet_05v0
XM_1645 n_278 n_I3260 VDD_DEC VDD_DEC pfet_05v0 L=0.5U W=1.22U AS=0.379P
+ AD=0.5368P PS=2.37U PD=3.32U
* device instance _1646 m0 *1 518.105,799.64 pfet_05v0
XM_1646 VDD_DEC n_I2271 n_I3258 VDD_DEC pfet_05v0 L=0.5U W=0.36U AS=0.3852P
+ AD=0.1116P PS=2.86U PD=0.98U
* device instance _1647 m0 *1 519.225,799.64 pfet_05v0
XM_1647 n_I3263 n_I3258 VDD_DEC VDD_DEC pfet_05v0 L=0.5U W=0.36U AS=0.1116P
+ AD=0.0612P PS=0.98U PD=0.7U
* device instance _1648 m0 *1 520.065,799.64 pfet_05v0
XM_1648 n_I3263 n_I3258 n_I3259 VDD_DEC pfet_05v0 L=0.5U W=0.36U AS=0.3852P
+ AD=0.0612P PS=2.86U PD=0.7U
* device instance _1649 m0 *1 522.395,802.518 nfet_05v0
XM_1649 n_I3262 n_I3259 n_I3260 VSS nfet_05v0 L=0.6U W=0.365U AS=0.3705P
+ AD=0.0438P PS=2.77U PD=0.605U
* device instance _1650 m0 *1 523.235,802.518 nfet_05v0
XM_1650 VSS n_I3259 n_I3262 VSS nfet_05v0 L=0.6U W=0.365U AS=0.0438P
+ AD=0.282625P PS=0.605U PD=1.87U
* device instance _1651 m0 *1 524.885,802.29 nfet_05v0
XM_1651 n_278 n_I3260 VSS VSS nfet_05v0 L=0.6U W=0.82U AS=0.282625P AD=0.3608P
+ PS=1.87U PD=2.52U
* device instance _1652 m0 *1 518.155,802.52 nfet_05v0
XM_1652 VSS n_I2271 n_I3258 VSS nfet_05v0 L=0.6U W=0.36U AS=0.333P AD=0.0936P
+ PS=2.57U PD=0.88U
* device instance _1653 m0 *1 519.275,802.52 nfet_05v0
XM_1653 n_I3261 n_I3258 VSS VSS nfet_05v0 L=0.6U W=0.36U AS=0.0936P AD=0.0432P
+ PS=0.88U PD=0.6U
* device instance _1654 m0 *1 520.115,802.52 nfet_05v0
XM_1654 n_I3259 n_I3258 n_I3261 VSS nfet_05v0 L=0.6U W=0.36U AS=0.0432P
+ AD=0.369P PS=0.6U PD=2.77U
* device instance _1655 r0 *1 524.025,798.49 pfet_05v0
XM_1655 n_I3271 n_I3266 n_I3267 VDD_DEC pfet_05v0 L=0.5U W=0.36U AS=0.3456P
+ AD=0.0612P PS=2.64U PD=0.7U
* device instance _1656 r0 *1 524.865,798.49 pfet_05v0
XM_1656 n_I3271 n_I3266 VDD_DEC VDD_DEC pfet_05v0 L=0.5U W=0.36U AS=0.379P
+ AD=0.0612P PS=2.37U PD=0.7U
* device instance _1657 r0 *1 526.515,798.17 pfet_05v0
XM_1657 n_280 n_I3267 VDD_DEC VDD_DEC pfet_05v0 L=0.5U W=1.22U AS=0.379P
+ AD=0.5368P PS=2.37U PD=3.32U
* device instance _1658 r0 *1 519.785,798.6 pfet_05v0
XM_1658 VDD_DEC n_I2232 n_I3265 VDD_DEC pfet_05v0 L=0.5U W=0.36U AS=0.3852P
+ AD=0.1116P PS=2.86U PD=0.98U
* device instance _1659 r0 *1 520.905,798.6 pfet_05v0
XM_1659 n_I3270 n_I3265 VDD_DEC VDD_DEC pfet_05v0 L=0.5U W=0.36U AS=0.1116P
+ AD=0.0612P PS=0.98U PD=0.7U
* device instance _1660 r0 *1 521.745,798.6 pfet_05v0
XM_1660 n_I3270 n_I3265 n_I3266 VDD_DEC pfet_05v0 L=0.5U W=0.36U AS=0.3852P
+ AD=0.0612P PS=2.86U PD=0.7U
* device instance _1661 r0 *1 524.075,795.722 nfet_05v0
XM_1661 n_I3269 n_I3266 n_I3267 VSS nfet_05v0 L=0.6U W=0.365U AS=0.3705P
+ AD=0.0438P PS=2.77U PD=0.605U
* device instance _1662 r0 *1 524.915,795.722 nfet_05v0
XM_1662 VSS n_I3266 n_I3269 VSS nfet_05v0 L=0.6U W=0.365U AS=0.0438P
+ AD=0.282625P PS=0.605U PD=1.87U
* device instance _1663 r0 *1 526.565,795.95 nfet_05v0
XM_1663 n_280 n_I3267 VSS VSS nfet_05v0 L=0.6U W=0.82U AS=0.282625P AD=0.3608P
+ PS=1.87U PD=2.52U
* device instance _1664 r0 *1 519.835,795.72 nfet_05v0
XM_1664 VSS n_I2232 n_I3265 VSS nfet_05v0 L=0.6U W=0.36U AS=0.333P AD=0.0936P
+ PS=2.57U PD=0.88U
* device instance _1665 r0 *1 520.955,795.72 nfet_05v0
XM_1665 n_I3268 n_I3265 VSS VSS nfet_05v0 L=0.6U W=0.36U AS=0.0936P AD=0.0432P
+ PS=0.88U PD=0.6U
* device instance _1666 r0 *1 521.795,795.72 nfet_05v0
XM_1666 n_I3266 n_I3265 n_I3268 VSS nfet_05v0 L=0.6U W=0.36U AS=0.0432P
+ AD=0.369P PS=0.6U PD=2.77U
* device instance _1667 m90 *1 531.175,806.33 pfet_05v0
XM_1667 n_I3278 n_I3273 n_I3274 VDD_DEC pfet_05v0 L=0.5U W=0.36U AS=0.3456P
+ AD=0.0612P PS=2.64U PD=0.7U
* device instance _1668 m90 *1 530.335,806.33 pfet_05v0
XM_1668 n_I3278 n_I3273 VDD_DEC VDD_DEC pfet_05v0 L=0.5U W=0.36U AS=0.379P
+ AD=0.0612P PS=2.37U PD=0.7U
* device instance _1669 m90 *1 528.685,806.01 pfet_05v0
XM_1669 n_151 n_I3274 VDD_DEC VDD_DEC pfet_05v0 L=0.5U W=1.22U AS=0.379P
+ AD=0.5368P PS=2.37U PD=3.32U
* device instance _1670 m90 *1 535.415,806.44 pfet_05v0
XM_1670 VDD_DEC n_I2273 n_I3272 VDD_DEC pfet_05v0 L=0.5U W=0.36U AS=0.3852P
+ AD=0.1116P PS=2.86U PD=0.98U
* device instance _1671 m90 *1 534.295,806.44 pfet_05v0
XM_1671 n_I3277 n_I3272 VDD_DEC VDD_DEC pfet_05v0 L=0.5U W=0.36U AS=0.1116P
+ AD=0.0612P PS=0.98U PD=0.7U
* device instance _1672 m90 *1 533.455,806.44 pfet_05v0
XM_1672 n_I3277 n_I3272 n_I3273 VDD_DEC pfet_05v0 L=0.5U W=0.36U AS=0.3852P
+ AD=0.0612P PS=2.86U PD=0.7U
* device instance _1673 m90 *1 531.125,803.562 nfet_05v0
XM_1673 n_I3276 n_I3273 n_I3274 VSS nfet_05v0 L=0.6U W=0.365U AS=0.3705P
+ AD=0.0438P PS=2.77U PD=0.605U
* device instance _1674 m90 *1 530.285,803.562 nfet_05v0
XM_1674 VSS n_I3273 n_I3276 VSS nfet_05v0 L=0.6U W=0.365U AS=0.0438P
+ AD=0.282625P PS=0.605U PD=1.87U
* device instance _1675 m90 *1 528.635,803.79 nfet_05v0
XM_1675 n_151 n_I3274 VSS VSS nfet_05v0 L=0.6U W=0.82U AS=0.282625P AD=0.3608P
+ PS=1.87U PD=2.52U
* device instance _1676 m90 *1 535.365,803.56 nfet_05v0
XM_1676 VSS n_I2273 n_I3272 VSS nfet_05v0 L=0.6U W=0.36U AS=0.333P AD=0.0936P
+ PS=2.57U PD=0.88U
* device instance _1677 m90 *1 534.245,803.56 nfet_05v0
XM_1677 n_I3275 n_I3272 VSS VSS nfet_05v0 L=0.6U W=0.36U AS=0.0936P AD=0.0432P
+ PS=0.88U PD=0.6U
* device instance _1678 m90 *1 533.405,803.56 nfet_05v0
XM_1678 n_I3273 n_I3272 n_I3275 VSS nfet_05v0 L=0.6U W=0.36U AS=0.0432P
+ AD=0.369P PS=0.6U PD=2.77U
* device instance _1679 m0 *1 534.665,799.75 pfet_05v0
XM_1679 n_I3285 n_I3280 n_I3281 VDD_DEC pfet_05v0 L=0.5U W=0.36U AS=0.3456P
+ AD=0.0612P PS=2.64U PD=0.7U
* device instance _1680 m0 *1 535.505,799.75 pfet_05v0
XM_1680 n_I3285 n_I3280 VDD_DEC VDD_DEC pfet_05v0 L=0.5U W=0.36U AS=0.379P
+ AD=0.0612P PS=2.37U PD=0.7U
* device instance _1681 m0 *1 537.155,800.07 pfet_05v0
XM_1681 n_163 n_I3281 VDD_DEC VDD_DEC pfet_05v0 L=0.5U W=1.22U AS=0.379P
+ AD=0.5368P PS=2.37U PD=3.32U
* device instance _1682 m0 *1 530.425,799.64 pfet_05v0
XM_1682 VDD_DEC n_I2275 n_I3279 VDD_DEC pfet_05v0 L=0.5U W=0.36U AS=0.3852P
+ AD=0.1116P PS=2.86U PD=0.98U
* device instance _1683 m0 *1 531.545,799.64 pfet_05v0
XM_1683 n_I3284 n_I3279 VDD_DEC VDD_DEC pfet_05v0 L=0.5U W=0.36U AS=0.1116P
+ AD=0.0612P PS=0.98U PD=0.7U
* device instance _1684 m0 *1 532.385,799.64 pfet_05v0
XM_1684 n_I3284 n_I3279 n_I3280 VDD_DEC pfet_05v0 L=0.5U W=0.36U AS=0.3852P
+ AD=0.0612P PS=2.86U PD=0.7U
* device instance _1685 m0 *1 534.715,802.518 nfet_05v0
XM_1685 n_I3283 n_I3280 n_I3281 VSS nfet_05v0 L=0.6U W=0.365U AS=0.3705P
+ AD=0.0438P PS=2.77U PD=0.605U
* device instance _1686 m0 *1 535.555,802.518 nfet_05v0
XM_1686 VSS n_I3280 n_I3283 VSS nfet_05v0 L=0.6U W=0.365U AS=0.0438P
+ AD=0.282625P PS=0.605U PD=1.87U
* device instance _1687 m0 *1 537.205,802.29 nfet_05v0
XM_1687 n_163 n_I3281 VSS VSS nfet_05v0 L=0.6U W=0.82U AS=0.282625P AD=0.3608P
+ PS=1.87U PD=2.52U
* device instance _1688 m0 *1 530.475,802.52 nfet_05v0
XM_1688 VSS n_I2275 n_I3279 VSS nfet_05v0 L=0.6U W=0.36U AS=0.333P AD=0.0936P
+ PS=2.57U PD=0.88U
* device instance _1689 m0 *1 531.595,802.52 nfet_05v0
XM_1689 n_I3282 n_I3279 VSS VSS nfet_05v0 L=0.6U W=0.36U AS=0.0936P AD=0.0432P
+ PS=0.88U PD=0.6U
* device instance _1690 m0 *1 532.435,802.52 nfet_05v0
XM_1690 n_I3280 n_I3279 n_I3282 VSS nfet_05v0 L=0.6U W=0.36U AS=0.0432P
+ AD=0.369P PS=0.6U PD=2.77U
* device instance _1691 r0 *1 532.985,798.49 pfet_05v0
XM_1691 n_I3292 n_I3287 n_I3288 VDD_DEC pfet_05v0 L=0.5U W=0.36U AS=0.3456P
+ AD=0.0612P PS=2.64U PD=0.7U
* device instance _1692 r0 *1 533.825,798.49 pfet_05v0
XM_1692 n_I3292 n_I3287 VDD_DEC VDD_DEC pfet_05v0 L=0.5U W=0.36U AS=0.379P
+ AD=0.0612P PS=2.37U PD=0.7U
* device instance _1693 r0 *1 535.475,798.17 pfet_05v0
XM_1693 n_169 n_I3288 VDD_DEC VDD_DEC pfet_05v0 L=0.5U W=1.22U AS=0.379P
+ AD=0.5368P PS=2.37U PD=3.32U
* device instance _1694 r0 *1 528.745,798.6 pfet_05v0
XM_1694 VDD_DEC n_I2234 n_I3286 VDD_DEC pfet_05v0 L=0.5U W=0.36U AS=0.3852P
+ AD=0.1116P PS=2.86U PD=0.98U
* device instance _1695 r0 *1 529.865,798.6 pfet_05v0
XM_1695 n_I3291 n_I3286 VDD_DEC VDD_DEC pfet_05v0 L=0.5U W=0.36U AS=0.1116P
+ AD=0.0612P PS=0.98U PD=0.7U
* device instance _1696 r0 *1 530.705,798.6 pfet_05v0
XM_1696 n_I3291 n_I3286 n_I3287 VDD_DEC pfet_05v0 L=0.5U W=0.36U AS=0.3852P
+ AD=0.0612P PS=2.86U PD=0.7U
* device instance _1697 r0 *1 533.035,795.722 nfet_05v0
XM_1697 n_I3290 n_I3287 n_I3288 VSS nfet_05v0 L=0.6U W=0.365U AS=0.3705P
+ AD=0.0438P PS=2.77U PD=0.605U
* device instance _1698 r0 *1 533.875,795.722 nfet_05v0
XM_1698 VSS n_I3287 n_I3290 VSS nfet_05v0 L=0.6U W=0.365U AS=0.0438P
+ AD=0.282625P PS=0.605U PD=1.87U
* device instance _1699 r0 *1 535.525,795.95 nfet_05v0
XM_1699 n_169 n_I3288 VSS VSS nfet_05v0 L=0.6U W=0.82U AS=0.282625P AD=0.3608P
+ PS=1.87U PD=2.52U
* device instance _1700 r0 *1 528.795,795.72 nfet_05v0
XM_1700 VSS n_I2234 n_I3286 VSS nfet_05v0 L=0.6U W=0.36U AS=0.333P AD=0.0936P
+ PS=2.57U PD=0.88U
* device instance _1701 r0 *1 529.915,795.72 nfet_05v0
XM_1701 n_I3289 n_I3286 VSS VSS nfet_05v0 L=0.6U W=0.36U AS=0.0936P AD=0.0432P
+ PS=0.88U PD=0.6U
* device instance _1702 r0 *1 530.755,795.72 nfet_05v0
XM_1702 n_I3287 n_I3286 n_I3289 VSS nfet_05v0 L=0.6U W=0.36U AS=0.0432P
+ AD=0.369P PS=0.6U PD=2.77U
* device instance _1703 m90 *1 540.135,806.33 pfet_05v0
XM_1703 n_I3299 n_I3294 n_I3295 VDD_DEC pfet_05v0 L=0.5U W=0.36U AS=0.3456P
+ AD=0.0612P PS=2.64U PD=0.7U
* device instance _1704 m90 *1 539.295,806.33 pfet_05v0
XM_1704 n_I3299 n_I3294 VDD_DEC VDD_DEC pfet_05v0 L=0.5U W=0.36U AS=0.379P
+ AD=0.0612P PS=2.37U PD=0.7U
* device instance _1705 m90 *1 537.645,806.01 pfet_05v0
XM_1705 n_178 n_I3295 VDD_DEC VDD_DEC pfet_05v0 L=0.5U W=1.22U AS=0.379P
+ AD=0.5368P PS=2.37U PD=3.32U
* device instance _1706 m90 *1 544.375,806.44 pfet_05v0
XM_1706 VDD_DEC n_I2308 n_I3293 VDD_DEC pfet_05v0 L=0.5U W=0.36U AS=0.3852P
+ AD=0.1116P PS=2.86U PD=0.98U
* device instance _1707 m90 *1 543.255,806.44 pfet_05v0
XM_1707 n_I3298 n_I3293 VDD_DEC VDD_DEC pfet_05v0 L=0.5U W=0.36U AS=0.1116P
+ AD=0.0612P PS=0.98U PD=0.7U
* device instance _1708 m90 *1 542.415,806.44 pfet_05v0
XM_1708 n_I3298 n_I3293 n_I3294 VDD_DEC pfet_05v0 L=0.5U W=0.36U AS=0.3852P
+ AD=0.0612P PS=2.86U PD=0.7U
* device instance _1709 m90 *1 540.085,803.562 nfet_05v0
XM_1709 n_I3297 n_I3294 n_I3295 VSS nfet_05v0 L=0.6U W=0.365U AS=0.3705P
+ AD=0.0438P PS=2.77U PD=0.605U
* device instance _1710 m90 *1 539.245,803.562 nfet_05v0
XM_1710 VSS n_I3294 n_I3297 VSS nfet_05v0 L=0.6U W=0.365U AS=0.0438P
+ AD=0.282625P PS=0.605U PD=1.87U
* device instance _1711 m90 *1 537.595,803.79 nfet_05v0
XM_1711 n_178 n_I3295 VSS VSS nfet_05v0 L=0.6U W=0.82U AS=0.282625P AD=0.3608P
+ PS=1.87U PD=2.52U
* device instance _1712 m90 *1 544.325,803.56 nfet_05v0
XM_1712 VSS n_I2308 n_I3293 VSS nfet_05v0 L=0.6U W=0.36U AS=0.333P AD=0.0936P
+ PS=2.57U PD=0.88U
* device instance _1713 m90 *1 543.205,803.56 nfet_05v0
XM_1713 n_I3296 n_I3293 VSS VSS nfet_05v0 L=0.6U W=0.36U AS=0.0936P AD=0.0432P
+ PS=0.88U PD=0.6U
* device instance _1714 m90 *1 542.365,803.56 nfet_05v0
XM_1714 n_I3294 n_I3293 n_I3296 VSS nfet_05v0 L=0.6U W=0.36U AS=0.0432P
+ AD=0.369P PS=0.6U PD=2.77U
* device instance _1715 m0 *1 543.625,799.75 pfet_05v0
XM_1715 n_I3306 n_I3301 n_I3302 VDD_DEC pfet_05v0 L=0.5U W=0.36U AS=0.3456P
+ AD=0.0612P PS=2.64U PD=0.7U
* device instance _1716 m0 *1 544.465,799.75 pfet_05v0
XM_1716 n_I3306 n_I3301 VDD_DEC VDD_DEC pfet_05v0 L=0.5U W=0.36U AS=0.379P
+ AD=0.0612P PS=2.37U PD=0.7U
* device instance _1717 m0 *1 546.115,800.07 pfet_05v0
XM_1717 n_187 n_I3302 VDD_DEC VDD_DEC pfet_05v0 L=0.5U W=1.22U AS=0.379P
+ AD=0.5368P PS=2.37U PD=3.32U
* device instance _1718 m0 *1 539.385,799.64 pfet_05v0
XM_1718 VDD_DEC n_I2276 n_I3300 VDD_DEC pfet_05v0 L=0.5U W=0.36U AS=0.3852P
+ AD=0.1116P PS=2.86U PD=0.98U
* device instance _1719 m0 *1 540.505,799.64 pfet_05v0
XM_1719 n_I3305 n_I3300 VDD_DEC VDD_DEC pfet_05v0 L=0.5U W=0.36U AS=0.1116P
+ AD=0.0612P PS=0.98U PD=0.7U
* device instance _1720 m0 *1 541.345,799.64 pfet_05v0
XM_1720 n_I3305 n_I3300 n_I3301 VDD_DEC pfet_05v0 L=0.5U W=0.36U AS=0.3852P
+ AD=0.0612P PS=2.86U PD=0.7U
* device instance _1721 m0 *1 543.675,802.518 nfet_05v0
XM_1721 n_I3304 n_I3301 n_I3302 VSS nfet_05v0 L=0.6U W=0.365U AS=0.3705P
+ AD=0.0438P PS=2.77U PD=0.605U
* device instance _1722 m0 *1 544.515,802.518 nfet_05v0
XM_1722 VSS n_I3301 n_I3304 VSS nfet_05v0 L=0.6U W=0.365U AS=0.0438P
+ AD=0.282625P PS=0.605U PD=1.87U
* device instance _1723 m0 *1 546.165,802.29 nfet_05v0
XM_1723 n_187 n_I3302 VSS VSS nfet_05v0 L=0.6U W=0.82U AS=0.282625P AD=0.3608P
+ PS=1.87U PD=2.52U
* device instance _1724 m0 *1 539.435,802.52 nfet_05v0
XM_1724 VSS n_I2276 n_I3300 VSS nfet_05v0 L=0.6U W=0.36U AS=0.333P AD=0.0936P
+ PS=2.57U PD=0.88U
* device instance _1725 m0 *1 540.555,802.52 nfet_05v0
XM_1725 n_I3303 n_I3300 VSS VSS nfet_05v0 L=0.6U W=0.36U AS=0.0936P AD=0.0432P
+ PS=0.88U PD=0.6U
* device instance _1726 m0 *1 541.395,802.52 nfet_05v0
XM_1726 n_I3301 n_I3300 n_I3303 VSS nfet_05v0 L=0.6U W=0.36U AS=0.0432P
+ AD=0.369P PS=0.6U PD=2.77U
* device instance _1727 r0 *1 541.945,798.49 pfet_05v0
XM_1727 n_I3313 n_I3308 n_I3309 VDD_DEC pfet_05v0 L=0.5U W=0.36U AS=0.3456P
+ AD=0.0612P PS=2.64U PD=0.7U
* device instance _1728 r0 *1 542.785,798.49 pfet_05v0
XM_1728 n_I3313 n_I3308 VDD_DEC VDD_DEC pfet_05v0 L=0.5U W=0.36U AS=0.379P
+ AD=0.0612P PS=2.37U PD=0.7U
* device instance _1729 r0 *1 544.435,798.17 pfet_05v0
XM_1729 n_146 n_I3309 VDD_DEC VDD_DEC pfet_05v0 L=0.5U W=1.22U AS=0.379P
+ AD=0.5368P PS=2.37U PD=3.32U
* device instance _1730 r0 *1 537.705,798.6 pfet_05v0
XM_1730 VDD_DEC n_I2235 n_I3307 VDD_DEC pfet_05v0 L=0.5U W=0.36U AS=0.3852P
+ AD=0.1116P PS=2.86U PD=0.98U
* device instance _1731 r0 *1 538.825,798.6 pfet_05v0
XM_1731 n_I3312 n_I3307 VDD_DEC VDD_DEC pfet_05v0 L=0.5U W=0.36U AS=0.1116P
+ AD=0.0612P PS=0.98U PD=0.7U
* device instance _1732 r0 *1 539.665,798.6 pfet_05v0
XM_1732 n_I3312 n_I3307 n_I3308 VDD_DEC pfet_05v0 L=0.5U W=0.36U AS=0.3852P
+ AD=0.0612P PS=2.86U PD=0.7U
* device instance _1733 r0 *1 541.995,795.722 nfet_05v0
XM_1733 n_I3311 n_I3308 n_I3309 VSS nfet_05v0 L=0.6U W=0.365U AS=0.3705P
+ AD=0.0438P PS=2.77U PD=0.605U
* device instance _1734 r0 *1 542.835,795.722 nfet_05v0
XM_1734 VSS n_I3308 n_I3311 VSS nfet_05v0 L=0.6U W=0.365U AS=0.0438P
+ AD=0.282625P PS=0.605U PD=1.87U
* device instance _1735 r0 *1 544.485,795.95 nfet_05v0
XM_1735 n_146 n_I3309 VSS VSS nfet_05v0 L=0.6U W=0.82U AS=0.282625P AD=0.3608P
+ PS=1.87U PD=2.52U
* device instance _1736 r0 *1 537.755,795.72 nfet_05v0
XM_1736 VSS n_I2235 n_I3307 VSS nfet_05v0 L=0.6U W=0.36U AS=0.333P AD=0.0936P
+ PS=2.57U PD=0.88U
* device instance _1737 r0 *1 538.875,795.72 nfet_05v0
XM_1737 n_I3310 n_I3307 VSS VSS nfet_05v0 L=0.6U W=0.36U AS=0.0936P AD=0.0432P
+ PS=0.88U PD=0.6U
* device instance _1738 r0 *1 539.715,795.72 nfet_05v0
XM_1738 n_I3308 n_I3307 n_I3310 VSS nfet_05v0 L=0.6U W=0.36U AS=0.0432P
+ AD=0.369P PS=0.6U PD=2.77U
* device instance _1739 m90 *1 550.215,806.33 pfet_05v0
XM_1739 n_I3320 n_I3315 n_I3316 VDD_DEC pfet_05v0 L=0.5U W=0.36U AS=0.3456P
+ AD=0.0612P PS=2.64U PD=0.7U
* device instance _1740 m90 *1 549.375,806.33 pfet_05v0
XM_1740 n_I3320 n_I3315 VDD_DEC VDD_DEC pfet_05v0 L=0.5U W=0.36U AS=0.379P
+ AD=0.0612P PS=2.37U PD=0.7U
* device instance _1741 m90 *1 547.725,806.01 pfet_05v0
XM_1741 n_149 n_I3316 VDD_DEC VDD_DEC pfet_05v0 L=0.5U W=1.22U AS=0.379P
+ AD=0.5368P PS=2.37U PD=3.32U
* device instance _1742 m90 *1 554.455,806.44 pfet_05v0
XM_1742 VDD_DEC n_I2310 n_I3314 VDD_DEC pfet_05v0 L=0.5U W=0.36U AS=0.3852P
+ AD=0.1116P PS=2.86U PD=0.98U
* device instance _1743 m90 *1 553.335,806.44 pfet_05v0
XM_1743 n_I3319 n_I3314 VDD_DEC VDD_DEC pfet_05v0 L=0.5U W=0.36U AS=0.1116P
+ AD=0.0612P PS=0.98U PD=0.7U
* device instance _1744 m90 *1 552.495,806.44 pfet_05v0
XM_1744 n_I3319 n_I3314 n_I3315 VDD_DEC pfet_05v0 L=0.5U W=0.36U AS=0.3852P
+ AD=0.0612P PS=2.86U PD=0.7U
* device instance _1745 m90 *1 550.165,803.562 nfet_05v0
XM_1745 n_I3318 n_I3315 n_I3316 VSS nfet_05v0 L=0.6U W=0.365U AS=0.3705P
+ AD=0.0438P PS=2.77U PD=0.605U
* device instance _1746 m90 *1 549.325,803.562 nfet_05v0
XM_1746 VSS n_I3315 n_I3318 VSS nfet_05v0 L=0.6U W=0.365U AS=0.0438P
+ AD=0.282625P PS=0.605U PD=1.87U
* device instance _1747 m90 *1 547.675,803.79 nfet_05v0
XM_1747 n_149 n_I3316 VSS VSS nfet_05v0 L=0.6U W=0.82U AS=0.282625P AD=0.3608P
+ PS=1.87U PD=2.52U
* device instance _1748 m90 *1 554.405,803.56 nfet_05v0
XM_1748 VSS n_I2310 n_I3314 VSS nfet_05v0 L=0.6U W=0.36U AS=0.333P AD=0.0936P
+ PS=2.57U PD=0.88U
* device instance _1749 m90 *1 553.285,803.56 nfet_05v0
XM_1749 n_I3317 n_I3314 VSS VSS nfet_05v0 L=0.6U W=0.36U AS=0.0936P AD=0.0432P
+ PS=0.88U PD=0.6U
* device instance _1750 m90 *1 552.445,803.56 nfet_05v0
XM_1750 n_I3315 n_I3314 n_I3317 VSS nfet_05v0 L=0.6U W=0.36U AS=0.0432P
+ AD=0.369P PS=0.6U PD=2.77U
* device instance _1751 m0 *1 552.585,799.75 pfet_05v0
XM_1751 n_I3327 n_I3322 n_I3323 VDD_DEC pfet_05v0 L=0.5U W=0.36U AS=0.3456P
+ AD=0.0612P PS=2.64U PD=0.7U
* device instance _1752 m0 *1 553.425,799.75 pfet_05v0
XM_1752 n_I3327 n_I3322 VDD_DEC VDD_DEC pfet_05v0 L=0.5U W=0.36U AS=0.379P
+ AD=0.0612P PS=2.37U PD=0.7U
* device instance _1753 m0 *1 555.075,800.07 pfet_05v0
XM_1753 n_161 n_I3323 VDD_DEC VDD_DEC pfet_05v0 L=0.5U W=1.22U AS=0.379P
+ AD=0.5368P PS=2.37U PD=3.32U
* device instance _1754 m0 *1 548.345,799.64 pfet_05v0
XM_1754 VDD_DEC n_I2278 n_I3321 VDD_DEC pfet_05v0 L=0.5U W=0.36U AS=0.3852P
+ AD=0.1116P PS=2.86U PD=0.98U
* device instance _1755 m0 *1 549.465,799.64 pfet_05v0
XM_1755 n_I3326 n_I3321 VDD_DEC VDD_DEC pfet_05v0 L=0.5U W=0.36U AS=0.1116P
+ AD=0.0612P PS=0.98U PD=0.7U
* device instance _1756 m0 *1 550.305,799.64 pfet_05v0
XM_1756 n_I3326 n_I3321 n_I3322 VDD_DEC pfet_05v0 L=0.5U W=0.36U AS=0.3852P
+ AD=0.0612P PS=2.86U PD=0.7U
* device instance _1757 m0 *1 552.635,802.518 nfet_05v0
XM_1757 n_I3325 n_I3322 n_I3323 VSS nfet_05v0 L=0.6U W=0.365U AS=0.3705P
+ AD=0.0438P PS=2.77U PD=0.605U
* device instance _1758 m0 *1 553.475,802.518 nfet_05v0
XM_1758 VSS n_I3322 n_I3325 VSS nfet_05v0 L=0.6U W=0.365U AS=0.0438P
+ AD=0.282625P PS=0.605U PD=1.87U
* device instance _1759 m0 *1 555.125,802.29 nfet_05v0
XM_1759 n_161 n_I3323 VSS VSS nfet_05v0 L=0.6U W=0.82U AS=0.282625P AD=0.3608P
+ PS=1.87U PD=2.52U
* device instance _1760 m0 *1 548.395,802.52 nfet_05v0
XM_1760 VSS n_I2278 n_I3321 VSS nfet_05v0 L=0.6U W=0.36U AS=0.333P AD=0.0936P
+ PS=2.57U PD=0.88U
* device instance _1761 m0 *1 549.515,802.52 nfet_05v0
XM_1761 n_I3324 n_I3321 VSS VSS nfet_05v0 L=0.6U W=0.36U AS=0.0936P AD=0.0432P
+ PS=0.88U PD=0.6U
* device instance _1762 m0 *1 550.355,802.52 nfet_05v0
XM_1762 n_I3322 n_I3321 n_I3324 VSS nfet_05v0 L=0.6U W=0.36U AS=0.0432P
+ AD=0.369P PS=0.6U PD=2.77U
* device instance _1763 m0 *1 552.585,791.91 pfet_05v0
XM_1763 n_I3334 n_I3329 n_I3330 VDD_DEC pfet_05v0 L=0.5U W=0.36U AS=0.3456P
+ AD=0.0612P PS=2.64U PD=0.7U
* device instance _1764 m0 *1 553.425,791.91 pfet_05v0
XM_1764 n_I3334 n_I3329 VDD_DEC VDD_DEC pfet_05v0 L=0.5U W=0.36U AS=0.379P
+ AD=0.0612P PS=2.37U PD=0.7U
* device instance _1765 m0 *1 555.075,792.23 pfet_05v0
XM_1765 n_173 n_I3330 VDD_DEC VDD_DEC pfet_05v0 L=0.5U W=1.22U AS=0.379P
+ AD=0.5368P PS=2.37U PD=3.32U
* device instance _1766 m0 *1 548.345,791.8 pfet_05v0
XM_1766 VDD_DEC n_I2205 n_I3328 VDD_DEC pfet_05v0 L=0.5U W=0.36U AS=0.3852P
+ AD=0.1116P PS=2.86U PD=0.98U
* device instance _1767 m0 *1 549.465,791.8 pfet_05v0
XM_1767 n_I3333 n_I3328 VDD_DEC VDD_DEC pfet_05v0 L=0.5U W=0.36U AS=0.1116P
+ AD=0.0612P PS=0.98U PD=0.7U
* device instance _1768 m0 *1 550.305,791.8 pfet_05v0
XM_1768 n_I3333 n_I3328 n_I3329 VDD_DEC pfet_05v0 L=0.5U W=0.36U AS=0.3852P
+ AD=0.0612P PS=2.86U PD=0.7U
* device instance _1769 m0 *1 552.635,794.678 nfet_05v0
XM_1769 n_I3332 n_I3329 n_I3330 VSS nfet_05v0 L=0.6U W=0.365U AS=0.3705P
+ AD=0.0438P PS=2.77U PD=0.605U
* device instance _1770 m0 *1 553.475,794.678 nfet_05v0
XM_1770 VSS n_I3329 n_I3332 VSS nfet_05v0 L=0.6U W=0.365U AS=0.0438P
+ AD=0.282625P PS=0.605U PD=1.87U
* device instance _1771 m0 *1 555.125,794.45 nfet_05v0
XM_1771 n_173 n_I3330 VSS VSS nfet_05v0 L=0.6U W=0.82U AS=0.282625P AD=0.3608P
+ PS=1.87U PD=2.52U
* device instance _1772 m0 *1 548.395,794.68 nfet_05v0
XM_1772 VSS n_I2205 n_I3328 VSS nfet_05v0 L=0.6U W=0.36U AS=0.333P AD=0.0936P
+ PS=2.57U PD=0.88U
* device instance _1773 m0 *1 549.515,794.68 nfet_05v0
XM_1773 n_I3331 n_I3328 VSS VSS nfet_05v0 L=0.6U W=0.36U AS=0.0936P AD=0.0432P
+ PS=0.88U PD=0.6U
* device instance _1774 m0 *1 550.355,794.68 nfet_05v0
XM_1774 n_I3329 n_I3328 n_I3331 VSS nfet_05v0 L=0.6U W=0.36U AS=0.0432P
+ AD=0.369P PS=0.6U PD=2.77U
* device instance _1775 r180 *1 559.735,799.75 pfet_05v0
XM_1775 n_I3341 n_I3336 n_I3337 VDD_DEC pfet_05v0 L=0.5U W=0.36U AS=0.3456P
+ AD=0.0612P PS=2.64U PD=0.7U
* device instance _1776 r180 *1 558.895,799.75 pfet_05v0
XM_1776 n_I3341 n_I3336 VDD_DEC VDD_DEC pfet_05v0 L=0.5U W=0.36U AS=0.379P
+ AD=0.0612P PS=2.37U PD=0.7U
* device instance _1777 r180 *1 557.245,800.07 pfet_05v0
XM_1777 n_179 n_I3337 VDD_DEC VDD_DEC pfet_05v0 L=0.5U W=1.22U AS=0.379P
+ AD=0.5368P PS=2.37U PD=3.32U
* device instance _1778 r180 *1 563.975,799.64 pfet_05v0
XM_1778 VDD_DEC n_I2279 n_I3335 VDD_DEC pfet_05v0 L=0.5U W=0.36U AS=0.3852P
+ AD=0.1116P PS=2.86U PD=0.98U
* device instance _1779 r180 *1 562.855,799.64 pfet_05v0
XM_1779 n_I3340 n_I3335 VDD_DEC VDD_DEC pfet_05v0 L=0.5U W=0.36U AS=0.1116P
+ AD=0.0612P PS=0.98U PD=0.7U
* device instance _1780 r180 *1 562.015,799.64 pfet_05v0
XM_1780 n_I3340 n_I3335 n_I3336 VDD_DEC pfet_05v0 L=0.5U W=0.36U AS=0.3852P
+ AD=0.0612P PS=2.86U PD=0.7U
* device instance _1781 r180 *1 559.685,802.518 nfet_05v0
XM_1781 n_I3339 n_I3336 n_I3337 VSS nfet_05v0 L=0.6U W=0.365U AS=0.3705P
+ AD=0.0438P PS=2.77U PD=0.605U
* device instance _1782 r180 *1 558.845,802.518 nfet_05v0
XM_1782 VSS n_I3336 n_I3339 VSS nfet_05v0 L=0.6U W=0.365U AS=0.0438P
+ AD=0.282625P PS=0.605U PD=1.87U
* device instance _1783 r180 *1 557.195,802.29 nfet_05v0
XM_1783 n_179 n_I3337 VSS VSS nfet_05v0 L=0.6U W=0.82U AS=0.282625P AD=0.3608P
+ PS=1.87U PD=2.52U
* device instance _1784 r180 *1 563.925,802.52 nfet_05v0
XM_1784 VSS n_I2279 n_I3335 VSS nfet_05v0 L=0.6U W=0.36U AS=0.333P AD=0.0936P
+ PS=2.57U PD=0.88U
* device instance _1785 r180 *1 562.805,802.52 nfet_05v0
XM_1785 n_I3338 n_I3335 VSS VSS nfet_05v0 L=0.6U W=0.36U AS=0.0936P AD=0.0432P
+ PS=0.88U PD=0.6U
* device instance _1786 r180 *1 561.965,802.52 nfet_05v0
XM_1786 n_I3336 n_I3335 n_I3338 VSS nfet_05v0 L=0.6U W=0.36U AS=0.0432P
+ AD=0.369P PS=0.6U PD=2.77U
* device instance _1787 r0 *1 554.265,790.65 pfet_05v0
XM_1787 n_I3348 n_I3343 n_I3344 VDD_DEC pfet_05v0 L=0.5U W=0.36U AS=0.3456P
+ AD=0.0612P PS=2.64U PD=0.7U
* device instance _1788 r0 *1 555.105,790.65 pfet_05v0
XM_1788 n_I3348 n_I3343 VDD_DEC VDD_DEC pfet_05v0 L=0.5U W=0.36U AS=0.379P
+ AD=0.0612P PS=2.37U PD=0.7U
* device instance _1789 r0 *1 556.755,790.33 pfet_05v0
XM_1789 n_182 n_I3344 VDD_DEC VDD_DEC pfet_05v0 L=0.5U W=1.22U AS=0.379P
+ AD=0.5368P PS=2.37U PD=3.32U
* device instance _1790 r0 *1 550.025,790.76 pfet_05v0
XM_1790 VDD_DEC n_I2162 n_I3342 VDD_DEC pfet_05v0 L=0.5U W=0.36U AS=0.3852P
+ AD=0.1116P PS=2.86U PD=0.98U
* device instance _1791 r0 *1 551.145,790.76 pfet_05v0
XM_1791 n_I3347 n_I3342 VDD_DEC VDD_DEC pfet_05v0 L=0.5U W=0.36U AS=0.1116P
+ AD=0.0612P PS=0.98U PD=0.7U
* device instance _1792 r0 *1 551.985,790.76 pfet_05v0
XM_1792 n_I3347 n_I3342 n_I3343 VDD_DEC pfet_05v0 L=0.5U W=0.36U AS=0.3852P
+ AD=0.0612P PS=2.86U PD=0.7U
* device instance _1793 r0 *1 554.315,787.882 nfet_05v0
XM_1793 n_I3346 n_I3343 n_I3344 VSS nfet_05v0 L=0.6U W=0.365U AS=0.3705P
+ AD=0.0438P PS=2.77U PD=0.605U
* device instance _1794 r0 *1 555.155,787.882 nfet_05v0
XM_1794 VSS n_I3343 n_I3346 VSS nfet_05v0 L=0.6U W=0.365U AS=0.0438P
+ AD=0.282625P PS=0.605U PD=1.87U
* device instance _1795 r0 *1 556.805,788.11 nfet_05v0
XM_1795 n_182 n_I3344 VSS VSS nfet_05v0 L=0.6U W=0.82U AS=0.282625P AD=0.3608P
+ PS=1.87U PD=2.52U
* device instance _1796 r0 *1 550.075,787.88 nfet_05v0
XM_1796 VSS n_I2162 n_I3342 VSS nfet_05v0 L=0.6U W=0.36U AS=0.333P AD=0.0936P
+ PS=2.57U PD=0.88U
* device instance _1797 r0 *1 551.195,787.88 nfet_05v0
XM_1797 n_I3345 n_I3342 VSS VSS nfet_05v0 L=0.6U W=0.36U AS=0.0936P AD=0.0432P
+ PS=0.88U PD=0.6U
* device instance _1798 r0 *1 552.035,787.88 nfet_05v0
XM_1798 n_I3343 n_I3342 n_I3345 VSS nfet_05v0 L=0.6U W=0.36U AS=0.0432P
+ AD=0.369P PS=0.6U PD=2.77U
* device instance _1799 m90 *1 565.895,798.49 pfet_05v0
XM_1799 n_I3355 n_I3350 n_I3351 VDD_DEC pfet_05v0 L=0.5U W=0.36U AS=0.3456P
+ AD=0.0612P PS=2.64U PD=0.7U
* device instance _1800 m90 *1 565.055,798.49 pfet_05v0
XM_1800 n_I3355 n_I3350 VDD_DEC VDD_DEC pfet_05v0 L=0.5U W=0.36U AS=0.379P
+ AD=0.0612P PS=2.37U PD=0.7U
* device instance _1801 m90 *1 563.405,798.17 pfet_05v0
XM_1801 n_147 n_I3351 VDD_DEC VDD_DEC pfet_05v0 L=0.5U W=1.22U AS=0.379P
+ AD=0.5368P PS=2.37U PD=3.32U
* device instance _1802 m90 *1 570.135,798.6 pfet_05v0
XM_1802 VDD_DEC n_I2281 n_I3349 VDD_DEC pfet_05v0 L=0.5U W=0.36U AS=0.3852P
+ AD=0.1116P PS=2.86U PD=0.98U
* device instance _1803 m90 *1 569.015,798.6 pfet_05v0
XM_1803 n_I3354 n_I3349 VDD_DEC VDD_DEC pfet_05v0 L=0.5U W=0.36U AS=0.1116P
+ AD=0.0612P PS=0.98U PD=0.7U
* device instance _1804 m90 *1 568.175,798.6 pfet_05v0
XM_1804 n_I3354 n_I3349 n_I3350 VDD_DEC pfet_05v0 L=0.5U W=0.36U AS=0.3852P
+ AD=0.0612P PS=2.86U PD=0.7U
* device instance _1805 m90 *1 565.845,795.722 nfet_05v0
XM_1805 n_I3353 n_I3350 n_I3351 VSS nfet_05v0 L=0.6U W=0.365U AS=0.3705P
+ AD=0.0438P PS=2.77U PD=0.605U
* device instance _1806 m90 *1 565.005,795.722 nfet_05v0
XM_1806 VSS n_I3350 n_I3353 VSS nfet_05v0 L=0.6U W=0.365U AS=0.0438P
+ AD=0.282625P PS=0.605U PD=1.87U
* device instance _1807 m90 *1 563.355,795.95 nfet_05v0
XM_1807 n_147 n_I3351 VSS VSS nfet_05v0 L=0.6U W=0.82U AS=0.282625P AD=0.3608P
+ PS=1.87U PD=2.52U
* device instance _1808 m90 *1 570.085,795.72 nfet_05v0
XM_1808 VSS n_I2281 n_I3349 VSS nfet_05v0 L=0.6U W=0.36U AS=0.333P AD=0.0936P
+ PS=2.57U PD=0.88U
* device instance _1809 m90 *1 568.965,795.72 nfet_05v0
XM_1809 n_I3352 n_I3349 VSS VSS nfet_05v0 L=0.6U W=0.36U AS=0.0936P AD=0.0432P
+ PS=0.88U PD=0.6U
* device instance _1810 m90 *1 568.125,795.72 nfet_05v0
XM_1810 n_I3350 n_I3349 n_I3352 VSS nfet_05v0 L=0.6U W=0.36U AS=0.0432P
+ AD=0.369P PS=0.6U PD=2.77U
* device instance _1811 r0 *1 563.225,782.81 pfet_05v0
XM_1811 n_I3362 n_I3357 n_I3358 VDD_DEC pfet_05v0 L=0.5U W=0.36U AS=0.3456P
+ AD=0.0612P PS=2.64U PD=0.7U
* device instance _1812 r0 *1 564.065,782.81 pfet_05v0
XM_1812 n_I3362 n_I3357 VDD_DEC VDD_DEC pfet_05v0 L=0.5U W=0.36U AS=0.379P
+ AD=0.0612P PS=2.37U PD=0.7U
* device instance _1813 r0 *1 565.715,782.49 pfet_05v0
XM_1813 n_165 n_I3358 VDD_DEC VDD_DEC pfet_05v0 L=0.5U W=1.22U AS=0.379P
+ AD=0.5368P PS=2.37U PD=3.32U
* device instance _1814 r0 *1 558.985,782.92 pfet_05v0
XM_1814 VDD_DEC n_I2064 n_I3356 VDD_DEC pfet_05v0 L=0.5U W=0.36U AS=0.3852P
+ AD=0.1116P PS=2.86U PD=0.98U
* device instance _1815 r0 *1 560.105,782.92 pfet_05v0
XM_1815 n_I3361 n_I3356 VDD_DEC VDD_DEC pfet_05v0 L=0.5U W=0.36U AS=0.1116P
+ AD=0.0612P PS=0.98U PD=0.7U
* device instance _1816 r0 *1 560.945,782.92 pfet_05v0
XM_1816 n_I3361 n_I3356 n_I3357 VDD_DEC pfet_05v0 L=0.5U W=0.36U AS=0.3852P
+ AD=0.0612P PS=2.86U PD=0.7U
* device instance _1817 r0 *1 563.275,780.042 nfet_05v0
XM_1817 n_I3360 n_I3357 n_I3358 VSS nfet_05v0 L=0.6U W=0.365U AS=0.3705P
+ AD=0.0438P PS=2.77U PD=0.605U
* device instance _1818 r0 *1 564.115,780.042 nfet_05v0
XM_1818 VSS n_I3357 n_I3360 VSS nfet_05v0 L=0.6U W=0.365U AS=0.0438P
+ AD=0.282625P PS=0.605U PD=1.87U
* device instance _1819 r0 *1 565.765,780.27 nfet_05v0
XM_1819 n_165 n_I3358 VSS VSS nfet_05v0 L=0.6U W=0.82U AS=0.282625P AD=0.3608P
+ PS=1.87U PD=2.52U
* device instance _1820 r0 *1 559.035,780.04 nfet_05v0
XM_1820 VSS n_I2064 n_I3356 VSS nfet_05v0 L=0.6U W=0.36U AS=0.333P AD=0.0936P
+ PS=2.57U PD=0.88U
* device instance _1821 r0 *1 560.155,780.04 nfet_05v0
XM_1821 n_I3359 n_I3356 VSS VSS nfet_05v0 L=0.6U W=0.36U AS=0.0936P AD=0.0432P
+ PS=0.88U PD=0.6U
* device instance _1822 r0 *1 560.995,780.04 nfet_05v0
XM_1822 n_I3357 n_I3356 n_I3359 VSS nfet_05v0 L=0.6U W=0.36U AS=0.0432P
+ AD=0.369P PS=0.6U PD=2.77U
* device instance _1823 m90 *1 570.375,790.65 pfet_05v0
XM_1823 n_I3369 n_I3364 n_I3365 VDD_DEC pfet_05v0 L=0.5U W=0.36U AS=0.3456P
+ AD=0.0612P PS=2.64U PD=0.7U
* device instance _1824 m90 *1 569.535,790.65 pfet_05v0
XM_1824 n_I3369 n_I3364 VDD_DEC VDD_DEC pfet_05v0 L=0.5U W=0.36U AS=0.379P
+ AD=0.0612P PS=2.37U PD=0.7U
* device instance _1825 m90 *1 567.885,790.33 pfet_05v0
XM_1825 n_168 n_I3365 VDD_DEC VDD_DEC pfet_05v0 L=0.5U W=1.22U AS=0.379P
+ AD=0.5368P PS=2.37U PD=3.32U
* device instance _1826 m90 *1 574.615,790.76 pfet_05v0
XM_1826 VDD_DEC n_I2164 n_I3363 VDD_DEC pfet_05v0 L=0.5U W=0.36U AS=0.3852P
+ AD=0.1116P PS=2.86U PD=0.98U
* device instance _1827 m90 *1 573.495,790.76 pfet_05v0
XM_1827 n_I3368 n_I3363 VDD_DEC VDD_DEC pfet_05v0 L=0.5U W=0.36U AS=0.1116P
+ AD=0.0612P PS=0.98U PD=0.7U
* device instance _1828 m90 *1 572.655,790.76 pfet_05v0
XM_1828 n_I3368 n_I3363 n_I3364 VDD_DEC pfet_05v0 L=0.5U W=0.36U AS=0.3852P
+ AD=0.0612P PS=2.86U PD=0.7U
* device instance _1829 m90 *1 570.325,787.882 nfet_05v0
XM_1829 n_I3367 n_I3364 n_I3365 VSS nfet_05v0 L=0.6U W=0.365U AS=0.3705P
+ AD=0.0438P PS=2.77U PD=0.605U
* device instance _1830 m90 *1 569.485,787.882 nfet_05v0
XM_1830 VSS n_I3364 n_I3367 VSS nfet_05v0 L=0.6U W=0.365U AS=0.0438P
+ AD=0.282625P PS=0.605U PD=1.87U
* device instance _1831 m90 *1 567.835,788.11 nfet_05v0
XM_1831 n_168 n_I3365 VSS VSS nfet_05v0 L=0.6U W=0.82U AS=0.282625P AD=0.3608P
+ PS=1.87U PD=2.52U
* device instance _1832 m90 *1 574.565,787.88 nfet_05v0
XM_1832 VSS n_I2164 n_I3363 VSS nfet_05v0 L=0.6U W=0.36U AS=0.333P AD=0.0936P
+ PS=2.57U PD=0.88U
* device instance _1833 m90 *1 573.445,787.88 nfet_05v0
XM_1833 n_I3366 n_I3363 VSS VSS nfet_05v0 L=0.6U W=0.36U AS=0.0936P AD=0.0432P
+ PS=0.88U PD=0.6U
* device instance _1834 m90 *1 572.605,787.88 nfet_05v0
XM_1834 n_I3364 n_I3363 n_I3366 VSS nfet_05v0 L=0.6U W=0.36U AS=0.0432P
+ AD=0.369P PS=0.6U PD=2.77U
* device instance _1835 m0 *1 572.185,784.07 pfet_05v0
XM_1835 n_I3376 n_I3371 n_I3372 VDD_DEC pfet_05v0 L=0.5U W=0.36U AS=0.3456P
+ AD=0.0612P PS=2.64U PD=0.7U
* device instance _1836 m0 *1 573.025,784.07 pfet_05v0
XM_1836 n_I3376 n_I3371 VDD_DEC VDD_DEC pfet_05v0 L=0.5U W=0.36U AS=0.379P
+ AD=0.0612P PS=2.37U PD=0.7U
* device instance _1837 m0 *1 574.675,784.39 pfet_05v0
XM_1837 n_177 n_I3372 VDD_DEC VDD_DEC pfet_05v0 L=0.5U W=1.22U AS=0.379P
+ AD=0.5368P PS=2.37U PD=3.32U
* device instance _1838 m0 *1 567.945,783.96 pfet_05v0
XM_1838 VDD_DEC n_I2132 n_I3370 VDD_DEC pfet_05v0 L=0.5U W=0.36U AS=0.3852P
+ AD=0.1116P PS=2.86U PD=0.98U
* device instance _1839 m0 *1 569.065,783.96 pfet_05v0
XM_1839 n_I3375 n_I3370 VDD_DEC VDD_DEC pfet_05v0 L=0.5U W=0.36U AS=0.1116P
+ AD=0.0612P PS=0.98U PD=0.7U
* device instance _1840 m0 *1 569.905,783.96 pfet_05v0
XM_1840 n_I3375 n_I3370 n_I3371 VDD_DEC pfet_05v0 L=0.5U W=0.36U AS=0.3852P
+ AD=0.0612P PS=2.86U PD=0.7U
* device instance _1841 m0 *1 572.235,786.838 nfet_05v0
XM_1841 n_I3374 n_I3371 n_I3372 VSS nfet_05v0 L=0.6U W=0.365U AS=0.3705P
+ AD=0.0438P PS=2.77U PD=0.605U
* device instance _1842 m0 *1 573.075,786.838 nfet_05v0
XM_1842 VSS n_I3371 n_I3374 VSS nfet_05v0 L=0.6U W=0.365U AS=0.0438P
+ AD=0.282625P PS=0.605U PD=1.87U
* device instance _1843 m0 *1 574.725,786.61 nfet_05v0
XM_1843 n_177 n_I3372 VSS VSS nfet_05v0 L=0.6U W=0.82U AS=0.282625P AD=0.3608P
+ PS=1.87U PD=2.52U
* device instance _1844 m0 *1 567.995,786.84 nfet_05v0
XM_1844 VSS n_I2132 n_I3370 VSS nfet_05v0 L=0.6U W=0.36U AS=0.333P AD=0.0936P
+ PS=2.57U PD=0.88U
* device instance _1845 m0 *1 569.115,786.84 nfet_05v0
XM_1845 n_I3373 n_I3370 VSS VSS nfet_05v0 L=0.6U W=0.36U AS=0.0936P AD=0.0432P
+ PS=0.88U PD=0.6U
* device instance _1846 m0 *1 569.955,786.84 nfet_05v0
XM_1846 n_I3371 n_I3370 n_I3373 VSS nfet_05v0 L=0.6U W=0.36U AS=0.0432P
+ AD=0.369P PS=0.6U PD=2.77U
* device instance _1847 r180 *1 578.215,791.91 pfet_05v0
XM_1847 n_I3383 n_I3378 n_I3379 VDD_DEC pfet_05v0 L=0.5U W=0.36U AS=0.3456P
+ AD=0.0612P PS=2.64U PD=0.7U
* device instance _1848 r180 *1 577.375,791.91 pfet_05v0
XM_1848 n_I3383 n_I3378 VDD_DEC VDD_DEC pfet_05v0 L=0.5U W=0.36U AS=0.379P
+ AD=0.0612P PS=2.37U PD=0.7U
* device instance _1849 r180 *1 575.725,792.23 pfet_05v0
XM_1849 n_180 n_I3379 VDD_DEC VDD_DEC pfet_05v0 L=0.5U W=1.22U AS=0.379P
+ AD=0.5368P PS=2.37U PD=3.32U
* device instance _1850 r180 *1 582.455,791.8 pfet_05v0
XM_1850 VDD_DEC n_I2209 n_I3377 VDD_DEC pfet_05v0 L=0.5U W=0.36U AS=0.3852P
+ AD=0.1116P PS=2.86U PD=0.98U
* device instance _1851 r180 *1 581.335,791.8 pfet_05v0
XM_1851 n_I3382 n_I3377 VDD_DEC VDD_DEC pfet_05v0 L=0.5U W=0.36U AS=0.1116P
+ AD=0.0612P PS=0.98U PD=0.7U
* device instance _1852 r180 *1 580.495,791.8 pfet_05v0
XM_1852 n_I3382 n_I3377 n_I3378 VDD_DEC pfet_05v0 L=0.5U W=0.36U AS=0.3852P
+ AD=0.0612P PS=2.86U PD=0.7U
* device instance _1853 r180 *1 578.165,794.678 nfet_05v0
XM_1853 n_I3381 n_I3378 n_I3379 VSS nfet_05v0 L=0.6U W=0.365U AS=0.3705P
+ AD=0.0438P PS=2.77U PD=0.605U
* device instance _1854 r180 *1 577.325,794.678 nfet_05v0
XM_1854 VSS n_I3378 n_I3381 VSS nfet_05v0 L=0.6U W=0.365U AS=0.0438P
+ AD=0.282625P PS=0.605U PD=1.87U
* device instance _1855 r180 *1 575.675,794.45 nfet_05v0
XM_1855 n_180 n_I3379 VSS VSS nfet_05v0 L=0.6U W=0.82U AS=0.282625P AD=0.3608P
+ PS=1.87U PD=2.52U
* device instance _1856 r180 *1 582.405,794.68 nfet_05v0
XM_1856 VSS n_I2209 n_I3377 VSS nfet_05v0 L=0.6U W=0.36U AS=0.333P AD=0.0936P
+ PS=2.57U PD=0.88U
* device instance _1857 r180 *1 581.285,794.68 nfet_05v0
XM_1857 n_I3380 n_I3377 VSS VSS nfet_05v0 L=0.6U W=0.36U AS=0.0936P AD=0.0432P
+ PS=0.88U PD=0.6U
* device instance _1858 r180 *1 580.445,794.68 nfet_05v0
XM_1858 n_I3378 n_I3377 n_I3380 VSS nfet_05v0 L=0.6U W=0.36U AS=0.0432P
+ AD=0.369P PS=0.6U PD=2.77U
* device instance _1859 m90 *1 579.335,790.65 pfet_05v0
XM_1859 n_I3390 n_I3385 n_I3386 VDD_DEC pfet_05v0 L=0.5U W=0.36U AS=0.3456P
+ AD=0.0612P PS=2.64U PD=0.7U
* device instance _1860 m90 *1 578.495,790.65 pfet_05v0
XM_1860 n_I3390 n_I3385 VDD_DEC VDD_DEC pfet_05v0 L=0.5U W=0.36U AS=0.379P
+ AD=0.0612P PS=2.37U PD=0.7U
* device instance _1861 m90 *1 576.845,790.33 pfet_05v0
XM_1861 n_186 n_I3386 VDD_DEC VDD_DEC pfet_05v0 L=0.5U W=1.22U AS=0.379P
+ AD=0.5368P PS=2.37U PD=3.32U
* device instance _1862 m90 *1 583.575,790.76 pfet_05v0
XM_1862 VDD_DEC n_I2170 n_I3384 VDD_DEC pfet_05v0 L=0.5U W=0.36U AS=0.3852P
+ AD=0.1116P PS=2.86U PD=0.98U
* device instance _1863 m90 *1 582.455,790.76 pfet_05v0
XM_1863 n_I3389 n_I3384 VDD_DEC VDD_DEC pfet_05v0 L=0.5U W=0.36U AS=0.1116P
+ AD=0.0612P PS=0.98U PD=0.7U
* device instance _1864 m90 *1 581.615,790.76 pfet_05v0
XM_1864 n_I3389 n_I3384 n_I3385 VDD_DEC pfet_05v0 L=0.5U W=0.36U AS=0.3852P
+ AD=0.0612P PS=2.86U PD=0.7U
* device instance _1865 m90 *1 579.285,787.882 nfet_05v0
XM_1865 n_I3388 n_I3385 n_I3386 VSS nfet_05v0 L=0.6U W=0.365U AS=0.3705P
+ AD=0.0438P PS=2.77U PD=0.605U
* device instance _1866 m90 *1 578.445,787.882 nfet_05v0
XM_1866 VSS n_I3385 n_I3388 VSS nfet_05v0 L=0.6U W=0.365U AS=0.0438P
+ AD=0.282625P PS=0.605U PD=1.87U
* device instance _1867 m90 *1 576.795,788.11 nfet_05v0
XM_1867 n_186 n_I3386 VSS VSS nfet_05v0 L=0.6U W=0.82U AS=0.282625P AD=0.3608P
+ PS=1.87U PD=2.52U
* device instance _1868 m90 *1 583.525,787.88 nfet_05v0
XM_1868 VSS n_I2170 n_I3384 VSS nfet_05v0 L=0.6U W=0.36U AS=0.333P AD=0.0936P
+ PS=2.57U PD=0.88U
* device instance _1869 m90 *1 582.405,787.88 nfet_05v0
XM_1869 n_I3387 n_I3384 VSS VSS nfet_05v0 L=0.6U W=0.36U AS=0.0936P AD=0.0432P
+ PS=0.88U PD=0.6U
* device instance _1870 m90 *1 581.565,787.88 nfet_05v0
XM_1870 n_I3385 n_I3384 n_I3387 VSS nfet_05v0 L=0.6U W=0.36U AS=0.0432P
+ AD=0.369P PS=0.6U PD=2.77U
* device instance _1871 r180 *1 579.335,784.07 pfet_05v0
XM_1871 n_I3397 n_I3392 n_I3393 VDD_DEC pfet_05v0 L=0.5U W=0.36U AS=0.3456P
+ AD=0.0612P PS=2.64U PD=0.7U
* device instance _1872 r180 *1 578.495,784.07 pfet_05v0
XM_1872 n_I3397 n_I3392 VDD_DEC VDD_DEC pfet_05v0 L=0.5U W=0.36U AS=0.379P
+ AD=0.0612P PS=2.37U PD=0.7U
* device instance _1873 r180 *1 576.845,784.39 pfet_05v0
XM_1873 n_82 n_I3393 VDD_DEC VDD_DEC pfet_05v0 L=0.5U W=1.22U AS=0.379P
+ AD=0.5368P PS=2.37U PD=3.32U
* device instance _1874 r180 *1 583.575,783.96 pfet_05v0
XM_1874 VDD_DEC n_I2134 n_I3391 VDD_DEC pfet_05v0 L=0.5U W=0.36U AS=0.3852P
+ AD=0.1116P PS=2.86U PD=0.98U
* device instance _1875 r180 *1 582.455,783.96 pfet_05v0
XM_1875 n_I3396 n_I3391 VDD_DEC VDD_DEC pfet_05v0 L=0.5U W=0.36U AS=0.1116P
+ AD=0.0612P PS=0.98U PD=0.7U
* device instance _1876 r180 *1 581.615,783.96 pfet_05v0
XM_1876 n_I3396 n_I3391 n_I3392 VDD_DEC pfet_05v0 L=0.5U W=0.36U AS=0.3852P
+ AD=0.0612P PS=2.86U PD=0.7U
* device instance _1877 r180 *1 579.285,786.838 nfet_05v0
XM_1877 n_I3395 n_I3392 n_I3393 VSS nfet_05v0 L=0.6U W=0.365U AS=0.3705P
+ AD=0.0438P PS=2.77U PD=0.605U
* device instance _1878 r180 *1 578.445,786.838 nfet_05v0
XM_1878 VSS n_I3392 n_I3395 VSS nfet_05v0 L=0.6U W=0.365U AS=0.0438P
+ AD=0.282625P PS=0.605U PD=1.87U
* device instance _1879 r180 *1 576.795,786.61 nfet_05v0
XM_1879 n_82 n_I3393 VSS VSS nfet_05v0 L=0.6U W=0.82U AS=0.282625P AD=0.3608P
+ PS=1.87U PD=2.52U
* device instance _1880 r180 *1 583.525,786.84 nfet_05v0
XM_1880 VSS n_I2134 n_I3391 VSS nfet_05v0 L=0.6U W=0.36U AS=0.333P AD=0.0936P
+ PS=2.57U PD=0.88U
* device instance _1881 r180 *1 582.405,786.84 nfet_05v0
XM_1881 n_I3394 n_I3391 VSS VSS nfet_05v0 L=0.6U W=0.36U AS=0.0936P AD=0.0432P
+ PS=0.88U PD=0.6U
* device instance _1882 r180 *1 581.565,786.84 nfet_05v0
XM_1882 n_I3392 n_I3391 n_I3394 VSS nfet_05v0 L=0.6U W=0.36U AS=0.0432P
+ AD=0.369P PS=0.6U PD=2.77U
* device instance _1883 r0 *1 578.345,774.97 pfet_05v0
XM_1883 n_I3404 n_I3399 n_I3400 VDD_DEC pfet_05v0 L=0.5U W=0.36U AS=0.3456P
+ AD=0.0612P PS=2.64U PD=0.7U
* device instance _1884 r0 *1 579.185,774.97 pfet_05v0
XM_1884 n_I3404 n_I3399 VDD_DEC VDD_DEC pfet_05v0 L=0.5U W=0.36U AS=0.379P
+ AD=0.0612P PS=2.37U PD=0.7U
* device instance _1885 r0 *1 580.835,774.65 pfet_05v0
XM_1885 n_86 n_I3400 VDD_DEC VDD_DEC pfet_05v0 L=0.5U W=1.22U AS=0.379P
+ AD=0.5368P PS=2.37U PD=3.32U
* device instance _1886 r0 *1 574.105,775.08 pfet_05v0
XM_1886 VDD_DEC n_I2028 n_I3398 VDD_DEC pfet_05v0 L=0.5U W=0.36U AS=0.3852P
+ AD=0.1116P PS=2.86U PD=0.98U
* device instance _1887 r0 *1 575.225,775.08 pfet_05v0
XM_1887 n_I3403 n_I3398 VDD_DEC VDD_DEC pfet_05v0 L=0.5U W=0.36U AS=0.1116P
+ AD=0.0612P PS=0.98U PD=0.7U
* device instance _1888 r0 *1 576.065,775.08 pfet_05v0
XM_1888 n_I3403 n_I3398 n_I3399 VDD_DEC pfet_05v0 L=0.5U W=0.36U AS=0.3852P
+ AD=0.0612P PS=2.86U PD=0.7U
* device instance _1889 r0 *1 578.395,772.202 nfet_05v0
XM_1889 n_I3402 n_I3399 n_I3400 VSS nfet_05v0 L=0.6U W=0.365U AS=0.3705P
+ AD=0.0438P PS=2.77U PD=0.605U
* device instance _1890 r0 *1 579.235,772.202 nfet_05v0
XM_1890 VSS n_I3399 n_I3402 VSS nfet_05v0 L=0.6U W=0.365U AS=0.0438P
+ AD=0.282625P PS=0.605U PD=1.87U
* device instance _1891 r0 *1 580.885,772.43 nfet_05v0
XM_1891 n_86 n_I3400 VSS VSS nfet_05v0 L=0.6U W=0.82U AS=0.282625P AD=0.3608P
+ PS=1.87U PD=2.52U
* device instance _1892 r0 *1 574.155,772.2 nfet_05v0
XM_1892 VSS n_I2028 n_I3398 VSS nfet_05v0 L=0.6U W=0.36U AS=0.333P AD=0.0936P
+ PS=2.57U PD=0.88U
* device instance _1893 r0 *1 575.275,772.2 nfet_05v0
XM_1893 n_I3401 n_I3398 VSS VSS nfet_05v0 L=0.6U W=0.36U AS=0.0936P AD=0.0432P
+ PS=0.88U PD=0.6U
* device instance _1894 r0 *1 576.115,772.2 nfet_05v0
XM_1894 n_I3399 n_I3398 n_I3401 VSS nfet_05v0 L=0.6U W=0.36U AS=0.0432P
+ AD=0.369P PS=0.6U PD=2.77U
* device instance _1895 r180 *1 588.295,784.07 pfet_05v0
XM_1895 n_I3411 n_I3406 n_I3407 VDD_DEC pfet_05v0 L=0.5U W=0.36U AS=0.3456P
+ AD=0.0612P PS=2.64U PD=0.7U
* device instance _1896 r180 *1 587.455,784.07 pfet_05v0
XM_1896 n_I3411 n_I3406 VDD_DEC VDD_DEC pfet_05v0 L=0.5U W=0.36U AS=0.379P
+ AD=0.0612P PS=2.37U PD=0.7U
* device instance _1897 r180 *1 585.805,784.39 pfet_05v0
XM_1897 n_90 n_I3407 VDD_DEC VDD_DEC pfet_05v0 L=0.5U W=1.22U AS=0.379P
+ AD=0.5368P PS=2.37U PD=3.32U
* device instance _1898 r180 *1 592.535,783.96 pfet_05v0
XM_1898 VDD_DEC n_I2135 n_I3405 VDD_DEC pfet_05v0 L=0.5U W=0.36U AS=0.3852P
+ AD=0.1116P PS=2.86U PD=0.98U
* device instance _1899 r180 *1 591.415,783.96 pfet_05v0
XM_1899 n_I3410 n_I3405 VDD_DEC VDD_DEC pfet_05v0 L=0.5U W=0.36U AS=0.1116P
+ AD=0.0612P PS=0.98U PD=0.7U
* device instance _1900 r180 *1 590.575,783.96 pfet_05v0
XM_1900 n_I3410 n_I3405 n_I3406 VDD_DEC pfet_05v0 L=0.5U W=0.36U AS=0.3852P
+ AD=0.0612P PS=2.86U PD=0.7U
* device instance _1901 r180 *1 588.245,786.838 nfet_05v0
XM_1901 n_I3409 n_I3406 n_I3407 VSS nfet_05v0 L=0.6U W=0.365U AS=0.3705P
+ AD=0.0438P PS=2.77U PD=0.605U
* device instance _1902 r180 *1 587.405,786.838 nfet_05v0
XM_1902 VSS n_I3406 n_I3409 VSS nfet_05v0 L=0.6U W=0.365U AS=0.0438P
+ AD=0.282625P PS=0.605U PD=1.87U
* device instance _1903 r180 *1 585.755,786.61 nfet_05v0
XM_1903 n_90 n_I3407 VSS VSS nfet_05v0 L=0.6U W=0.82U AS=0.282625P AD=0.3608P
+ PS=1.87U PD=2.52U
* device instance _1904 r180 *1 592.485,786.84 nfet_05v0
XM_1904 VSS n_I2135 n_I3405 VSS nfet_05v0 L=0.6U W=0.36U AS=0.333P AD=0.0936P
+ PS=2.57U PD=0.88U
* device instance _1905 r180 *1 591.365,786.84 nfet_05v0
XM_1905 n_I3408 n_I3405 VSS VSS nfet_05v0 L=0.6U W=0.36U AS=0.0936P AD=0.0432P
+ PS=0.88U PD=0.6U
* device instance _1906 r180 *1 590.525,786.84 nfet_05v0
XM_1906 n_I3406 n_I3405 n_I3408 VSS nfet_05v0 L=0.6U W=0.36U AS=0.0432P
+ AD=0.369P PS=0.6U PD=2.77U
* device instance _1907 r180 *1 589.415,776.23 pfet_05v0
XM_1907 n_I3418 n_I3413 n_I3414 VDD_DEC pfet_05v0 L=0.5U W=0.36U AS=0.3456P
+ AD=0.0612P PS=2.64U PD=0.7U
* device instance _1908 r180 *1 588.575,776.23 pfet_05v0
XM_1908 n_I3418 n_I3413 VDD_DEC VDD_DEC pfet_05v0 L=0.5U W=0.36U AS=0.379P
+ AD=0.0612P PS=2.37U PD=0.7U
* device instance _1909 r180 *1 586.925,776.55 pfet_05v0
XM_1909 n_92 n_I3414 VDD_DEC VDD_DEC pfet_05v0 L=0.5U W=1.22U AS=0.379P
+ AD=0.5368P PS=2.37U PD=3.32U
* device instance _1910 r180 *1 593.655,776.12 pfet_05v0
XM_1910 VDD_DEC n_I2069 n_I3412 VDD_DEC pfet_05v0 L=0.5U W=0.36U AS=0.3852P
+ AD=0.1116P PS=2.86U PD=0.98U
* device instance _1911 r180 *1 592.535,776.12 pfet_05v0
XM_1911 n_I3417 n_I3412 VDD_DEC VDD_DEC pfet_05v0 L=0.5U W=0.36U AS=0.1116P
+ AD=0.0612P PS=0.98U PD=0.7U
* device instance _1912 r180 *1 591.695,776.12 pfet_05v0
XM_1912 n_I3417 n_I3412 n_I3413 VDD_DEC pfet_05v0 L=0.5U W=0.36U AS=0.3852P
+ AD=0.0612P PS=2.86U PD=0.7U
* device instance _1913 r180 *1 589.365,778.998 nfet_05v0
XM_1913 n_I3416 n_I3413 n_I3414 VSS nfet_05v0 L=0.6U W=0.365U AS=0.3705P
+ AD=0.0438P PS=2.77U PD=0.605U
* device instance _1914 r180 *1 588.525,778.998 nfet_05v0
XM_1914 VSS n_I3413 n_I3416 VSS nfet_05v0 L=0.6U W=0.365U AS=0.0438P
+ AD=0.282625P PS=0.605U PD=1.87U
* device instance _1915 r180 *1 586.875,778.77 nfet_05v0
XM_1915 n_92 n_I3414 VSS VSS nfet_05v0 L=0.6U W=0.82U AS=0.282625P AD=0.3608P
+ PS=1.87U PD=2.52U
* device instance _1916 r180 *1 593.605,779 nfet_05v0
XM_1916 VSS n_I2069 n_I3412 VSS nfet_05v0 L=0.6U W=0.36U AS=0.333P AD=0.0936P
+ PS=2.57U PD=0.88U
* device instance _1917 r180 *1 592.485,779 nfet_05v0
XM_1917 n_I3415 n_I3412 VSS VSS nfet_05v0 L=0.6U W=0.36U AS=0.0936P AD=0.0432P
+ PS=0.88U PD=0.6U
* device instance _1918 r180 *1 591.645,779 nfet_05v0
XM_1918 n_I3413 n_I3412 n_I3415 VSS nfet_05v0 L=0.6U W=0.36U AS=0.0432P
+ AD=0.369P PS=0.6U PD=2.77U
* device instance _1919 m90 *1 590.535,774.97 pfet_05v0
XM_1919 n_I3425 n_I3420 n_I3421 VDD_DEC pfet_05v0 L=0.5U W=0.36U AS=0.3456P
+ AD=0.0612P PS=2.64U PD=0.7U
* device instance _1920 m90 *1 589.695,774.97 pfet_05v0
XM_1920 n_I3425 n_I3420 VDD_DEC VDD_DEC pfet_05v0 L=0.5U W=0.36U AS=0.379P
+ AD=0.0612P PS=2.37U PD=0.7U
* device instance _1921 m90 *1 588.045,774.65 pfet_05v0
XM_1921 n_94 n_I3421 VDD_DEC VDD_DEC pfet_05v0 L=0.5U W=1.22U AS=0.379P
+ AD=0.5368P PS=2.37U PD=3.32U
* device instance _1922 m90 *1 594.775,775.08 pfet_05v0
XM_1922 VDD_DEC n_I2029 n_I3419 VDD_DEC pfet_05v0 L=0.5U W=0.36U AS=0.3852P
+ AD=0.1116P PS=2.86U PD=0.98U
* device instance _1923 m90 *1 593.655,775.08 pfet_05v0
XM_1923 n_I3424 n_I3419 VDD_DEC VDD_DEC pfet_05v0 L=0.5U W=0.36U AS=0.1116P
+ AD=0.0612P PS=0.98U PD=0.7U
* device instance _1924 m90 *1 592.815,775.08 pfet_05v0
XM_1924 n_I3424 n_I3419 n_I3420 VDD_DEC pfet_05v0 L=0.5U W=0.36U AS=0.3852P
+ AD=0.0612P PS=2.86U PD=0.7U
* device instance _1925 m90 *1 590.485,772.202 nfet_05v0
XM_1925 n_I3423 n_I3420 n_I3421 VSS nfet_05v0 L=0.6U W=0.365U AS=0.3705P
+ AD=0.0438P PS=2.77U PD=0.605U
* device instance _1926 m90 *1 589.645,772.202 nfet_05v0
XM_1926 VSS n_I3420 n_I3423 VSS nfet_05v0 L=0.6U W=0.365U AS=0.0438P
+ AD=0.282625P PS=0.605U PD=1.87U
* device instance _1927 m90 *1 587.995,772.43 nfet_05v0
XM_1927 n_94 n_I3421 VSS VSS nfet_05v0 L=0.6U W=0.82U AS=0.282625P AD=0.3608P
+ PS=1.87U PD=2.52U
* device instance _1928 m90 *1 594.725,772.2 nfet_05v0
XM_1928 VSS n_I2029 n_I3419 VSS nfet_05v0 L=0.6U W=0.36U AS=0.333P AD=0.0936P
+ PS=2.57U PD=0.88U
* device instance _1929 m90 *1 593.605,772.2 nfet_05v0
XM_1929 n_I3422 n_I3419 VSS VSS nfet_05v0 L=0.6U W=0.36U AS=0.0936P AD=0.0432P
+ PS=0.88U PD=0.6U
* device instance _1930 m90 *1 592.765,772.2 nfet_05v0
XM_1930 n_I3420 n_I3419 n_I3422 VSS nfet_05v0 L=0.6U W=0.36U AS=0.0432P
+ AD=0.369P PS=0.6U PD=2.77U
* device instance _1931 m90 *1 591.655,782.81 pfet_05v0
XM_1931 n_I3432 n_I3427 n_I3428 VDD_DEC pfet_05v0 L=0.5U W=0.36U AS=0.3456P
+ AD=0.0612P PS=2.64U PD=0.7U
* device instance _1932 m90 *1 590.815,782.81 pfet_05v0
XM_1932 n_I3432 n_I3427 VDD_DEC VDD_DEC pfet_05v0 L=0.5U W=0.36U AS=0.379P
+ AD=0.0612P PS=2.37U PD=0.7U
* device instance _1933 m90 *1 589.165,782.49 pfet_05v0
XM_1933 n_96 n_I3428 VDD_DEC VDD_DEC pfet_05v0 L=0.5U W=1.22U AS=0.379P
+ AD=0.5368P PS=2.37U PD=3.32U
* device instance _1934 m90 *1 595.895,782.92 pfet_05v0
XM_1934 VDD_DEC n_I2068 n_I3426 VDD_DEC pfet_05v0 L=0.5U W=0.36U AS=0.3852P
+ AD=0.1116P PS=2.86U PD=0.98U
* device instance _1935 m90 *1 594.775,782.92 pfet_05v0
XM_1935 n_I3431 n_I3426 VDD_DEC VDD_DEC pfet_05v0 L=0.5U W=0.36U AS=0.1116P
+ AD=0.0612P PS=0.98U PD=0.7U
* device instance _1936 m90 *1 593.935,782.92 pfet_05v0
XM_1936 n_I3431 n_I3426 n_I3427 VDD_DEC pfet_05v0 L=0.5U W=0.36U AS=0.3852P
+ AD=0.0612P PS=2.86U PD=0.7U
* device instance _1937 m90 *1 591.605,780.042 nfet_05v0
XM_1937 n_I3430 n_I3427 n_I3428 VSS nfet_05v0 L=0.6U W=0.365U AS=0.3705P
+ AD=0.0438P PS=2.77U PD=0.605U
* device instance _1938 m90 *1 590.765,780.042 nfet_05v0
XM_1938 VSS n_I3427 n_I3430 VSS nfet_05v0 L=0.6U W=0.365U AS=0.0438P
+ AD=0.282625P PS=0.605U PD=1.87U
* device instance _1939 m90 *1 589.115,780.27 nfet_05v0
XM_1939 n_96 n_I3428 VSS VSS nfet_05v0 L=0.6U W=0.82U AS=0.282625P AD=0.3608P
+ PS=1.87U PD=2.52U
* device instance _1940 m90 *1 595.845,780.04 nfet_05v0
XM_1940 VSS n_I2068 n_I3426 VSS nfet_05v0 L=0.6U W=0.36U AS=0.333P AD=0.0936P
+ PS=2.57U PD=0.88U
* device instance _1941 m90 *1 594.725,780.04 nfet_05v0
XM_1941 n_I3429 n_I3426 VSS VSS nfet_05v0 L=0.6U W=0.36U AS=0.0936P AD=0.0432P
+ PS=0.88U PD=0.6U
* device instance _1942 m90 *1 593.885,780.04 nfet_05v0
XM_1942 n_I3427 n_I3426 n_I3429 VSS nfet_05v0 L=0.6U W=0.36U AS=0.0432P
+ AD=0.369P PS=0.6U PD=2.77U
* device instance _1943 r180 *1 598.375,776.23 pfet_05v0
XM_1943 n_I3439 n_I3434 n_I3435 VDD_DEC pfet_05v0 L=0.5U W=0.36U AS=0.3456P
+ AD=0.0612P PS=2.64U PD=0.7U
* device instance _1944 r180 *1 597.535,776.23 pfet_05v0
XM_1944 n_I3439 n_I3434 VDD_DEC VDD_DEC pfet_05v0 L=0.5U W=0.36U AS=0.379P
+ AD=0.0612P PS=2.37U PD=0.7U
* device instance _1945 r180 *1 595.885,776.55 pfet_05v0
XM_1945 n_98 n_I3435 VDD_DEC VDD_DEC pfet_05v0 L=0.5U W=1.22U AS=0.379P
+ AD=0.5368P PS=2.37U PD=3.32U
* device instance _1946 r180 *1 602.615,776.12 pfet_05v0
XM_1946 VDD_DEC n_I2238 n_I3433 VDD_DEC pfet_05v0 L=0.5U W=0.36U AS=0.3852P
+ AD=0.1116P PS=2.86U PD=0.98U
* device instance _1947 r180 *1 601.495,776.12 pfet_05v0
XM_1947 n_I3438 n_I3433 VDD_DEC VDD_DEC pfet_05v0 L=0.5U W=0.36U AS=0.1116P
+ AD=0.0612P PS=0.98U PD=0.7U
* device instance _1948 r180 *1 600.655,776.12 pfet_05v0
XM_1948 n_I3438 n_I3433 n_I3434 VDD_DEC pfet_05v0 L=0.5U W=0.36U AS=0.3852P
+ AD=0.0612P PS=2.86U PD=0.7U
* device instance _1949 r180 *1 598.325,778.998 nfet_05v0
XM_1949 n_I3437 n_I3434 n_I3435 VSS nfet_05v0 L=0.6U W=0.365U AS=0.3705P
+ AD=0.0438P PS=2.77U PD=0.605U
* device instance _1950 r180 *1 597.485,778.998 nfet_05v0
XM_1950 VSS n_I3434 n_I3437 VSS nfet_05v0 L=0.6U W=0.365U AS=0.0438P
+ AD=0.282625P PS=0.605U PD=1.87U
* device instance _1951 r180 *1 595.835,778.77 nfet_05v0
XM_1951 n_98 n_I3435 VSS VSS nfet_05v0 L=0.6U W=0.82U AS=0.282625P AD=0.3608P
+ PS=1.87U PD=2.52U
* device instance _1952 r180 *1 602.565,779 nfet_05v0
XM_1952 VSS n_I2238 n_I3433 VSS nfet_05v0 L=0.6U W=0.36U AS=0.333P AD=0.0936P
+ PS=2.57U PD=0.88U
* device instance _1953 r180 *1 601.445,779 nfet_05v0
XM_1953 n_I3436 n_I3433 VSS VSS nfet_05v0 L=0.6U W=0.36U AS=0.0936P AD=0.0432P
+ PS=0.88U PD=0.6U
* device instance _1954 r180 *1 600.605,779 nfet_05v0
XM_1954 n_I3434 n_I3433 n_I3436 VSS nfet_05v0 L=0.6U W=0.36U AS=0.0432P
+ AD=0.369P PS=0.6U PD=2.77U
* device instance _1955 m90 *1 605.655,774.97 pfet_05v0
XM_1955 n_I3446 n_I3441 n_I3442 VDD_DEC pfet_05v0 L=0.5U W=0.36U AS=0.3456P
+ AD=0.0612P PS=2.64U PD=0.7U
* device instance _1956 m90 *1 604.815,774.97 pfet_05v0
XM_1956 n_I3446 n_I3441 VDD_DEC VDD_DEC pfet_05v0 L=0.5U W=0.36U AS=0.379P
+ AD=0.0612P PS=2.37U PD=0.7U
* device instance _1957 m90 *1 603.165,774.65 pfet_05v0
XM_1957 n_100 n_I3442 VDD_DEC VDD_DEC pfet_05v0 L=0.5U W=1.22U AS=0.379P
+ AD=0.5368P PS=2.37U PD=3.32U
* device instance _1958 m90 *1 609.895,775.08 pfet_05v0
XM_1958 VDD_DEC n_I2253 n_I3440 VDD_DEC pfet_05v0 L=0.5U W=0.36U AS=0.3852P
+ AD=0.1116P PS=2.86U PD=0.98U
* device instance _1959 m90 *1 608.775,775.08 pfet_05v0
XM_1959 n_I3445 n_I3440 VDD_DEC VDD_DEC pfet_05v0 L=0.5U W=0.36U AS=0.1116P
+ AD=0.0612P PS=0.98U PD=0.7U
* device instance _1960 m90 *1 607.935,775.08 pfet_05v0
XM_1960 n_I3445 n_I3440 n_I3441 VDD_DEC pfet_05v0 L=0.5U W=0.36U AS=0.3852P
+ AD=0.0612P PS=2.86U PD=0.7U
* device instance _1961 m90 *1 605.605,772.202 nfet_05v0
XM_1961 n_I3444 n_I3441 n_I3442 VSS nfet_05v0 L=0.6U W=0.365U AS=0.3705P
+ AD=0.0438P PS=2.77U PD=0.605U
* device instance _1962 m90 *1 604.765,772.202 nfet_05v0
XM_1962 VSS n_I3441 n_I3444 VSS nfet_05v0 L=0.6U W=0.365U AS=0.0438P
+ AD=0.282625P PS=0.605U PD=1.87U
* device instance _1963 m90 *1 603.115,772.43 nfet_05v0
XM_1963 n_100 n_I3442 VSS VSS nfet_05v0 L=0.6U W=0.82U AS=0.282625P AD=0.3608P
+ PS=1.87U PD=2.52U
* device instance _1964 m90 *1 609.845,772.2 nfet_05v0
XM_1964 VSS n_I2253 n_I3440 VSS nfet_05v0 L=0.6U W=0.36U AS=0.333P AD=0.0936P
+ PS=2.57U PD=0.88U
* device instance _1965 m90 *1 608.725,772.2 nfet_05v0
XM_1965 n_I3443 n_I3440 VSS VSS nfet_05v0 L=0.6U W=0.36U AS=0.0936P AD=0.0432P
+ PS=0.88U PD=0.6U
* device instance _1966 m90 *1 607.885,772.2 nfet_05v0
XM_1966 n_I3441 n_I3440 n_I3443 VSS nfet_05v0 L=0.6U W=0.36U AS=0.0432P
+ AD=0.369P PS=0.6U PD=2.77U
* device instance _1967 m90 *1 600.615,782.81 pfet_05v0
XM_1967 n_I3453 n_I3448 n_I3449 VDD_DEC pfet_05v0 L=0.5U W=0.36U AS=0.3456P
+ AD=0.0612P PS=2.64U PD=0.7U
* device instance _1968 m90 *1 599.775,782.81 pfet_05v0
XM_1968 n_I3453 n_I3448 VDD_DEC VDD_DEC pfet_05v0 L=0.5U W=0.36U AS=0.379P
+ AD=0.0612P PS=2.37U PD=0.7U
* device instance _1969 m90 *1 598.125,782.49 pfet_05v0
XM_1969 n_102 n_I3449 VDD_DEC VDD_DEC pfet_05v0 L=0.5U W=1.22U AS=0.379P
+ AD=0.5368P PS=2.37U PD=3.32U
* device instance _1970 m90 *1 604.855,782.92 pfet_05v0
XM_1970 VDD_DEC n_I2166 n_I3447 VDD_DEC pfet_05v0 L=0.5U W=0.36U AS=0.3852P
+ AD=0.1116P PS=2.86U PD=0.98U
* device instance _1971 m90 *1 603.735,782.92 pfet_05v0
XM_1971 n_I3452 n_I3447 VDD_DEC VDD_DEC pfet_05v0 L=0.5U W=0.36U AS=0.1116P
+ AD=0.0612P PS=0.98U PD=0.7U
* device instance _1972 m90 *1 602.895,782.92 pfet_05v0
XM_1972 n_I3452 n_I3447 n_I3448 VDD_DEC pfet_05v0 L=0.5U W=0.36U AS=0.3852P
+ AD=0.0612P PS=2.86U PD=0.7U
* device instance _1973 m90 *1 600.565,780.042 nfet_05v0
XM_1973 n_I3451 n_I3448 n_I3449 VSS nfet_05v0 L=0.6U W=0.365U AS=0.3705P
+ AD=0.0438P PS=2.77U PD=0.605U
* device instance _1974 m90 *1 599.725,780.042 nfet_05v0
XM_1974 VSS n_I3448 n_I3451 VSS nfet_05v0 L=0.6U W=0.365U AS=0.0438P
+ AD=0.282625P PS=0.605U PD=1.87U
* device instance _1975 m90 *1 598.075,780.27 nfet_05v0
XM_1975 n_102 n_I3449 VSS VSS nfet_05v0 L=0.6U W=0.82U AS=0.282625P AD=0.3608P
+ PS=1.87U PD=2.52U
* device instance _1976 m90 *1 604.805,780.04 nfet_05v0
XM_1976 VSS n_I2166 n_I3447 VSS nfet_05v0 L=0.6U W=0.36U AS=0.333P AD=0.0936P
+ PS=2.57U PD=0.88U
* device instance _1977 m90 *1 603.685,780.04 nfet_05v0
XM_1977 n_I3450 n_I3447 VSS VSS nfet_05v0 L=0.6U W=0.36U AS=0.0936P AD=0.0432P
+ PS=0.88U PD=0.6U
* device instance _1978 m90 *1 602.845,780.04 nfet_05v0
XM_1978 n_I3448 n_I3447 n_I3450 VSS nfet_05v0 L=0.6U W=0.36U AS=0.0432P
+ AD=0.369P PS=0.6U PD=2.77U
* device instance _1979 r180 *1 597.255,784.07 pfet_05v0
XM_1979 n_I3460 n_I3455 n_I3456 VDD_DEC pfet_05v0 L=0.5U W=0.36U AS=0.3456P
+ AD=0.0612P PS=2.64U PD=0.7U
* device instance _1980 r180 *1 596.415,784.07 pfet_05v0
XM_1980 n_I3460 n_I3455 VDD_DEC VDD_DEC pfet_05v0 L=0.5U W=0.36U AS=0.379P
+ AD=0.0612P PS=2.37U PD=0.7U
* device instance _1981 r180 *1 594.765,784.39 pfet_05v0
XM_1981 n_104 n_I3456 VDD_DEC VDD_DEC pfet_05v0 L=0.5U W=1.22U AS=0.379P
+ AD=0.5368P PS=2.37U PD=3.32U
* device instance _1982 r180 *1 601.495,783.96 pfet_05v0
XM_1982 VDD_DEC n_I2133 n_I3454 VDD_DEC pfet_05v0 L=0.5U W=0.36U AS=0.3852P
+ AD=0.1116P PS=2.86U PD=0.98U
* device instance _1983 r180 *1 600.375,783.96 pfet_05v0
XM_1983 n_I3459 n_I3454 VDD_DEC VDD_DEC pfet_05v0 L=0.5U W=0.36U AS=0.1116P
+ AD=0.0612P PS=0.98U PD=0.7U
* device instance _1984 r180 *1 599.535,783.96 pfet_05v0
XM_1984 n_I3459 n_I3454 n_I3455 VDD_DEC pfet_05v0 L=0.5U W=0.36U AS=0.3852P
+ AD=0.0612P PS=2.86U PD=0.7U
* device instance _1985 r180 *1 597.205,786.838 nfet_05v0
XM_1985 n_I3458 n_I3455 n_I3456 VSS nfet_05v0 L=0.6U W=0.365U AS=0.3705P
+ AD=0.0438P PS=2.77U PD=0.605U
* device instance _1986 r180 *1 596.365,786.838 nfet_05v0
XM_1986 VSS n_I3455 n_I3458 VSS nfet_05v0 L=0.6U W=0.365U AS=0.0438P
+ AD=0.282625P PS=0.605U PD=1.87U
* device instance _1987 r180 *1 594.715,786.61 nfet_05v0
XM_1987 n_104 n_I3456 VSS VSS nfet_05v0 L=0.6U W=0.82U AS=0.282625P AD=0.3608P
+ PS=1.87U PD=2.52U
* device instance _1988 r180 *1 601.445,786.84 nfet_05v0
XM_1988 VSS n_I2133 n_I3454 VSS nfet_05v0 L=0.6U W=0.36U AS=0.333P AD=0.0936P
+ PS=2.57U PD=0.88U
* device instance _1989 r180 *1 600.325,786.84 nfet_05v0
XM_1989 n_I3457 n_I3454 VSS VSS nfet_05v0 L=0.6U W=0.36U AS=0.0936P AD=0.0432P
+ PS=0.88U PD=0.6U
* device instance _1990 r180 *1 599.485,786.84 nfet_05v0
XM_1990 n_I3455 n_I3454 n_I3457 VSS nfet_05v0 L=0.6U W=0.36U AS=0.0432P
+ AD=0.369P PS=0.6U PD=2.77U
* device instance _1991 m90 *1 597.255,790.65 pfet_05v0
XM_1991 n_I3467 n_I3462 n_I3463 VDD_DEC pfet_05v0 L=0.5U W=0.36U AS=0.3456P
+ AD=0.0612P PS=2.64U PD=0.7U
* device instance _1992 m90 *1 596.415,790.65 pfet_05v0
XM_1992 n_I3467 n_I3462 VDD_DEC VDD_DEC pfet_05v0 L=0.5U W=0.36U AS=0.379P
+ AD=0.0612P PS=2.37U PD=0.7U
* device instance _1993 m90 *1 594.765,790.33 pfet_05v0
XM_1993 n_106 n_I3463 VDD_DEC VDD_DEC pfet_05v0 L=0.5U W=1.22U AS=0.379P
+ AD=0.5368P PS=2.37U PD=3.32U
* device instance _1994 m90 *1 601.495,790.76 pfet_05v0
XM_1994 VDD_DEC n_I2367 n_I3461 VDD_DEC pfet_05v0 L=0.5U W=0.36U AS=0.3852P
+ AD=0.1116P PS=2.86U PD=0.98U
* device instance _1995 m90 *1 600.375,790.76 pfet_05v0
XM_1995 n_I3466 n_I3461 VDD_DEC VDD_DEC pfet_05v0 L=0.5U W=0.36U AS=0.1116P
+ AD=0.0612P PS=0.98U PD=0.7U
* device instance _1996 m90 *1 599.535,790.76 pfet_05v0
XM_1996 n_I3466 n_I3461 n_I3462 VDD_DEC pfet_05v0 L=0.5U W=0.36U AS=0.3852P
+ AD=0.0612P PS=2.86U PD=0.7U
* device instance _1997 m90 *1 597.205,787.882 nfet_05v0
XM_1997 n_I3465 n_I3462 n_I3463 VSS nfet_05v0 L=0.6U W=0.365U AS=0.3705P
+ AD=0.0438P PS=2.77U PD=0.605U
* device instance _1998 m90 *1 596.365,787.882 nfet_05v0
XM_1998 VSS n_I3462 n_I3465 VSS nfet_05v0 L=0.6U W=0.365U AS=0.0438P
+ AD=0.282625P PS=0.605U PD=1.87U
* device instance _1999 m90 *1 594.715,788.11 nfet_05v0
XM_1999 n_106 n_I3463 VSS VSS nfet_05v0 L=0.6U W=0.82U AS=0.282625P AD=0.3608P
+ PS=1.87U PD=2.52U
* device instance _2000 m90 *1 601.445,787.88 nfet_05v0
XM_2000 VSS n_I2367 n_I3461 VSS nfet_05v0 L=0.6U W=0.36U AS=0.333P AD=0.0936P
+ PS=2.57U PD=0.88U
* device instance _2001 m90 *1 600.325,787.88 nfet_05v0
XM_2001 n_I3464 n_I3461 VSS VSS nfet_05v0 L=0.6U W=0.36U AS=0.0936P AD=0.0432P
+ PS=0.88U PD=0.6U
* device instance _2002 m90 *1 599.485,787.88 nfet_05v0
XM_2002 n_I3462 n_I3461 n_I3464 VSS nfet_05v0 L=0.6U W=0.36U AS=0.0432P
+ AD=0.369P PS=0.6U PD=2.77U
* device instance _2003 r180 *1 609.015,776.23 pfet_05v0
XM_2003 n_I3474 n_I3469 n_I3470 VDD_DEC pfet_05v0 L=0.5U W=0.36U AS=0.3456P
+ AD=0.0612P PS=2.64U PD=0.7U
* device instance _2004 r180 *1 608.175,776.23 pfet_05v0
XM_2004 n_I3474 n_I3469 VDD_DEC VDD_DEC pfet_05v0 L=0.5U W=0.36U AS=0.379P
+ AD=0.0612P PS=2.37U PD=0.7U
* device instance _2005 r180 *1 606.525,776.55 pfet_05v0
XM_2005 n_108 n_I3470 VDD_DEC VDD_DEC pfet_05v0 L=0.5U W=1.22U AS=0.379P
+ AD=0.5368P PS=2.37U PD=3.32U
* device instance _2006 r180 *1 613.255,776.12 pfet_05v0
XM_2006 VDD_DEC n_I2071 n_I3468 VDD_DEC pfet_05v0 L=0.5U W=0.36U AS=0.3852P
+ AD=0.1116P PS=2.86U PD=0.98U
* device instance _2007 r180 *1 612.135,776.12 pfet_05v0
XM_2007 n_I3473 n_I3468 VDD_DEC VDD_DEC pfet_05v0 L=0.5U W=0.36U AS=0.1116P
+ AD=0.0612P PS=0.98U PD=0.7U
* device instance _2008 r180 *1 611.295,776.12 pfet_05v0
XM_2008 n_I3473 n_I3468 n_I3469 VDD_DEC pfet_05v0 L=0.5U W=0.36U AS=0.3852P
+ AD=0.0612P PS=2.86U PD=0.7U
* device instance _2009 r180 *1 608.965,778.998 nfet_05v0
XM_2009 n_I3472 n_I3469 n_I3470 VSS nfet_05v0 L=0.6U W=0.365U AS=0.3705P
+ AD=0.0438P PS=2.77U PD=0.605U
* device instance _2010 r180 *1 608.125,778.998 nfet_05v0
XM_2010 VSS n_I3469 n_I3472 VSS nfet_05v0 L=0.6U W=0.365U AS=0.0438P
+ AD=0.282625P PS=0.605U PD=1.87U
* device instance _2011 r180 *1 606.475,778.77 nfet_05v0
XM_2011 n_108 n_I3470 VSS VSS nfet_05v0 L=0.6U W=0.82U AS=0.282625P AD=0.3608P
+ PS=1.87U PD=2.52U
* device instance _2012 r180 *1 613.205,779 nfet_05v0
XM_2012 VSS n_I2071 n_I3468 VSS nfet_05v0 L=0.6U W=0.36U AS=0.333P AD=0.0936P
+ PS=2.57U PD=0.88U
* device instance _2013 r180 *1 612.085,779 nfet_05v0
XM_2013 n_I3471 n_I3468 VSS VSS nfet_05v0 L=0.6U W=0.36U AS=0.0936P AD=0.0432P
+ PS=0.88U PD=0.6U
* device instance _2014 r180 *1 611.245,779 nfet_05v0
XM_2014 n_I3469 n_I3468 n_I3471 VSS nfet_05v0 L=0.6U W=0.36U AS=0.0432P
+ AD=0.369P PS=0.6U PD=2.77U
* device instance _2015 m90 *1 614.615,774.97 pfet_05v0
XM_2015 n_I3481 n_I3476 n_I3477 VDD_DEC pfet_05v0 L=0.5U W=0.36U AS=0.3456P
+ AD=0.0612P PS=2.64U PD=0.7U
* device instance _2016 m90 *1 613.775,774.97 pfet_05v0
XM_2016 n_I3481 n_I3476 VDD_DEC VDD_DEC pfet_05v0 L=0.5U W=0.36U AS=0.379P
+ AD=0.0612P PS=2.37U PD=0.7U
* device instance _2017 m90 *1 612.125,774.65 pfet_05v0
XM_2017 n_110 n_I3477 VDD_DEC VDD_DEC pfet_05v0 L=0.5U W=1.22U AS=0.379P
+ AD=0.5368P PS=2.37U PD=3.32U
* device instance _2018 m90 *1 618.855,775.08 pfet_05v0
XM_2018 VDD_DEC n_I2070 n_I3475 VDD_DEC pfet_05v0 L=0.5U W=0.36U AS=0.3852P
+ AD=0.1116P PS=2.86U PD=0.98U
* device instance _2019 m90 *1 617.735,775.08 pfet_05v0
XM_2019 n_I3480 n_I3475 VDD_DEC VDD_DEC pfet_05v0 L=0.5U W=0.36U AS=0.1116P
+ AD=0.0612P PS=0.98U PD=0.7U
* device instance _2020 m90 *1 616.895,775.08 pfet_05v0
XM_2020 n_I3480 n_I3475 n_I3476 VDD_DEC pfet_05v0 L=0.5U W=0.36U AS=0.3852P
+ AD=0.0612P PS=2.86U PD=0.7U
* device instance _2021 m90 *1 614.565,772.202 nfet_05v0
XM_2021 n_I3479 n_I3476 n_I3477 VSS nfet_05v0 L=0.6U W=0.365U AS=0.3705P
+ AD=0.0438P PS=2.77U PD=0.605U
* device instance _2022 m90 *1 613.725,772.202 nfet_05v0
XM_2022 VSS n_I3476 n_I3479 VSS nfet_05v0 L=0.6U W=0.365U AS=0.0438P
+ AD=0.282625P PS=0.605U PD=1.87U
* device instance _2023 m90 *1 612.075,772.43 nfet_05v0
XM_2023 n_110 n_I3477 VSS VSS nfet_05v0 L=0.6U W=0.82U AS=0.282625P AD=0.3608P
+ PS=1.87U PD=2.52U
* device instance _2024 m90 *1 618.805,772.2 nfet_05v0
XM_2024 VSS n_I2070 n_I3475 VSS nfet_05v0 L=0.6U W=0.36U AS=0.333P AD=0.0936P
+ PS=2.57U PD=0.88U
* device instance _2025 m90 *1 617.685,772.2 nfet_05v0
XM_2025 n_I3478 n_I3475 VSS VSS nfet_05v0 L=0.6U W=0.36U AS=0.0936P AD=0.0432P
+ PS=0.88U PD=0.6U
* device instance _2026 m90 *1 616.845,772.2 nfet_05v0
XM_2026 n_I3476 n_I3475 n_I3478 VSS nfet_05v0 L=0.6U W=0.36U AS=0.0432P
+ AD=0.369P PS=0.6U PD=2.77U
* device instance _2027 m90 *1 609.575,782.81 pfet_05v0
XM_2027 n_I3488 n_I3483 n_I3484 VDD_DEC pfet_05v0 L=0.5U W=0.36U AS=0.3456P
+ AD=0.0612P PS=2.64U PD=0.7U
* device instance _2028 m90 *1 608.735,782.81 pfet_05v0
XM_2028 n_I3488 n_I3483 VDD_DEC VDD_DEC pfet_05v0 L=0.5U W=0.36U AS=0.379P
+ AD=0.0612P PS=2.37U PD=0.7U
* device instance _2029 m90 *1 607.085,782.49 pfet_05v0
XM_2029 n_112 n_I3484 VDD_DEC VDD_DEC pfet_05v0 L=0.5U W=1.22U AS=0.379P
+ AD=0.5368P PS=2.37U PD=3.32U
* device instance _2030 m90 *1 613.815,782.92 pfet_05v0
XM_2030 VDD_DEC n_I2102 n_I3482 VDD_DEC pfet_05v0 L=0.5U W=0.36U AS=0.3852P
+ AD=0.1116P PS=2.86U PD=0.98U
* device instance _2031 m90 *1 612.695,782.92 pfet_05v0
XM_2031 n_I3487 n_I3482 VDD_DEC VDD_DEC pfet_05v0 L=0.5U W=0.36U AS=0.1116P
+ AD=0.0612P PS=0.98U PD=0.7U
* device instance _2032 m90 *1 611.855,782.92 pfet_05v0
XM_2032 n_I3487 n_I3482 n_I3483 VDD_DEC pfet_05v0 L=0.5U W=0.36U AS=0.3852P
+ AD=0.0612P PS=2.86U PD=0.7U
* device instance _2033 m90 *1 609.525,780.042 nfet_05v0
XM_2033 n_I3486 n_I3483 n_I3484 VSS nfet_05v0 L=0.6U W=0.365U AS=0.3705P
+ AD=0.0438P PS=2.77U PD=0.605U
* device instance _2034 m90 *1 608.685,780.042 nfet_05v0
XM_2034 VSS n_I3483 n_I3486 VSS nfet_05v0 L=0.6U W=0.365U AS=0.0438P
+ AD=0.282625P PS=0.605U PD=1.87U
* device instance _2035 m90 *1 607.035,780.27 nfet_05v0
XM_2035 n_112 n_I3484 VSS VSS nfet_05v0 L=0.6U W=0.82U AS=0.282625P AD=0.3608P
+ PS=1.87U PD=2.52U
* device instance _2036 m90 *1 613.765,780.04 nfet_05v0
XM_2036 VSS n_I2102 n_I3482 VSS nfet_05v0 L=0.6U W=0.36U AS=0.333P AD=0.0936P
+ PS=2.57U PD=0.88U
* device instance _2037 m90 *1 612.645,780.04 nfet_05v0
XM_2037 n_I3485 n_I3482 VSS VSS nfet_05v0 L=0.6U W=0.36U AS=0.0936P AD=0.0432P
+ PS=0.88U PD=0.6U
* device instance _2038 m90 *1 611.805,780.04 nfet_05v0
XM_2038 n_I3483 n_I3482 n_I3485 VSS nfet_05v0 L=0.6U W=0.36U AS=0.0432P
+ AD=0.369P PS=0.6U PD=2.77U
* device instance _2039 r180 *1 609.015,784.07 pfet_05v0
XM_2039 n_I3495 n_I3490 n_I3491 VDD_DEC pfet_05v0 L=0.5U W=0.36U AS=0.3456P
+ AD=0.0612P PS=2.64U PD=0.7U
* device instance _2040 r180 *1 608.175,784.07 pfet_05v0
XM_2040 n_I3495 n_I3490 VDD_DEC VDD_DEC pfet_05v0 L=0.5U W=0.36U AS=0.379P
+ AD=0.0612P PS=2.37U PD=0.7U
* device instance _2041 r180 *1 606.525,784.39 pfet_05v0
XM_2041 n_83 n_I3491 VDD_DEC VDD_DEC pfet_05v0 L=0.5U W=1.22U AS=0.379P
+ AD=0.5368P PS=2.37U PD=3.32U
* device instance _2042 r180 *1 613.255,783.96 pfet_05v0
XM_2042 VDD_DEC n_I2173 n_I3489 VDD_DEC pfet_05v0 L=0.5U W=0.36U AS=0.3852P
+ AD=0.1116P PS=2.86U PD=0.98U
* device instance _2043 r180 *1 612.135,783.96 pfet_05v0
XM_2043 n_I3494 n_I3489 VDD_DEC VDD_DEC pfet_05v0 L=0.5U W=0.36U AS=0.1116P
+ AD=0.0612P PS=0.98U PD=0.7U
* device instance _2044 r180 *1 611.295,783.96 pfet_05v0
XM_2044 n_I3494 n_I3489 n_I3490 VDD_DEC pfet_05v0 L=0.5U W=0.36U AS=0.3852P
+ AD=0.0612P PS=2.86U PD=0.7U
* device instance _2045 r180 *1 608.965,786.838 nfet_05v0
XM_2045 n_I3493 n_I3490 n_I3491 VSS nfet_05v0 L=0.6U W=0.365U AS=0.3705P
+ AD=0.0438P PS=2.77U PD=0.605U
* device instance _2046 r180 *1 608.125,786.838 nfet_05v0
XM_2046 VSS n_I3490 n_I3493 VSS nfet_05v0 L=0.6U W=0.365U AS=0.0438P
+ AD=0.282625P PS=0.605U PD=1.87U
* device instance _2047 r180 *1 606.475,786.61 nfet_05v0
XM_2047 n_83 n_I3491 VSS VSS nfet_05v0 L=0.6U W=0.82U AS=0.282625P AD=0.3608P
+ PS=1.87U PD=2.52U
* device instance _2048 r180 *1 613.205,786.84 nfet_05v0
XM_2048 VSS n_I2173 n_I3489 VSS nfet_05v0 L=0.6U W=0.36U AS=0.333P AD=0.0936P
+ PS=2.57U PD=0.88U
* device instance _2049 r180 *1 612.085,786.84 nfet_05v0
XM_2049 n_I3492 n_I3489 VSS VSS nfet_05v0 L=0.6U W=0.36U AS=0.0936P AD=0.0432P
+ PS=0.88U PD=0.6U
* device instance _2050 r180 *1 611.245,786.84 nfet_05v0
XM_2050 n_I3490 n_I3489 n_I3492 VSS nfet_05v0 L=0.6U W=0.36U AS=0.0432P
+ AD=0.369P PS=0.6U PD=2.77U
* device instance _2051 m90 *1 606.215,790.65 pfet_05v0
XM_2051 n_I3502 n_I3497 n_I3498 VDD_DEC pfet_05v0 L=0.5U W=0.36U AS=0.3456P
+ AD=0.0612P PS=2.64U PD=0.7U
* device instance _2052 m90 *1 605.375,790.65 pfet_05v0
XM_2052 n_I3502 n_I3497 VDD_DEC VDD_DEC pfet_05v0 L=0.5U W=0.36U AS=0.379P
+ AD=0.0612P PS=2.37U PD=0.7U
* device instance _2053 m90 *1 603.725,790.33 pfet_05v0
XM_2053 n_85 n_I3498 VDD_DEC VDD_DEC pfet_05v0 L=0.5U W=1.22U AS=0.379P
+ AD=0.5368P PS=2.37U PD=3.32U
* device instance _2054 m90 *1 610.455,790.76 pfet_05v0
XM_2054 VDD_DEC n_I2254 n_I3496 VDD_DEC pfet_05v0 L=0.5U W=0.36U AS=0.3852P
+ AD=0.1116P PS=2.86U PD=0.98U
* device instance _2055 m90 *1 609.335,790.76 pfet_05v0
XM_2055 n_I3501 n_I3496 VDD_DEC VDD_DEC pfet_05v0 L=0.5U W=0.36U AS=0.1116P
+ AD=0.0612P PS=0.98U PD=0.7U
* device instance _2056 m90 *1 608.495,790.76 pfet_05v0
XM_2056 n_I3501 n_I3496 n_I3497 VDD_DEC pfet_05v0 L=0.5U W=0.36U AS=0.3852P
+ AD=0.0612P PS=2.86U PD=0.7U
* device instance _2057 m90 *1 606.165,787.882 nfet_05v0
XM_2057 n_I3500 n_I3497 n_I3498 VSS nfet_05v0 L=0.6U W=0.365U AS=0.3705P
+ AD=0.0438P PS=2.77U PD=0.605U
* device instance _2058 m90 *1 605.325,787.882 nfet_05v0
XM_2058 VSS n_I3497 n_I3500 VSS nfet_05v0 L=0.6U W=0.365U AS=0.0438P
+ AD=0.282625P PS=0.605U PD=1.87U
* device instance _2059 m90 *1 603.675,788.11 nfet_05v0
XM_2059 n_85 n_I3498 VSS VSS nfet_05v0 L=0.6U W=0.82U AS=0.282625P AD=0.3608P
+ PS=1.87U PD=2.52U
* device instance _2060 m90 *1 610.405,787.88 nfet_05v0
XM_2060 VSS n_I2254 n_I3496 VSS nfet_05v0 L=0.6U W=0.36U AS=0.333P AD=0.0936P
+ PS=2.57U PD=0.88U
* device instance _2061 m90 *1 609.285,787.88 nfet_05v0
XM_2061 n_I3499 n_I3496 VSS VSS nfet_05v0 L=0.6U W=0.36U AS=0.0936P AD=0.0432P
+ PS=0.88U PD=0.6U
* device instance _2062 m90 *1 608.445,787.88 nfet_05v0
XM_2062 n_I3497 n_I3496 n_I3499 VSS nfet_05v0 L=0.6U W=0.36U AS=0.0432P
+ AD=0.369P PS=0.6U PD=2.77U
* device instance _2063 r180 *1 617.975,776.23 pfet_05v0
XM_2063 n_I3509 n_I3504 n_I3505 VDD_DEC pfet_05v0 L=0.5U W=0.36U AS=0.3456P
+ AD=0.0612P PS=2.64U PD=0.7U
* device instance _2064 r180 *1 617.135,776.23 pfet_05v0
XM_2064 n_I3509 n_I3504 VDD_DEC VDD_DEC pfet_05v0 L=0.5U W=0.36U AS=0.379P
+ AD=0.0612P PS=2.37U PD=0.7U
* device instance _2065 r180 *1 615.485,776.55 pfet_05v0
XM_2065 n_87 n_I3505 VDD_DEC VDD_DEC pfet_05v0 L=0.5U W=1.22U AS=0.379P
+ AD=0.5368P PS=2.37U PD=3.32U
* device instance _2066 r180 *1 622.215,776.12 pfet_05v0
XM_2066 VDD_DEC n_I2212 n_I3503 VDD_DEC pfet_05v0 L=0.5U W=0.36U AS=0.3852P
+ AD=0.1116P PS=2.86U PD=0.98U
* device instance _2067 r180 *1 621.095,776.12 pfet_05v0
XM_2067 n_I3508 n_I3503 VDD_DEC VDD_DEC pfet_05v0 L=0.5U W=0.36U AS=0.1116P
+ AD=0.0612P PS=0.98U PD=0.7U
* device instance _2068 r180 *1 620.255,776.12 pfet_05v0
XM_2068 n_I3508 n_I3503 n_I3504 VDD_DEC pfet_05v0 L=0.5U W=0.36U AS=0.3852P
+ AD=0.0612P PS=2.86U PD=0.7U
* device instance _2069 r180 *1 617.925,778.998 nfet_05v0
XM_2069 n_I3507 n_I3504 n_I3505 VSS nfet_05v0 L=0.6U W=0.365U AS=0.3705P
+ AD=0.0438P PS=2.77U PD=0.605U
* device instance _2070 r180 *1 617.085,778.998 nfet_05v0
XM_2070 VSS n_I3504 n_I3507 VSS nfet_05v0 L=0.6U W=0.365U AS=0.0438P
+ AD=0.282625P PS=0.605U PD=1.87U
* device instance _2071 r180 *1 615.435,778.77 nfet_05v0
XM_2071 n_87 n_I3505 VSS VSS nfet_05v0 L=0.6U W=0.82U AS=0.282625P AD=0.3608P
+ PS=1.87U PD=2.52U
* device instance _2072 r180 *1 622.165,779 nfet_05v0
XM_2072 VSS n_I2212 n_I3503 VSS nfet_05v0 L=0.6U W=0.36U AS=0.333P AD=0.0936P
+ PS=2.57U PD=0.88U
* device instance _2073 r180 *1 621.045,779 nfet_05v0
XM_2073 n_I3506 n_I3503 VSS VSS nfet_05v0 L=0.6U W=0.36U AS=0.0936P AD=0.0432P
+ PS=0.88U PD=0.6U
* device instance _2074 r180 *1 620.205,779 nfet_05v0
XM_2074 n_I3504 n_I3503 n_I3506 VSS nfet_05v0 L=0.6U W=0.36U AS=0.0432P
+ AD=0.369P PS=0.6U PD=2.77U
* device instance _2075 m90 *1 624.695,774.97 pfet_05v0
XM_2075 n_I3516 n_I3511 n_I3512 VDD_DEC pfet_05v0 L=0.5U W=0.36U AS=0.3456P
+ AD=0.0612P PS=2.64U PD=0.7U
* device instance _2076 m90 *1 623.855,774.97 pfet_05v0
XM_2076 n_I3516 n_I3511 VDD_DEC VDD_DEC pfet_05v0 L=0.5U W=0.36U AS=0.379P
+ AD=0.0612P PS=2.37U PD=0.7U
* device instance _2077 m90 *1 622.205,774.65 pfet_05v0
XM_2077 n_89 n_I3512 VDD_DEC VDD_DEC pfet_05v0 L=0.5U W=1.22U AS=0.379P
+ AD=0.5368P PS=2.37U PD=3.32U
* device instance _2078 m90 *1 628.935,775.08 pfet_05v0
XM_2078 VDD_DEC n_I2257 n_I3510 VDD_DEC pfet_05v0 L=0.5U W=0.36U AS=0.3852P
+ AD=0.1116P PS=2.86U PD=0.98U
* device instance _2079 m90 *1 627.815,775.08 pfet_05v0
XM_2079 n_I3515 n_I3510 VDD_DEC VDD_DEC pfet_05v0 L=0.5U W=0.36U AS=0.1116P
+ AD=0.0612P PS=0.98U PD=0.7U
* device instance _2080 m90 *1 626.975,775.08 pfet_05v0
XM_2080 n_I3515 n_I3510 n_I3511 VDD_DEC pfet_05v0 L=0.5U W=0.36U AS=0.3852P
+ AD=0.0612P PS=2.86U PD=0.7U
* device instance _2081 m90 *1 624.645,772.202 nfet_05v0
XM_2081 n_I3514 n_I3511 n_I3512 VSS nfet_05v0 L=0.6U W=0.365U AS=0.3705P
+ AD=0.0438P PS=2.77U PD=0.605U
* device instance _2082 m90 *1 623.805,772.202 nfet_05v0
XM_2082 VSS n_I3511 n_I3514 VSS nfet_05v0 L=0.6U W=0.365U AS=0.0438P
+ AD=0.282625P PS=0.605U PD=1.87U
* device instance _2083 m90 *1 622.155,772.43 nfet_05v0
XM_2083 n_89 n_I3512 VSS VSS nfet_05v0 L=0.6U W=0.82U AS=0.282625P AD=0.3608P
+ PS=1.87U PD=2.52U
* device instance _2084 m90 *1 628.885,772.2 nfet_05v0
XM_2084 VSS n_I2257 n_I3510 VSS nfet_05v0 L=0.6U W=0.36U AS=0.333P AD=0.0936P
+ PS=2.57U PD=0.88U
* device instance _2085 m90 *1 627.765,772.2 nfet_05v0
XM_2085 n_I3513 n_I3510 VSS VSS nfet_05v0 L=0.6U W=0.36U AS=0.0936P AD=0.0432P
+ PS=0.88U PD=0.6U
* device instance _2086 m90 *1 626.925,772.2 nfet_05v0
XM_2086 n_I3511 n_I3510 n_I3513 VSS nfet_05v0 L=0.6U W=0.36U AS=0.0432P
+ AD=0.369P PS=0.6U PD=2.77U
* device instance _2087 m90 *1 618.535,782.81 pfet_05v0
XM_2087 n_I3523 n_I3518 n_I3519 VDD_DEC pfet_05v0 L=0.5U W=0.36U AS=0.3456P
+ AD=0.0612P PS=2.64U PD=0.7U
* device instance _2088 m90 *1 617.695,782.81 pfet_05v0
XM_2088 n_I3523 n_I3518 VDD_DEC VDD_DEC pfet_05v0 L=0.5U W=0.36U AS=0.379P
+ AD=0.0612P PS=2.37U PD=0.7U
* device instance _2089 m90 *1 616.045,782.49 pfet_05v0
XM_2089 n_91 n_I3519 VDD_DEC VDD_DEC pfet_05v0 L=0.5U W=1.22U AS=0.379P
+ AD=0.5368P PS=2.37U PD=3.32U
* device instance _2090 m90 *1 622.775,782.92 pfet_05v0
XM_2090 VDD_DEC n_I2072 n_I3517 VDD_DEC pfet_05v0 L=0.5U W=0.36U AS=0.3852P
+ AD=0.1116P PS=2.86U PD=0.98U
* device instance _2091 m90 *1 621.655,782.92 pfet_05v0
XM_2091 n_I3522 n_I3517 VDD_DEC VDD_DEC pfet_05v0 L=0.5U W=0.36U AS=0.1116P
+ AD=0.0612P PS=0.98U PD=0.7U
* device instance _2092 m90 *1 620.815,782.92 pfet_05v0
XM_2092 n_I3522 n_I3517 n_I3518 VDD_DEC pfet_05v0 L=0.5U W=0.36U AS=0.3852P
+ AD=0.0612P PS=2.86U PD=0.7U
* device instance _2093 m90 *1 618.485,780.042 nfet_05v0
XM_2093 n_I3521 n_I3518 n_I3519 VSS nfet_05v0 L=0.6U W=0.365U AS=0.3705P
+ AD=0.0438P PS=2.77U PD=0.605U
* device instance _2094 m90 *1 617.645,780.042 nfet_05v0
XM_2094 VSS n_I3518 n_I3521 VSS nfet_05v0 L=0.6U W=0.365U AS=0.0438P
+ AD=0.282625P PS=0.605U PD=1.87U
* device instance _2095 m90 *1 615.995,780.27 nfet_05v0
XM_2095 n_91 n_I3519 VSS VSS nfet_05v0 L=0.6U W=0.82U AS=0.282625P AD=0.3608P
+ PS=1.87U PD=2.52U
* device instance _2096 m90 *1 622.725,780.04 nfet_05v0
XM_2096 VSS n_I2072 n_I3517 VSS nfet_05v0 L=0.6U W=0.36U AS=0.333P AD=0.0936P
+ PS=2.57U PD=0.88U
* device instance _2097 m90 *1 621.605,780.04 nfet_05v0
XM_2097 n_I3520 n_I3517 VSS VSS nfet_05v0 L=0.6U W=0.36U AS=0.0936P AD=0.0432P
+ PS=0.88U PD=0.6U
* device instance _2098 m90 *1 620.765,780.04 nfet_05v0
XM_2098 n_I3518 n_I3517 n_I3520 VSS nfet_05v0 L=0.6U W=0.36U AS=0.0432P
+ AD=0.369P PS=0.6U PD=2.77U
* device instance _2099 r180 *1 609.015,791.91 pfet_05v0
XM_2099 n_I3530 n_I3525 n_I3526 VDD_DEC pfet_05v0 L=0.5U W=0.36U AS=0.3456P
+ AD=0.0612P PS=2.64U PD=0.7U
* device instance _2100 r180 *1 608.175,791.91 pfet_05v0
XM_2100 n_I3530 n_I3525 VDD_DEC VDD_DEC pfet_05v0 L=0.5U W=0.36U AS=0.379P
+ AD=0.0612P PS=2.37U PD=0.7U
* device instance _2101 r180 *1 606.525,792.23 pfet_05v0
XM_2101 n_93 n_I3526 VDD_DEC VDD_DEC pfet_05v0 L=0.5U W=1.22U AS=0.379P
+ AD=0.5368P PS=2.37U PD=3.32U
* device instance _2102 r180 *1 613.255,791.8 pfet_05v0
XM_2102 VDD_DEC n_I2241 n_I3524 VDD_DEC pfet_05v0 L=0.5U W=0.36U AS=0.3852P
+ AD=0.1116P PS=2.86U PD=0.98U
* device instance _2103 r180 *1 612.135,791.8 pfet_05v0
XM_2103 n_I3529 n_I3524 VDD_DEC VDD_DEC pfet_05v0 L=0.5U W=0.36U AS=0.1116P
+ AD=0.0612P PS=0.98U PD=0.7U
* device instance _2104 r180 *1 611.295,791.8 pfet_05v0
XM_2104 n_I3529 n_I3524 n_I3525 VDD_DEC pfet_05v0 L=0.5U W=0.36U AS=0.3852P
+ AD=0.0612P PS=2.86U PD=0.7U
* device instance _2105 r180 *1 608.965,794.678 nfet_05v0
XM_2105 n_I3528 n_I3525 n_I3526 VSS nfet_05v0 L=0.6U W=0.365U AS=0.3705P
+ AD=0.0438P PS=2.77U PD=0.605U
* device instance _2106 r180 *1 608.125,794.678 nfet_05v0
XM_2106 VSS n_I3525 n_I3528 VSS nfet_05v0 L=0.6U W=0.365U AS=0.0438P
+ AD=0.282625P PS=0.605U PD=1.87U
* device instance _2107 r180 *1 606.475,794.45 nfet_05v0
XM_2107 n_93 n_I3526 VSS VSS nfet_05v0 L=0.6U W=0.82U AS=0.282625P AD=0.3608P
+ PS=1.87U PD=2.52U
* device instance _2108 r180 *1 613.205,794.68 nfet_05v0
XM_2108 VSS n_I2241 n_I3524 VSS nfet_05v0 L=0.6U W=0.36U AS=0.333P AD=0.0936P
+ PS=2.57U PD=0.88U
* device instance _2109 r180 *1 612.085,794.68 nfet_05v0
XM_2109 n_I3527 n_I3524 VSS VSS nfet_05v0 L=0.6U W=0.36U AS=0.0936P AD=0.0432P
+ PS=0.88U PD=0.6U
* device instance _2110 r180 *1 611.245,794.68 nfet_05v0
XM_2110 n_I3525 n_I3524 n_I3527 VSS nfet_05v0 L=0.6U W=0.36U AS=0.0432P
+ AD=0.369P PS=0.6U PD=2.77U
* device instance _2111 r180 *1 617.975,784.07 pfet_05v0
XM_2111 n_I3537 n_I3532 n_I3533 VDD_DEC pfet_05v0 L=0.5U W=0.36U AS=0.3456P
+ AD=0.0612P PS=2.64U PD=0.7U
* device instance _2112 r180 *1 617.135,784.07 pfet_05v0
XM_2112 n_I3537 n_I3532 VDD_DEC VDD_DEC pfet_05v0 L=0.5U W=0.36U AS=0.379P
+ AD=0.0612P PS=2.37U PD=0.7U
* device instance _2113 r180 *1 615.485,784.39 pfet_05v0
XM_2113 n_95 n_I3533 VDD_DEC VDD_DEC pfet_05v0 L=0.5U W=1.22U AS=0.379P
+ AD=0.5368P PS=2.37U PD=3.32U
* device instance _2114 r180 *1 622.215,783.96 pfet_05v0
XM_2114 VDD_DEC n_I2136 n_I3531 VDD_DEC pfet_05v0 L=0.5U W=0.36U AS=0.3852P
+ AD=0.1116P PS=2.86U PD=0.98U
* device instance _2115 r180 *1 621.095,783.96 pfet_05v0
XM_2115 n_I3536 n_I3531 VDD_DEC VDD_DEC pfet_05v0 L=0.5U W=0.36U AS=0.1116P
+ AD=0.0612P PS=0.98U PD=0.7U
* device instance _2116 r180 *1 620.255,783.96 pfet_05v0
XM_2116 n_I3536 n_I3531 n_I3532 VDD_DEC pfet_05v0 L=0.5U W=0.36U AS=0.3852P
+ AD=0.0612P PS=2.86U PD=0.7U
* device instance _2117 r180 *1 617.925,786.838 nfet_05v0
XM_2117 n_I3535 n_I3532 n_I3533 VSS nfet_05v0 L=0.6U W=0.365U AS=0.3705P
+ AD=0.0438P PS=2.77U PD=0.605U
* device instance _2118 r180 *1 617.085,786.838 nfet_05v0
XM_2118 VSS n_I3532 n_I3535 VSS nfet_05v0 L=0.6U W=0.365U AS=0.0438P
+ AD=0.282625P PS=0.605U PD=1.87U
* device instance _2119 r180 *1 615.435,786.61 nfet_05v0
XM_2119 n_95 n_I3533 VSS VSS nfet_05v0 L=0.6U W=0.82U AS=0.282625P AD=0.3608P
+ PS=1.87U PD=2.52U
* device instance _2120 r180 *1 622.165,786.84 nfet_05v0
XM_2120 VSS n_I2136 n_I3531 VSS nfet_05v0 L=0.6U W=0.36U AS=0.333P AD=0.0936P
+ PS=2.57U PD=0.88U
* device instance _2121 r180 *1 621.045,786.84 nfet_05v0
XM_2121 n_I3534 n_I3531 VSS VSS nfet_05v0 L=0.6U W=0.36U AS=0.0936P AD=0.0432P
+ PS=0.88U PD=0.6U
* device instance _2122 r180 *1 620.205,786.84 nfet_05v0
XM_2122 n_I3532 n_I3531 n_I3534 VSS nfet_05v0 L=0.6U W=0.36U AS=0.0432P
+ AD=0.369P PS=0.6U PD=2.77U
* device instance _2123 m90 *1 615.175,790.65 pfet_05v0
XM_2123 n_I3544 n_I3539 n_I3540 VDD_DEC pfet_05v0 L=0.5U W=0.36U AS=0.3456P
+ AD=0.0612P PS=2.64U PD=0.7U
* device instance _2124 m90 *1 614.335,790.65 pfet_05v0
XM_2124 n_I3544 n_I3539 VDD_DEC VDD_DEC pfet_05v0 L=0.5U W=0.36U AS=0.379P
+ AD=0.0612P PS=2.37U PD=0.7U
* device instance _2125 m90 *1 612.685,790.33 pfet_05v0
XM_2125 n_97 n_I3540 VDD_DEC VDD_DEC pfet_05v0 L=0.5U W=1.22U AS=0.379P
+ AD=0.5368P PS=2.37U PD=3.32U
* device instance _2126 m90 *1 619.415,790.76 pfet_05v0
XM_2126 VDD_DEC n_I2255 n_I3538 VDD_DEC pfet_05v0 L=0.5U W=0.36U AS=0.3852P
+ AD=0.1116P PS=2.86U PD=0.98U
* device instance _2127 m90 *1 618.295,790.76 pfet_05v0
XM_2127 n_I3543 n_I3538 VDD_DEC VDD_DEC pfet_05v0 L=0.5U W=0.36U AS=0.1116P
+ AD=0.0612P PS=0.98U PD=0.7U
* device instance _2128 m90 *1 617.455,790.76 pfet_05v0
XM_2128 n_I3543 n_I3538 n_I3539 VDD_DEC pfet_05v0 L=0.5U W=0.36U AS=0.3852P
+ AD=0.0612P PS=2.86U PD=0.7U
* device instance _2129 m90 *1 615.125,787.882 nfet_05v0
XM_2129 n_I3542 n_I3539 n_I3540 VSS nfet_05v0 L=0.6U W=0.365U AS=0.3705P
+ AD=0.0438P PS=2.77U PD=0.605U
* device instance _2130 m90 *1 614.285,787.882 nfet_05v0
XM_2130 VSS n_I3539 n_I3542 VSS nfet_05v0 L=0.6U W=0.365U AS=0.0438P
+ AD=0.282625P PS=0.605U PD=1.87U
* device instance _2131 m90 *1 612.635,788.11 nfet_05v0
XM_2131 n_97 n_I3540 VSS VSS nfet_05v0 L=0.6U W=0.82U AS=0.282625P AD=0.3608P
+ PS=1.87U PD=2.52U
* device instance _2132 m90 *1 619.365,787.88 nfet_05v0
XM_2132 VSS n_I2255 n_I3538 VSS nfet_05v0 L=0.6U W=0.36U AS=0.333P AD=0.0936P
+ PS=2.57U PD=0.88U
* device instance _2133 m90 *1 618.245,787.88 nfet_05v0
XM_2133 n_I3541 n_I3538 VSS VSS nfet_05v0 L=0.6U W=0.36U AS=0.0936P AD=0.0432P
+ PS=0.88U PD=0.6U
* device instance _2134 m90 *1 617.405,787.88 nfet_05v0
XM_2134 n_I3539 n_I3538 n_I3541 VSS nfet_05v0 L=0.6U W=0.36U AS=0.0432P
+ AD=0.369P PS=0.6U PD=2.77U
* device instance _2135 r180 *1 626.935,776.23 pfet_05v0
XM_2135 n_I3551 n_I3546 n_I3547 VDD_DEC pfet_05v0 L=0.5U W=0.36U AS=0.3456P
+ AD=0.0612P PS=2.64U PD=0.7U
* device instance _2136 r180 *1 626.095,776.23 pfet_05v0
XM_2136 n_I3551 n_I3546 VDD_DEC VDD_DEC pfet_05v0 L=0.5U W=0.36U AS=0.379P
+ AD=0.0612P PS=2.37U PD=0.7U
* device instance _2137 r180 *1 624.445,776.55 pfet_05v0
XM_2137 n_99 n_I3547 VDD_DEC VDD_DEC pfet_05v0 L=0.5U W=1.22U AS=0.379P
+ AD=0.5368P PS=2.37U PD=3.32U
* device instance _2138 r180 *1 631.175,776.12 pfet_05v0
XM_2138 VDD_DEC n_I2103 n_I3545 VDD_DEC pfet_05v0 L=0.5U W=0.36U AS=0.3852P
+ AD=0.1116P PS=2.86U PD=0.98U
* device instance _2139 r180 *1 630.055,776.12 pfet_05v0
XM_2139 n_I3550 n_I3545 VDD_DEC VDD_DEC pfet_05v0 L=0.5U W=0.36U AS=0.1116P
+ AD=0.0612P PS=0.98U PD=0.7U
* device instance _2140 r180 *1 629.215,776.12 pfet_05v0
XM_2140 n_I3550 n_I3545 n_I3546 VDD_DEC pfet_05v0 L=0.5U W=0.36U AS=0.3852P
+ AD=0.0612P PS=2.86U PD=0.7U
* device instance _2141 r180 *1 626.885,778.998 nfet_05v0
XM_2141 n_I3549 n_I3546 n_I3547 VSS nfet_05v0 L=0.6U W=0.365U AS=0.3705P
+ AD=0.0438P PS=2.77U PD=0.605U
* device instance _2142 r180 *1 626.045,778.998 nfet_05v0
XM_2142 VSS n_I3546 n_I3549 VSS nfet_05v0 L=0.6U W=0.365U AS=0.0438P
+ AD=0.282625P PS=0.605U PD=1.87U
* device instance _2143 r180 *1 624.395,778.77 nfet_05v0
XM_2143 n_99 n_I3547 VSS VSS nfet_05v0 L=0.6U W=0.82U AS=0.282625P AD=0.3608P
+ PS=1.87U PD=2.52U
* device instance _2144 r180 *1 631.125,779 nfet_05v0
XM_2144 VSS n_I2103 n_I3545 VSS nfet_05v0 L=0.6U W=0.36U AS=0.333P AD=0.0936P
+ PS=2.57U PD=0.88U
* device instance _2145 r180 *1 630.005,779 nfet_05v0
XM_2145 n_I3548 n_I3545 VSS VSS nfet_05v0 L=0.6U W=0.36U AS=0.0936P AD=0.0432P
+ PS=0.88U PD=0.6U
* device instance _2146 r180 *1 629.165,779 nfet_05v0
XM_2146 n_I3546 n_I3545 n_I3548 VSS nfet_05v0 L=0.6U W=0.36U AS=0.0432P
+ AD=0.369P PS=0.6U PD=2.77U
* device instance _2147 m90 *1 633.655,774.97 pfet_05v0
XM_2147 n_I3558 n_I3553 n_I3554 VDD_DEC pfet_05v0 L=0.5U W=0.36U AS=0.3456P
+ AD=0.0612P PS=2.64U PD=0.7U
* device instance _2148 m90 *1 632.815,774.97 pfet_05v0
XM_2148 n_I3558 n_I3553 VDD_DEC VDD_DEC pfet_05v0 L=0.5U W=0.36U AS=0.379P
+ AD=0.0612P PS=2.37U PD=0.7U
* device instance _2149 m90 *1 631.165,774.65 pfet_05v0
XM_2149 n_101 n_I3554 VDD_DEC VDD_DEC pfet_05v0 L=0.5U W=1.22U AS=0.379P
+ AD=0.5368P PS=2.37U PD=3.32U
* device instance _2150 m90 *1 637.895,775.08 pfet_05v0
XM_2150 VDD_DEC n_I2031 n_I3552 VDD_DEC pfet_05v0 L=0.5U W=0.36U AS=0.3852P
+ AD=0.1116P PS=2.86U PD=0.98U
* device instance _2151 m90 *1 636.775,775.08 pfet_05v0
XM_2151 n_I3557 n_I3552 VDD_DEC VDD_DEC pfet_05v0 L=0.5U W=0.36U AS=0.1116P
+ AD=0.0612P PS=0.98U PD=0.7U
* device instance _2152 m90 *1 635.935,775.08 pfet_05v0
XM_2152 n_I3557 n_I3552 n_I3553 VDD_DEC pfet_05v0 L=0.5U W=0.36U AS=0.3852P
+ AD=0.0612P PS=2.86U PD=0.7U
* device instance _2153 m90 *1 633.605,772.202 nfet_05v0
XM_2153 n_I3556 n_I3553 n_I3554 VSS nfet_05v0 L=0.6U W=0.365U AS=0.3705P
+ AD=0.0438P PS=2.77U PD=0.605U
* device instance _2154 m90 *1 632.765,772.202 nfet_05v0
XM_2154 VSS n_I3553 n_I3556 VSS nfet_05v0 L=0.6U W=0.365U AS=0.0438P
+ AD=0.282625P PS=0.605U PD=1.87U
* device instance _2155 m90 *1 631.115,772.43 nfet_05v0
XM_2155 n_101 n_I3554 VSS VSS nfet_05v0 L=0.6U W=0.82U AS=0.282625P AD=0.3608P
+ PS=1.87U PD=2.52U
* device instance _2156 m90 *1 637.845,772.2 nfet_05v0
XM_2156 VSS n_I2031 n_I3552 VSS nfet_05v0 L=0.6U W=0.36U AS=0.333P AD=0.0936P
+ PS=2.57U PD=0.88U
* device instance _2157 m90 *1 636.725,772.2 nfet_05v0
XM_2157 n_I3555 n_I3552 VSS VSS nfet_05v0 L=0.6U W=0.36U AS=0.0936P AD=0.0432P
+ PS=0.88U PD=0.6U
* device instance _2158 m90 *1 635.885,772.2 nfet_05v0
XM_2158 n_I3553 n_I3552 n_I3555 VSS nfet_05v0 L=0.6U W=0.36U AS=0.0432P
+ AD=0.369P PS=0.6U PD=2.77U
* device instance _2159 m90 *1 612.935,798.49 pfet_05v0
XM_2159 n_I3565 n_I3560 n_I3561 VDD_DEC pfet_05v0 L=0.5U W=0.36U AS=0.3456P
+ AD=0.0612P PS=2.64U PD=0.7U
* device instance _2160 m90 *1 612.095,798.49 pfet_05v0
XM_2160 n_I3565 n_I3560 VDD_DEC VDD_DEC pfet_05v0 L=0.5U W=0.36U AS=0.379P
+ AD=0.0612P PS=2.37U PD=0.7U
* device instance _2161 m90 *1 610.445,798.17 pfet_05v0
XM_2161 n_103 n_I3561 VDD_DEC VDD_DEC pfet_05v0 L=0.5U W=1.22U AS=0.379P
+ AD=0.5368P PS=2.37U PD=3.32U
* device instance _2162 m90 *1 617.175,798.6 pfet_05v0
XM_2162 VDD_DEC n_I2243 n_I3559 VDD_DEC pfet_05v0 L=0.5U W=0.36U AS=0.3852P
+ AD=0.1116P PS=2.86U PD=0.98U
* device instance _2163 m90 *1 616.055,798.6 pfet_05v0
XM_2163 n_I3564 n_I3559 VDD_DEC VDD_DEC pfet_05v0 L=0.5U W=0.36U AS=0.1116P
+ AD=0.0612P PS=0.98U PD=0.7U
* device instance _2164 m90 *1 615.215,798.6 pfet_05v0
XM_2164 n_I3564 n_I3559 n_I3560 VDD_DEC pfet_05v0 L=0.5U W=0.36U AS=0.3852P
+ AD=0.0612P PS=2.86U PD=0.7U
* device instance _2165 m90 *1 612.885,795.722 nfet_05v0
XM_2165 n_I3563 n_I3560 n_I3561 VSS nfet_05v0 L=0.6U W=0.365U AS=0.3705P
+ AD=0.0438P PS=2.77U PD=0.605U
* device instance _2166 m90 *1 612.045,795.722 nfet_05v0
XM_2166 VSS n_I3560 n_I3563 VSS nfet_05v0 L=0.6U W=0.365U AS=0.0438P
+ AD=0.282625P PS=0.605U PD=1.87U
* device instance _2167 m90 *1 610.395,795.95 nfet_05v0
XM_2167 n_103 n_I3561 VSS VSS nfet_05v0 L=0.6U W=0.82U AS=0.282625P AD=0.3608P
+ PS=1.87U PD=2.52U
* device instance _2168 m90 *1 617.125,795.72 nfet_05v0
XM_2168 VSS n_I2243 n_I3559 VSS nfet_05v0 L=0.6U W=0.36U AS=0.333P AD=0.0936P
+ PS=2.57U PD=0.88U
* device instance _2169 m90 *1 616.005,795.72 nfet_05v0
XM_2169 n_I3562 n_I3559 VSS VSS nfet_05v0 L=0.6U W=0.36U AS=0.0936P AD=0.0432P
+ PS=0.88U PD=0.6U
* device instance _2170 m90 *1 615.165,795.72 nfet_05v0
XM_2170 n_I3560 n_I3559 n_I3562 VSS nfet_05v0 L=0.6U W=0.36U AS=0.0432P
+ AD=0.369P PS=0.6U PD=2.77U
* device instance _2171 m90 *1 628.615,782.81 pfet_05v0
XM_2171 n_I3572 n_I3567 n_I3568 VDD_DEC pfet_05v0 L=0.5U W=0.36U AS=0.3456P
+ AD=0.0612P PS=2.64U PD=0.7U
* device instance _2172 m90 *1 627.775,782.81 pfet_05v0
XM_2172 n_I3572 n_I3567 VDD_DEC VDD_DEC pfet_05v0 L=0.5U W=0.36U AS=0.379P
+ AD=0.0612P PS=2.37U PD=0.7U
* device instance _2173 m90 *1 626.125,782.49 pfet_05v0
XM_2173 n_105 n_I3568 VDD_DEC VDD_DEC pfet_05v0 L=0.5U W=1.22U AS=0.379P
+ AD=0.5368P PS=2.37U PD=3.32U
* device instance _2174 m90 *1 632.855,782.92 pfet_05v0
XM_2174 VDD_DEC n_I2073 n_I3566 VDD_DEC pfet_05v0 L=0.5U W=0.36U AS=0.3852P
+ AD=0.1116P PS=2.86U PD=0.98U
* device instance _2175 m90 *1 631.735,782.92 pfet_05v0
XM_2175 n_I3571 n_I3566 VDD_DEC VDD_DEC pfet_05v0 L=0.5U W=0.36U AS=0.1116P
+ AD=0.0612P PS=0.98U PD=0.7U
* device instance _2176 m90 *1 630.895,782.92 pfet_05v0
XM_2176 n_I3571 n_I3566 n_I3567 VDD_DEC pfet_05v0 L=0.5U W=0.36U AS=0.3852P
+ AD=0.0612P PS=2.86U PD=0.7U
* device instance _2177 m90 *1 628.565,780.042 nfet_05v0
XM_2177 n_I3570 n_I3567 n_I3568 VSS nfet_05v0 L=0.6U W=0.365U AS=0.3705P
+ AD=0.0438P PS=2.77U PD=0.605U
* device instance _2178 m90 *1 627.725,780.042 nfet_05v0
XM_2178 VSS n_I3567 n_I3570 VSS nfet_05v0 L=0.6U W=0.365U AS=0.0438P
+ AD=0.282625P PS=0.605U PD=1.87U
* device instance _2179 m90 *1 626.075,780.27 nfet_05v0
XM_2179 n_105 n_I3568 VSS VSS nfet_05v0 L=0.6U W=0.82U AS=0.282625P AD=0.3608P
+ PS=1.87U PD=2.52U
* device instance _2180 m90 *1 632.805,780.04 nfet_05v0
XM_2180 VSS n_I2073 n_I3566 VSS nfet_05v0 L=0.6U W=0.36U AS=0.333P AD=0.0936P
+ PS=2.57U PD=0.88U
* device instance _2181 m90 *1 631.685,780.04 nfet_05v0
XM_2181 n_I3569 n_I3566 VSS VSS nfet_05v0 L=0.6U W=0.36U AS=0.0936P AD=0.0432P
+ PS=0.88U PD=0.6U
* device instance _2182 m90 *1 630.845,780.04 nfet_05v0
XM_2182 n_I3567 n_I3566 n_I3569 VSS nfet_05v0 L=0.6U W=0.36U AS=0.0432P
+ AD=0.369P PS=0.6U PD=2.77U
* device instance _2183 r180 *1 626.935,784.07 pfet_05v0
XM_2183 n_I3579 n_I3574 n_I3575 VDD_DEC pfet_05v0 L=0.5U W=0.36U AS=0.3456P
+ AD=0.0612P PS=2.64U PD=0.7U
* device instance _2184 r180 *1 626.095,784.07 pfet_05v0
XM_2184 n_I3579 n_I3574 VDD_DEC VDD_DEC pfet_05v0 L=0.5U W=0.36U AS=0.379P
+ AD=0.0612P PS=2.37U PD=0.7U
* device instance _2185 r180 *1 624.445,784.39 pfet_05v0
XM_2185 n_107 n_I3575 VDD_DEC VDD_DEC pfet_05v0 L=0.5U W=1.22U AS=0.379P
+ AD=0.5368P PS=2.37U PD=3.32U
* device instance _2186 r180 *1 631.175,783.96 pfet_05v0
XM_2186 VDD_DEC n_I2137 n_I3573 VDD_DEC pfet_05v0 L=0.5U W=0.36U AS=0.3852P
+ AD=0.1116P PS=2.86U PD=0.98U
* device instance _2187 r180 *1 630.055,783.96 pfet_05v0
XM_2187 n_I3578 n_I3573 VDD_DEC VDD_DEC pfet_05v0 L=0.5U W=0.36U AS=0.1116P
+ AD=0.0612P PS=0.98U PD=0.7U
* device instance _2188 r180 *1 629.215,783.96 pfet_05v0
XM_2188 n_I3578 n_I3573 n_I3574 VDD_DEC pfet_05v0 L=0.5U W=0.36U AS=0.3852P
+ AD=0.0612P PS=2.86U PD=0.7U
* device instance _2189 r180 *1 626.885,786.838 nfet_05v0
XM_2189 n_I3577 n_I3574 n_I3575 VSS nfet_05v0 L=0.6U W=0.365U AS=0.3705P
+ AD=0.0438P PS=2.77U PD=0.605U
* device instance _2190 r180 *1 626.045,786.838 nfet_05v0
XM_2190 VSS n_I3574 n_I3577 VSS nfet_05v0 L=0.6U W=0.365U AS=0.0438P
+ AD=0.282625P PS=0.605U PD=1.87U
* device instance _2191 r180 *1 624.395,786.61 nfet_05v0
XM_2191 n_107 n_I3575 VSS VSS nfet_05v0 L=0.6U W=0.82U AS=0.282625P AD=0.3608P
+ PS=1.87U PD=2.52U
* device instance _2192 r180 *1 631.125,786.84 nfet_05v0
XM_2192 VSS n_I2137 n_I3573 VSS nfet_05v0 L=0.6U W=0.36U AS=0.333P AD=0.0936P
+ PS=2.57U PD=0.88U
* device instance _2193 r180 *1 630.005,786.84 nfet_05v0
XM_2193 n_I3576 n_I3573 VSS VSS nfet_05v0 L=0.6U W=0.36U AS=0.0936P AD=0.0432P
+ PS=0.88U PD=0.6U
* device instance _2194 r180 *1 629.165,786.84 nfet_05v0
XM_2194 n_I3574 n_I3573 n_I3576 VSS nfet_05v0 L=0.6U W=0.36U AS=0.0432P
+ AD=0.369P PS=0.6U PD=2.77U
* device instance _2195 r180 *1 635.895,776.23 pfet_05v0
XM_2195 n_I3586 n_I3581 n_I3582 VDD_DEC pfet_05v0 L=0.5U W=0.36U AS=0.3456P
+ AD=0.0612P PS=2.64U PD=0.7U
* device instance _2196 r180 *1 635.055,776.23 pfet_05v0
XM_2196 n_I3586 n_I3581 VDD_DEC VDD_DEC pfet_05v0 L=0.5U W=0.36U AS=0.379P
+ AD=0.0612P PS=2.37U PD=0.7U
* device instance _2197 r180 *1 633.405,776.55 pfet_05v0
XM_2197 n_109 n_I3582 VDD_DEC VDD_DEC pfet_05v0 L=0.5U W=1.22U AS=0.379P
+ AD=0.5368P PS=2.37U PD=3.32U
* device instance _2198 r180 *1 640.135,776.12 pfet_05v0
XM_2198 VDD_DEC n_I2075 n_I3580 VDD_DEC pfet_05v0 L=0.5U W=0.36U AS=0.3852P
+ AD=0.1116P PS=2.86U PD=0.98U
* device instance _2199 r180 *1 639.015,776.12 pfet_05v0
XM_2199 n_I3585 n_I3580 VDD_DEC VDD_DEC pfet_05v0 L=0.5U W=0.36U AS=0.1116P
+ AD=0.0612P PS=0.98U PD=0.7U
* device instance _2200 r180 *1 638.175,776.12 pfet_05v0
XM_2200 n_I3585 n_I3580 n_I3581 VDD_DEC pfet_05v0 L=0.5U W=0.36U AS=0.3852P
+ AD=0.0612P PS=2.86U PD=0.7U
* device instance _2201 r180 *1 635.845,778.998 nfet_05v0
XM_2201 n_I3584 n_I3581 n_I3582 VSS nfet_05v0 L=0.6U W=0.365U AS=0.3705P
+ AD=0.0438P PS=2.77U PD=0.605U
* device instance _2202 r180 *1 635.005,778.998 nfet_05v0
XM_2202 VSS n_I3581 n_I3584 VSS nfet_05v0 L=0.6U W=0.365U AS=0.0438P
+ AD=0.282625P PS=0.605U PD=1.87U
* device instance _2203 r180 *1 633.355,778.77 nfet_05v0
XM_2203 n_109 n_I3582 VSS VSS nfet_05v0 L=0.6U W=0.82U AS=0.282625P AD=0.3608P
+ PS=1.87U PD=2.52U
* device instance _2204 r180 *1 640.085,779 nfet_05v0
XM_2204 VSS n_I2075 n_I3580 VSS nfet_05v0 L=0.6U W=0.36U AS=0.333P AD=0.0936P
+ PS=2.57U PD=0.88U
* device instance _2205 r180 *1 638.965,779 nfet_05v0
XM_2205 n_I3583 n_I3580 VSS VSS nfet_05v0 L=0.6U W=0.36U AS=0.0936P AD=0.0432P
+ PS=0.88U PD=0.6U
* device instance _2206 r180 *1 638.125,779 nfet_05v0
XM_2206 n_I3581 n_I3580 n_I3583 VSS nfet_05v0 L=0.6U W=0.36U AS=0.0432P
+ AD=0.369P PS=0.6U PD=2.77U
* device instance _2207 m90 *1 643.735,774.97 pfet_05v0
XM_2207 n_I3593 n_I3588 n_I3589 VDD_DEC pfet_05v0 L=0.5U W=0.36U AS=0.3456P
+ AD=0.0612P PS=2.64U PD=0.7U
* device instance _2208 m90 *1 642.895,774.97 pfet_05v0
XM_2208 n_I3593 n_I3588 VDD_DEC VDD_DEC pfet_05v0 L=0.5U W=0.36U AS=0.379P
+ AD=0.0612P PS=2.37U PD=0.7U
* device instance _2209 m90 *1 641.245,774.65 pfet_05v0
XM_2209 n_111 n_I3589 VDD_DEC VDD_DEC pfet_05v0 L=0.5U W=1.22U AS=0.379P
+ AD=0.5368P PS=2.37U PD=3.32U
* device instance _2210 m90 *1 647.975,775.08 pfet_05v0
XM_2210 VDD_DEC n_I2167 n_I3587 VDD_DEC pfet_05v0 L=0.5U W=0.36U AS=0.3852P
+ AD=0.1116P PS=2.86U PD=0.98U
* device instance _2211 m90 *1 646.855,775.08 pfet_05v0
XM_2211 n_I3592 n_I3587 VDD_DEC VDD_DEC pfet_05v0 L=0.5U W=0.36U AS=0.1116P
+ AD=0.0612P PS=0.98U PD=0.7U
* device instance _2212 m90 *1 646.015,775.08 pfet_05v0
XM_2212 n_I3592 n_I3587 n_I3588 VDD_DEC pfet_05v0 L=0.5U W=0.36U AS=0.3852P
+ AD=0.0612P PS=2.86U PD=0.7U
* device instance _2213 m90 *1 643.685,772.202 nfet_05v0
XM_2213 n_I3591 n_I3588 n_I3589 VSS nfet_05v0 L=0.6U W=0.365U AS=0.3705P
+ AD=0.0438P PS=2.77U PD=0.605U
* device instance _2214 m90 *1 642.845,772.202 nfet_05v0
XM_2214 VSS n_I3588 n_I3591 VSS nfet_05v0 L=0.6U W=0.365U AS=0.0438P
+ AD=0.282625P PS=0.605U PD=1.87U
* device instance _2215 m90 *1 641.195,772.43 nfet_05v0
XM_2215 n_111 n_I3589 VSS VSS nfet_05v0 L=0.6U W=0.82U AS=0.282625P AD=0.3608P
+ PS=1.87U PD=2.52U
* device instance _2216 m90 *1 647.925,772.2 nfet_05v0
XM_2216 VSS n_I2167 n_I3587 VSS nfet_05v0 L=0.6U W=0.36U AS=0.333P AD=0.0936P
+ PS=2.57U PD=0.88U
* device instance _2217 m90 *1 646.805,772.2 nfet_05v0
XM_2217 n_I3590 n_I3587 VSS VSS nfet_05v0 L=0.6U W=0.36U AS=0.0936P AD=0.0432P
+ PS=0.88U PD=0.6U
* device instance _2218 m90 *1 645.965,772.2 nfet_05v0
XM_2218 n_I3588 n_I3587 n_I3590 VSS nfet_05v0 L=0.6U W=0.36U AS=0.0432P
+ AD=0.369P PS=0.6U PD=2.77U
* device instance _2219 m90 *1 628.615,790.65 pfet_05v0
XM_2219 n_I3600 n_I3595 n_I3596 VDD_DEC pfet_05v0 L=0.5U W=0.36U AS=0.3456P
+ AD=0.0612P PS=2.64U PD=0.7U
* device instance _2220 m90 *1 627.775,790.65 pfet_05v0
XM_2220 n_I3600 n_I3595 VDD_DEC VDD_DEC pfet_05v0 L=0.5U W=0.36U AS=0.379P
+ AD=0.0612P PS=2.37U PD=0.7U
* device instance _2221 m90 *1 626.125,790.33 pfet_05v0
XM_2221 n_113 n_I3596 VDD_DEC VDD_DEC pfet_05v0 L=0.5U W=1.22U AS=0.379P
+ AD=0.5368P PS=2.37U PD=3.32U
* device instance _2222 m90 *1 632.855,790.76 pfet_05v0
XM_2222 VDD_DEC n_I2420 n_I3594 VDD_DEC pfet_05v0 L=0.5U W=0.36U AS=0.3852P
+ AD=0.1116P PS=2.86U PD=0.98U
* device instance _2223 m90 *1 631.735,790.76 pfet_05v0
XM_2223 n_I3599 n_I3594 VDD_DEC VDD_DEC pfet_05v0 L=0.5U W=0.36U AS=0.1116P
+ AD=0.0612P PS=0.98U PD=0.7U
* device instance _2224 m90 *1 630.895,790.76 pfet_05v0
XM_2224 n_I3599 n_I3594 n_I3595 VDD_DEC pfet_05v0 L=0.5U W=0.36U AS=0.3852P
+ AD=0.0612P PS=2.86U PD=0.7U
* device instance _2225 m90 *1 628.565,787.882 nfet_05v0
XM_2225 n_I3598 n_I3595 n_I3596 VSS nfet_05v0 L=0.6U W=0.365U AS=0.3705P
+ AD=0.0438P PS=2.77U PD=0.605U
* device instance _2226 m90 *1 627.725,787.882 nfet_05v0
XM_2226 VSS n_I3595 n_I3598 VSS nfet_05v0 L=0.6U W=0.365U AS=0.0438P
+ AD=0.282625P PS=0.605U PD=1.87U
* device instance _2227 m90 *1 626.075,788.11 nfet_05v0
XM_2227 n_113 n_I3596 VSS VSS nfet_05v0 L=0.6U W=0.82U AS=0.282625P AD=0.3608P
+ PS=1.87U PD=2.52U
* device instance _2228 m90 *1 632.805,787.88 nfet_05v0
XM_2228 VSS n_I2420 n_I3594 VSS nfet_05v0 L=0.6U W=0.36U AS=0.333P AD=0.0936P
+ PS=2.57U PD=0.88U
* device instance _2229 m90 *1 631.685,787.88 nfet_05v0
XM_2229 n_I3597 n_I3594 VSS VSS nfet_05v0 L=0.6U W=0.36U AS=0.0936P AD=0.0432P
+ PS=0.88U PD=0.6U
* device instance _2230 m90 *1 630.845,787.88 nfet_05v0
XM_2230 n_I3595 n_I3594 n_I3597 VSS nfet_05v0 L=0.6U W=0.36U AS=0.0432P
+ AD=0.369P PS=0.6U PD=2.77U
* device instance _2231 m90 *1 637.575,782.81 pfet_05v0
XM_2231 n_I3607 n_I3602 n_I3603 VDD_DEC pfet_05v0 L=0.5U W=0.36U AS=0.3456P
+ AD=0.0612P PS=2.64U PD=0.7U
* device instance _2232 m90 *1 636.735,782.81 pfet_05v0
XM_2232 n_I3607 n_I3602 VDD_DEC VDD_DEC pfet_05v0 L=0.5U W=0.36U AS=0.379P
+ AD=0.0612P PS=2.37U PD=0.7U
* device instance _2233 m90 *1 635.085,782.49 pfet_05v0
XM_2233 n_25 n_I3603 VDD_DEC VDD_DEC pfet_05v0 L=0.5U W=1.22U AS=0.379P
+ AD=0.5368P PS=2.37U PD=3.32U
* device instance _2234 m90 *1 641.815,782.92 pfet_05v0
XM_2234 VDD_DEC n_I2074 n_I3601 VDD_DEC pfet_05v0 L=0.5U W=0.36U AS=0.3852P
+ AD=0.1116P PS=2.86U PD=0.98U
* device instance _2235 m90 *1 640.695,782.92 pfet_05v0
XM_2235 n_I3606 n_I3601 VDD_DEC VDD_DEC pfet_05v0 L=0.5U W=0.36U AS=0.1116P
+ AD=0.0612P PS=0.98U PD=0.7U
* device instance _2236 m90 *1 639.855,782.92 pfet_05v0
XM_2236 n_I3606 n_I3601 n_I3602 VDD_DEC pfet_05v0 L=0.5U W=0.36U AS=0.3852P
+ AD=0.0612P PS=2.86U PD=0.7U
* device instance _2237 m90 *1 637.525,780.042 nfet_05v0
XM_2237 n_I3605 n_I3602 n_I3603 VSS nfet_05v0 L=0.6U W=0.365U AS=0.3705P
+ AD=0.0438P PS=2.77U PD=0.605U
* device instance _2238 m90 *1 636.685,780.042 nfet_05v0
XM_2238 VSS n_I3602 n_I3605 VSS nfet_05v0 L=0.6U W=0.365U AS=0.0438P
+ AD=0.282625P PS=0.605U PD=1.87U
* device instance _2239 m90 *1 635.035,780.27 nfet_05v0
XM_2239 n_25 n_I3603 VSS VSS nfet_05v0 L=0.6U W=0.82U AS=0.282625P AD=0.3608P
+ PS=1.87U PD=2.52U
* device instance _2240 m90 *1 641.765,780.04 nfet_05v0
XM_2240 VSS n_I2074 n_I3601 VSS nfet_05v0 L=0.6U W=0.36U AS=0.333P AD=0.0936P
+ PS=2.57U PD=0.88U
* device instance _2241 m90 *1 640.645,780.04 nfet_05v0
XM_2241 n_I3604 n_I3601 VSS VSS nfet_05v0 L=0.6U W=0.36U AS=0.0936P AD=0.0432P
+ PS=0.88U PD=0.6U
* device instance _2242 m90 *1 639.805,780.04 nfet_05v0
XM_2242 n_I3602 n_I3601 n_I3604 VSS nfet_05v0 L=0.6U W=0.36U AS=0.0432P
+ AD=0.369P PS=0.6U PD=2.77U
* device instance _2243 r180 *1 635.895,784.07 pfet_05v0
XM_2243 n_I3614 n_I3609 n_I3610 VDD_DEC pfet_05v0 L=0.5U W=0.36U AS=0.3456P
+ AD=0.0612P PS=2.64U PD=0.7U
* device instance _2244 r180 *1 635.055,784.07 pfet_05v0
XM_2244 n_I3614 n_I3609 VDD_DEC VDD_DEC pfet_05v0 L=0.5U W=0.36U AS=0.379P
+ AD=0.0612P PS=2.37U PD=0.7U
* device instance _2245 r180 *1 633.405,784.39 pfet_05v0
XM_2245 n_26 n_I3610 VDD_DEC VDD_DEC pfet_05v0 L=0.5U W=1.22U AS=0.379P
+ AD=0.5368P PS=2.37U PD=3.32U
* device instance _2246 r180 *1 640.135,783.96 pfet_05v0
XM_2246 VDD_DEC n_I2325 n_I3608 VDD_DEC pfet_05v0 L=0.5U W=0.36U AS=0.3852P
+ AD=0.1116P PS=2.86U PD=0.98U
* device instance _2247 r180 *1 639.015,783.96 pfet_05v0
XM_2247 n_I3613 n_I3608 VDD_DEC VDD_DEC pfet_05v0 L=0.5U W=0.36U AS=0.1116P
+ AD=0.0612P PS=0.98U PD=0.7U
* device instance _2248 r180 *1 638.175,783.96 pfet_05v0
XM_2248 n_I3613 n_I3608 n_I3609 VDD_DEC pfet_05v0 L=0.5U W=0.36U AS=0.3852P
+ AD=0.0612P PS=2.86U PD=0.7U
* device instance _2249 r180 *1 635.845,786.838 nfet_05v0
XM_2249 n_I3612 n_I3609 n_I3610 VSS nfet_05v0 L=0.6U W=0.365U AS=0.3705P
+ AD=0.0438P PS=2.77U PD=0.605U
* device instance _2250 r180 *1 635.005,786.838 nfet_05v0
XM_2250 VSS n_I3609 n_I3612 VSS nfet_05v0 L=0.6U W=0.365U AS=0.0438P
+ AD=0.282625P PS=0.605U PD=1.87U
* device instance _2251 r180 *1 633.355,786.61 nfet_05v0
XM_2251 n_26 n_I3610 VSS VSS nfet_05v0 L=0.6U W=0.82U AS=0.282625P AD=0.3608P
+ PS=1.87U PD=2.52U
* device instance _2252 r180 *1 640.085,786.84 nfet_05v0
XM_2252 VSS n_I2325 n_I3608 VSS nfet_05v0 L=0.6U W=0.36U AS=0.333P AD=0.0936P
+ PS=2.57U PD=0.88U
* device instance _2253 r180 *1 638.965,786.84 nfet_05v0
XM_2253 n_I3611 n_I3608 VSS VSS nfet_05v0 L=0.6U W=0.36U AS=0.0936P AD=0.0432P
+ PS=0.88U PD=0.6U
* device instance _2254 r180 *1 638.125,786.84 nfet_05v0
XM_2254 n_I3609 n_I3608 n_I3611 VSS nfet_05v0 L=0.6U W=0.36U AS=0.0432P
+ AD=0.369P PS=0.6U PD=2.77U
* device instance _2255 r180 *1 629.175,791.91 pfet_05v0
XM_2255 n_I3621 n_I3616 n_I3617 VDD_DEC pfet_05v0 L=0.5U W=0.36U AS=0.3456P
+ AD=0.0612P PS=2.64U PD=0.7U
* device instance _2256 r180 *1 628.335,791.91 pfet_05v0
XM_2256 n_I3621 n_I3616 VDD_DEC VDD_DEC pfet_05v0 L=0.5U W=0.36U AS=0.379P
+ AD=0.0612P PS=2.37U PD=0.7U
* device instance _2257 r180 *1 626.685,792.23 pfet_05v0
XM_2257 n_27 n_I3617 VDD_DEC VDD_DEC pfet_05v0 L=0.5U W=1.22U AS=0.379P
+ AD=0.5368P PS=2.37U PD=3.32U
* device instance _2258 r180 *1 633.415,791.8 pfet_05v0
XM_2258 VDD_DEC n_I2256 n_I3615 VDD_DEC pfet_05v0 L=0.5U W=0.36U AS=0.3852P
+ AD=0.1116P PS=2.86U PD=0.98U
* device instance _2259 r180 *1 632.295,791.8 pfet_05v0
XM_2259 n_I3620 n_I3615 VDD_DEC VDD_DEC pfet_05v0 L=0.5U W=0.36U AS=0.1116P
+ AD=0.0612P PS=0.98U PD=0.7U
* device instance _2260 r180 *1 631.455,791.8 pfet_05v0
XM_2260 n_I3620 n_I3615 n_I3616 VDD_DEC pfet_05v0 L=0.5U W=0.36U AS=0.3852P
+ AD=0.0612P PS=2.86U PD=0.7U
* device instance _2261 r180 *1 629.125,794.678 nfet_05v0
XM_2261 n_I3619 n_I3616 n_I3617 VSS nfet_05v0 L=0.6U W=0.365U AS=0.3705P
+ AD=0.0438P PS=2.77U PD=0.605U
* device instance _2262 r180 *1 628.285,794.678 nfet_05v0
XM_2262 VSS n_I3616 n_I3619 VSS nfet_05v0 L=0.6U W=0.365U AS=0.0438P
+ AD=0.282625P PS=0.605U PD=1.87U
* device instance _2263 r180 *1 626.635,794.45 nfet_05v0
XM_2263 n_27 n_I3617 VSS VSS nfet_05v0 L=0.6U W=0.82U AS=0.282625P AD=0.3608P
+ PS=1.87U PD=2.52U
* device instance _2264 r180 *1 633.365,794.68 nfet_05v0
XM_2264 VSS n_I2256 n_I3615 VSS nfet_05v0 L=0.6U W=0.36U AS=0.333P AD=0.0936P
+ PS=2.57U PD=0.88U
* device instance _2265 r180 *1 632.245,794.68 nfet_05v0
XM_2265 n_I3618 n_I3615 VSS VSS nfet_05v0 L=0.6U W=0.36U AS=0.0936P AD=0.0432P
+ PS=0.88U PD=0.6U
* device instance _2266 r180 *1 631.405,794.68 nfet_05v0
XM_2266 n_I3616 n_I3615 n_I3618 VSS nfet_05v0 L=0.6U W=0.36U AS=0.0432P
+ AD=0.369P PS=0.6U PD=2.77U
* device instance _2267 m90 *1 628.615,798.49 pfet_05v0
XM_2267 n_I3628 n_I3623 n_I3624 VDD_DEC pfet_05v0 L=0.5U W=0.36U AS=0.3456P
+ AD=0.0612P PS=2.64U PD=0.7U
* device instance _2268 m90 *1 627.775,798.49 pfet_05v0
XM_2268 n_I3628 n_I3623 VDD_DEC VDD_DEC pfet_05v0 L=0.5U W=0.36U AS=0.379P
+ AD=0.0612P PS=2.37U PD=0.7U
* device instance _2269 m90 *1 626.125,798.17 pfet_05v0
XM_2269 n_28 n_I3624 VDD_DEC VDD_DEC pfet_05v0 L=0.5U W=1.22U AS=0.379P
+ AD=0.5368P PS=2.37U PD=3.32U
* device instance _2270 m90 *1 632.855,798.6 pfet_05v0
XM_2270 VDD_DEC n_I2245 n_I3622 VDD_DEC pfet_05v0 L=0.5U W=0.36U AS=0.3852P
+ AD=0.1116P PS=2.86U PD=0.98U
* device instance _2271 m90 *1 631.735,798.6 pfet_05v0
XM_2271 n_I3627 n_I3622 VDD_DEC VDD_DEC pfet_05v0 L=0.5U W=0.36U AS=0.1116P
+ AD=0.0612P PS=0.98U PD=0.7U
* device instance _2272 m90 *1 630.895,798.6 pfet_05v0
XM_2272 n_I3627 n_I3622 n_I3623 VDD_DEC pfet_05v0 L=0.5U W=0.36U AS=0.3852P
+ AD=0.0612P PS=2.86U PD=0.7U
* device instance _2273 m90 *1 628.565,795.722 nfet_05v0
XM_2273 n_I3626 n_I3623 n_I3624 VSS nfet_05v0 L=0.6U W=0.365U AS=0.3705P
+ AD=0.0438P PS=2.77U PD=0.605U
* device instance _2274 m90 *1 627.725,795.722 nfet_05v0
XM_2274 VSS n_I3623 n_I3626 VSS nfet_05v0 L=0.6U W=0.365U AS=0.0438P
+ AD=0.282625P PS=0.605U PD=1.87U
* device instance _2275 m90 *1 626.075,795.95 nfet_05v0
XM_2275 n_28 n_I3624 VSS VSS nfet_05v0 L=0.6U W=0.82U AS=0.282625P AD=0.3608P
+ PS=1.87U PD=2.52U
* device instance _2276 m90 *1 632.805,795.72 nfet_05v0
XM_2276 VSS n_I2245 n_I3622 VSS nfet_05v0 L=0.6U W=0.36U AS=0.333P AD=0.0936P
+ PS=2.57U PD=0.88U
* device instance _2277 m90 *1 631.685,795.72 nfet_05v0
XM_2277 n_I3625 n_I3622 VSS VSS nfet_05v0 L=0.6U W=0.36U AS=0.0936P AD=0.0432P
+ PS=0.88U PD=0.6U
* device instance _2278 m90 *1 630.845,795.72 nfet_05v0
XM_2278 n_I3623 n_I3622 n_I3625 VSS nfet_05v0 L=0.6U W=0.36U AS=0.0432P
+ AD=0.369P PS=0.6U PD=2.77U
* device instance _2279 r180 *1 648.215,776.23 pfet_05v0
XM_2279 n_I3635 n_I3630 n_I3631 VDD_DEC pfet_05v0 L=0.5U W=0.36U AS=0.3456P
+ AD=0.0612P PS=2.64U PD=0.7U
* device instance _2280 r180 *1 647.375,776.23 pfet_05v0
XM_2280 n_I3635 n_I3630 VDD_DEC VDD_DEC pfet_05v0 L=0.5U W=0.36U AS=0.379P
+ AD=0.0612P PS=2.37U PD=0.7U
* device instance _2281 r180 *1 645.725,776.55 pfet_05v0
XM_2281 n_29 n_I3631 VDD_DEC VDD_DEC pfet_05v0 L=0.5U W=1.22U AS=0.379P
+ AD=0.5368P PS=2.37U PD=3.32U
* device instance _2282 r180 *1 652.455,776.12 pfet_05v0
XM_2282 VDD_DEC n_I2032 n_I3629 VDD_DEC pfet_05v0 L=0.5U W=0.36U AS=0.3852P
+ AD=0.1116P PS=2.86U PD=0.98U
* device instance _2283 r180 *1 651.335,776.12 pfet_05v0
XM_2283 n_I3634 n_I3629 VDD_DEC VDD_DEC pfet_05v0 L=0.5U W=0.36U AS=0.1116P
+ AD=0.0612P PS=0.98U PD=0.7U
* device instance _2284 r180 *1 650.495,776.12 pfet_05v0
XM_2284 n_I3634 n_I3629 n_I3630 VDD_DEC pfet_05v0 L=0.5U W=0.36U AS=0.3852P
+ AD=0.0612P PS=2.86U PD=0.7U
* device instance _2285 r180 *1 648.165,778.998 nfet_05v0
XM_2285 n_I3633 n_I3630 n_I3631 VSS nfet_05v0 L=0.6U W=0.365U AS=0.3705P
+ AD=0.0438P PS=2.77U PD=0.605U
* device instance _2286 r180 *1 647.325,778.998 nfet_05v0
XM_2286 VSS n_I3630 n_I3633 VSS nfet_05v0 L=0.6U W=0.365U AS=0.0438P
+ AD=0.282625P PS=0.605U PD=1.87U
* device instance _2287 r180 *1 645.675,778.77 nfet_05v0
XM_2287 n_29 n_I3631 VSS VSS nfet_05v0 L=0.6U W=0.82U AS=0.282625P AD=0.3608P
+ PS=1.87U PD=2.52U
* device instance _2288 r180 *1 652.405,779 nfet_05v0
XM_2288 VSS n_I2032 n_I3629 VSS nfet_05v0 L=0.6U W=0.36U AS=0.333P AD=0.0936P
+ PS=2.57U PD=0.88U
* device instance _2289 r180 *1 651.285,779 nfet_05v0
XM_2289 n_I3632 n_I3629 VSS VSS nfet_05v0 L=0.6U W=0.36U AS=0.0936P AD=0.0432P
+ PS=0.88U PD=0.6U
* device instance _2290 r180 *1 650.445,779 nfet_05v0
XM_2290 n_I3630 n_I3629 n_I3632 VSS nfet_05v0 L=0.6U W=0.36U AS=0.0432P
+ AD=0.369P PS=0.6U PD=2.77U
* device instance _2291 m90 *1 652.695,774.97 pfet_05v0
XM_2291 n_I3642 n_I3637 n_I3638 VDD_DEC pfet_05v0 L=0.5U W=0.36U AS=0.3456P
+ AD=0.0612P PS=2.64U PD=0.7U
* device instance _2292 m90 *1 651.855,774.97 pfet_05v0
XM_2292 n_I3642 n_I3637 VDD_DEC VDD_DEC pfet_05v0 L=0.5U W=0.36U AS=0.379P
+ AD=0.0612P PS=2.37U PD=0.7U
* device instance _2293 m90 *1 650.205,774.65 pfet_05v0
XM_2293 n_30 n_I3638 VDD_DEC VDD_DEC pfet_05v0 L=0.5U W=1.22U AS=0.379P
+ AD=0.5368P PS=2.37U PD=3.32U
* device instance _2294 m90 *1 656.935,775.08 pfet_05v0
XM_2294 VDD_DEC n_I2030 n_I3636 VDD_DEC pfet_05v0 L=0.5U W=0.36U AS=0.3852P
+ AD=0.1116P PS=2.86U PD=0.98U
* device instance _2295 m90 *1 655.815,775.08 pfet_05v0
XM_2295 n_I3641 n_I3636 VDD_DEC VDD_DEC pfet_05v0 L=0.5U W=0.36U AS=0.1116P
+ AD=0.0612P PS=0.98U PD=0.7U
* device instance _2296 m90 *1 654.975,775.08 pfet_05v0
XM_2296 n_I3641 n_I3636 n_I3637 VDD_DEC pfet_05v0 L=0.5U W=0.36U AS=0.3852P
+ AD=0.0612P PS=2.86U PD=0.7U
* device instance _2297 m90 *1 652.645,772.202 nfet_05v0
XM_2297 n_I3640 n_I3637 n_I3638 VSS nfet_05v0 L=0.6U W=0.365U AS=0.3705P
+ AD=0.0438P PS=2.77U PD=0.605U
* device instance _2298 m90 *1 651.805,772.202 nfet_05v0
XM_2298 VSS n_I3637 n_I3640 VSS nfet_05v0 L=0.6U W=0.365U AS=0.0438P
+ AD=0.282625P PS=0.605U PD=1.87U
* device instance _2299 m90 *1 650.155,772.43 nfet_05v0
XM_2299 n_30 n_I3638 VSS VSS nfet_05v0 L=0.6U W=0.82U AS=0.282625P AD=0.3608P
+ PS=1.87U PD=2.52U
* device instance _2300 m90 *1 656.885,772.2 nfet_05v0
XM_2300 VSS n_I2030 n_I3636 VSS nfet_05v0 L=0.6U W=0.36U AS=0.333P AD=0.0936P
+ PS=2.57U PD=0.88U
* device instance _2301 m90 *1 655.765,772.2 nfet_05v0
XM_2301 n_I3639 n_I3636 VSS VSS nfet_05v0 L=0.6U W=0.36U AS=0.0936P AD=0.0432P
+ PS=0.88U PD=0.6U
* device instance _2302 m90 *1 654.925,772.2 nfet_05v0
XM_2302 n_I3637 n_I3636 n_I3639 VSS nfet_05v0 L=0.6U W=0.36U AS=0.0432P
+ AD=0.369P PS=0.6U PD=2.77U
* device instance _2303 m90 *1 637.575,790.65 pfet_05v0
XM_2303 n_I3649 n_I3644 n_I3645 VDD_DEC pfet_05v0 L=0.5U W=0.36U AS=0.3456P
+ AD=0.0612P PS=2.64U PD=0.7U
* device instance _2304 m90 *1 636.735,790.65 pfet_05v0
XM_2304 n_I3649 n_I3644 VDD_DEC VDD_DEC pfet_05v0 L=0.5U W=0.36U AS=0.379P
+ AD=0.0612P PS=2.37U PD=0.7U
* device instance _2305 m90 *1 635.085,790.33 pfet_05v0
XM_2305 n_31 n_I3645 VDD_DEC VDD_DEC pfet_05v0 L=0.5U W=1.22U AS=0.379P
+ AD=0.5368P PS=2.37U PD=3.32U
* device instance _2306 m90 *1 641.815,790.76 pfet_05v0
XM_2306 VDD_DEC n_I2312 n_I3643 VDD_DEC pfet_05v0 L=0.5U W=0.36U AS=0.3852P
+ AD=0.1116P PS=2.86U PD=0.98U
* device instance _2307 m90 *1 640.695,790.76 pfet_05v0
XM_2307 n_I3648 n_I3643 VDD_DEC VDD_DEC pfet_05v0 L=0.5U W=0.36U AS=0.1116P
+ AD=0.0612P PS=0.98U PD=0.7U
* device instance _2308 m90 *1 639.855,790.76 pfet_05v0
XM_2308 n_I3648 n_I3643 n_I3644 VDD_DEC pfet_05v0 L=0.5U W=0.36U AS=0.3852P
+ AD=0.0612P PS=2.86U PD=0.7U
* device instance _2309 m90 *1 637.525,787.882 nfet_05v0
XM_2309 n_I3647 n_I3644 n_I3645 VSS nfet_05v0 L=0.6U W=0.365U AS=0.3705P
+ AD=0.0438P PS=2.77U PD=0.605U
* device instance _2310 m90 *1 636.685,787.882 nfet_05v0
XM_2310 VSS n_I3644 n_I3647 VSS nfet_05v0 L=0.6U W=0.365U AS=0.0438P
+ AD=0.282625P PS=0.605U PD=1.87U
* device instance _2311 m90 *1 635.035,788.11 nfet_05v0
XM_2311 n_31 n_I3645 VSS VSS nfet_05v0 L=0.6U W=0.82U AS=0.282625P AD=0.3608P
+ PS=1.87U PD=2.52U
* device instance _2312 m90 *1 641.765,787.88 nfet_05v0
XM_2312 VSS n_I2312 n_I3643 VSS nfet_05v0 L=0.6U W=0.36U AS=0.333P AD=0.0936P
+ PS=2.57U PD=0.88U
* device instance _2313 m90 *1 640.645,787.88 nfet_05v0
XM_2313 n_I3646 n_I3643 VSS VSS nfet_05v0 L=0.6U W=0.36U AS=0.0936P AD=0.0432P
+ PS=0.88U PD=0.6U
* device instance _2314 m90 *1 639.805,787.88 nfet_05v0
XM_2314 n_I3644 n_I3643 n_I3646 VSS nfet_05v0 L=0.6U W=0.36U AS=0.0432P
+ AD=0.369P PS=0.6U PD=2.77U
* device instance _2315 m90 *1 646.535,782.81 pfet_05v0
XM_2315 n_I3656 n_I3651 n_I3652 VDD_DEC pfet_05v0 L=0.5U W=0.36U AS=0.3456P
+ AD=0.0612P PS=2.64U PD=0.7U
* device instance _2316 m90 *1 645.695,782.81 pfet_05v0
XM_2316 n_I3656 n_I3651 VDD_DEC VDD_DEC pfet_05v0 L=0.5U W=0.36U AS=0.379P
+ AD=0.0612P PS=2.37U PD=0.7U
* device instance _2317 m90 *1 644.045,782.49 pfet_05v0
XM_2317 n_32 n_I3652 VDD_DEC VDD_DEC pfet_05v0 L=0.5U W=1.22U AS=0.379P
+ AD=0.5368P PS=2.37U PD=3.32U
* device instance _2318 m90 *1 650.775,782.92 pfet_05v0
XM_2318 VDD_DEC n_I2078 n_I3650 VDD_DEC pfet_05v0 L=0.5U W=0.36U AS=0.3852P
+ AD=0.1116P PS=2.86U PD=0.98U
* device instance _2319 m90 *1 649.655,782.92 pfet_05v0
XM_2319 n_I3655 n_I3650 VDD_DEC VDD_DEC pfet_05v0 L=0.5U W=0.36U AS=0.1116P
+ AD=0.0612P PS=0.98U PD=0.7U
* device instance _2320 m90 *1 648.815,782.92 pfet_05v0
XM_2320 n_I3655 n_I3650 n_I3651 VDD_DEC pfet_05v0 L=0.5U W=0.36U AS=0.3852P
+ AD=0.0612P PS=2.86U PD=0.7U
* device instance _2321 m90 *1 646.485,780.042 nfet_05v0
XM_2321 n_I3654 n_I3651 n_I3652 VSS nfet_05v0 L=0.6U W=0.365U AS=0.3705P
+ AD=0.0438P PS=2.77U PD=0.605U
* device instance _2322 m90 *1 645.645,780.042 nfet_05v0
XM_2322 VSS n_I3651 n_I3654 VSS nfet_05v0 L=0.6U W=0.365U AS=0.0438P
+ AD=0.282625P PS=0.605U PD=1.87U
* device instance _2323 m90 *1 643.995,780.27 nfet_05v0
XM_2323 n_32 n_I3652 VSS VSS nfet_05v0 L=0.6U W=0.82U AS=0.282625P AD=0.3608P
+ PS=1.87U PD=2.52U
* device instance _2324 m90 *1 650.725,780.04 nfet_05v0
XM_2324 VSS n_I2078 n_I3650 VSS nfet_05v0 L=0.6U W=0.36U AS=0.333P AD=0.0936P
+ PS=2.57U PD=0.88U
* device instance _2325 m90 *1 649.605,780.04 nfet_05v0
XM_2325 n_I3653 n_I3650 VSS VSS nfet_05v0 L=0.6U W=0.36U AS=0.0936P AD=0.0432P
+ PS=0.88U PD=0.6U
* device instance _2326 m90 *1 648.765,780.04 nfet_05v0
XM_2326 n_I3651 n_I3650 n_I3653 VSS nfet_05v0 L=0.6U W=0.36U AS=0.0432P
+ AD=0.369P PS=0.6U PD=2.77U
* device instance _2327 m90 *1 628.615,806.33 pfet_05v0
XM_2327 n_I3663 n_I3658 n_I3659 VDD_DEC pfet_05v0 L=0.5U W=0.36U AS=0.3456P
+ AD=0.0612P PS=2.64U PD=0.7U
* device instance _2328 m90 *1 627.775,806.33 pfet_05v0
XM_2328 n_I3663 n_I3658 VDD_DEC VDD_DEC pfet_05v0 L=0.5U W=0.36U AS=0.379P
+ AD=0.0612P PS=2.37U PD=0.7U
* device instance _2329 m90 *1 626.125,806.01 pfet_05v0
XM_2329 n_33 n_I3659 VDD_DEC VDD_DEC pfet_05v0 L=0.5U W=1.22U AS=0.379P
+ AD=0.5368P PS=2.37U PD=3.32U
* device instance _2330 m90 *1 632.855,806.44 pfet_05v0
XM_2330 VDD_DEC n_I2174 n_I3657 VDD_DEC pfet_05v0 L=0.5U W=0.36U AS=0.3852P
+ AD=0.1116P PS=2.86U PD=0.98U
* device instance _2331 m90 *1 631.735,806.44 pfet_05v0
XM_2331 n_I3662 n_I3657 VDD_DEC VDD_DEC pfet_05v0 L=0.5U W=0.36U AS=0.1116P
+ AD=0.0612P PS=0.98U PD=0.7U
* device instance _2332 m90 *1 630.895,806.44 pfet_05v0
XM_2332 n_I3662 n_I3657 n_I3658 VDD_DEC pfet_05v0 L=0.5U W=0.36U AS=0.3852P
+ AD=0.0612P PS=2.86U PD=0.7U
* device instance _2333 m90 *1 628.565,803.562 nfet_05v0
XM_2333 n_I3661 n_I3658 n_I3659 VSS nfet_05v0 L=0.6U W=0.365U AS=0.3705P
+ AD=0.0438P PS=2.77U PD=0.605U
* device instance _2334 m90 *1 627.725,803.562 nfet_05v0
XM_2334 VSS n_I3658 n_I3661 VSS nfet_05v0 L=0.6U W=0.365U AS=0.0438P
+ AD=0.282625P PS=0.605U PD=1.87U
* device instance _2335 m90 *1 626.075,803.79 nfet_05v0
XM_2335 n_33 n_I3659 VSS VSS nfet_05v0 L=0.6U W=0.82U AS=0.282625P AD=0.3608P
+ PS=1.87U PD=2.52U
* device instance _2336 m90 *1 632.805,803.56 nfet_05v0
XM_2336 VSS n_I2174 n_I3657 VSS nfet_05v0 L=0.6U W=0.36U AS=0.333P AD=0.0936P
+ PS=2.57U PD=0.88U
* device instance _2337 m90 *1 631.685,803.56 nfet_05v0
XM_2337 n_I3660 n_I3657 VSS VSS nfet_05v0 L=0.6U W=0.36U AS=0.0936P AD=0.0432P
+ PS=0.88U PD=0.6U
* device instance _2338 m90 *1 630.845,803.56 nfet_05v0
XM_2338 n_I3658 n_I3657 n_I3660 VSS nfet_05v0 L=0.6U W=0.36U AS=0.0432P
+ AD=0.369P PS=0.6U PD=2.77U
* device instance _2339 r180 *1 657.175,776.23 pfet_05v0
XM_2339 n_I3670 n_I3665 n_I3666 VDD_DEC pfet_05v0 L=0.5U W=0.36U AS=0.3456P
+ AD=0.0612P PS=2.64U PD=0.7U
* device instance _2340 r180 *1 656.335,776.23 pfet_05v0
XM_2340 n_I3670 n_I3665 VDD_DEC VDD_DEC pfet_05v0 L=0.5U W=0.36U AS=0.379P
+ AD=0.0612P PS=2.37U PD=0.7U
* device instance _2341 r180 *1 654.685,776.55 pfet_05v0
XM_2341 n_34 n_I3666 VDD_DEC VDD_DEC pfet_05v0 L=0.5U W=1.22U AS=0.379P
+ AD=0.5368P PS=2.37U PD=3.32U
* device instance _2342 r180 *1 661.415,776.12 pfet_05v0
XM_2342 VDD_DEC n_I2079 n_I3664 VDD_DEC pfet_05v0 L=0.5U W=0.36U AS=0.3852P
+ AD=0.1116P PS=2.86U PD=0.98U
* device instance _2343 r180 *1 660.295,776.12 pfet_05v0
XM_2343 n_I3669 n_I3664 VDD_DEC VDD_DEC pfet_05v0 L=0.5U W=0.36U AS=0.1116P
+ AD=0.0612P PS=0.98U PD=0.7U
* device instance _2344 r180 *1 659.455,776.12 pfet_05v0
XM_2344 n_I3669 n_I3664 n_I3665 VDD_DEC pfet_05v0 L=0.5U W=0.36U AS=0.3852P
+ AD=0.0612P PS=2.86U PD=0.7U
* device instance _2345 r180 *1 657.125,778.998 nfet_05v0
XM_2345 n_I3668 n_I3665 n_I3666 VSS nfet_05v0 L=0.6U W=0.365U AS=0.3705P
+ AD=0.0438P PS=2.77U PD=0.605U
* device instance _2346 r180 *1 656.285,778.998 nfet_05v0
XM_2346 VSS n_I3665 n_I3668 VSS nfet_05v0 L=0.6U W=0.365U AS=0.0438P
+ AD=0.282625P PS=0.605U PD=1.87U
* device instance _2347 r180 *1 654.635,778.77 nfet_05v0
XM_2347 n_34 n_I3666 VSS VSS nfet_05v0 L=0.6U W=0.82U AS=0.282625P AD=0.3608P
+ PS=1.87U PD=2.52U
* device instance _2348 r180 *1 661.365,779 nfet_05v0
XM_2348 VSS n_I2079 n_I3664 VSS nfet_05v0 L=0.6U W=0.36U AS=0.333P AD=0.0936P
+ PS=2.57U PD=0.88U
* device instance _2349 r180 *1 660.245,779 nfet_05v0
XM_2349 n_I3667 n_I3664 VSS VSS nfet_05v0 L=0.6U W=0.36U AS=0.0936P AD=0.0432P
+ PS=0.88U PD=0.6U
* device instance _2350 r180 *1 659.405,779 nfet_05v0
XM_2350 n_I3665 n_I3664 n_I3667 VSS nfet_05v0 L=0.6U W=0.36U AS=0.0432P
+ AD=0.369P PS=0.6U PD=2.77U
* device instance _2351 m90 *1 662.775,774.97 pfet_05v0
XM_2351 n_I3677 n_I3672 n_I3673 VDD_DEC pfet_05v0 L=0.5U W=0.36U AS=0.3456P
+ AD=0.0612P PS=2.64U PD=0.7U
* device instance _2352 m90 *1 661.935,774.97 pfet_05v0
XM_2352 n_I3677 n_I3672 VDD_DEC VDD_DEC pfet_05v0 L=0.5U W=0.36U AS=0.379P
+ AD=0.0612P PS=2.37U PD=0.7U
* device instance _2353 m90 *1 660.285,774.65 pfet_05v0
XM_2353 n_35 n_I3673 VDD_DEC VDD_DEC pfet_05v0 L=0.5U W=1.22U AS=0.379P
+ AD=0.5368P PS=2.37U PD=3.32U
* device instance _2354 m90 *1 667.015,775.08 pfet_05v0
XM_2354 VDD_DEC n_I2077 n_I3671 VDD_DEC pfet_05v0 L=0.5U W=0.36U AS=0.3852P
+ AD=0.1116P PS=2.86U PD=0.98U
* device instance _2355 m90 *1 665.895,775.08 pfet_05v0
XM_2355 n_I3676 n_I3671 VDD_DEC VDD_DEC pfet_05v0 L=0.5U W=0.36U AS=0.1116P
+ AD=0.0612P PS=0.98U PD=0.7U
* device instance _2356 m90 *1 665.055,775.08 pfet_05v0
XM_2356 n_I3676 n_I3671 n_I3672 VDD_DEC pfet_05v0 L=0.5U W=0.36U AS=0.3852P
+ AD=0.0612P PS=2.86U PD=0.7U
* device instance _2357 m90 *1 662.725,772.202 nfet_05v0
XM_2357 n_I3675 n_I3672 n_I3673 VSS nfet_05v0 L=0.6U W=0.365U AS=0.3705P
+ AD=0.0438P PS=2.77U PD=0.605U
* device instance _2358 m90 *1 661.885,772.202 nfet_05v0
XM_2358 VSS n_I3672 n_I3675 VSS nfet_05v0 L=0.6U W=0.365U AS=0.0438P
+ AD=0.282625P PS=0.605U PD=1.87U
* device instance _2359 m90 *1 660.235,772.43 nfet_05v0
XM_2359 n_35 n_I3673 VSS VSS nfet_05v0 L=0.6U W=0.82U AS=0.282625P AD=0.3608P
+ PS=1.87U PD=2.52U
* device instance _2360 m90 *1 666.965,772.2 nfet_05v0
XM_2360 VSS n_I2077 n_I3671 VSS nfet_05v0 L=0.6U W=0.36U AS=0.333P AD=0.0936P
+ PS=2.57U PD=0.88U
* device instance _2361 m90 *1 665.845,772.2 nfet_05v0
XM_2361 n_I3674 n_I3671 VSS VSS nfet_05v0 L=0.6U W=0.36U AS=0.0936P AD=0.0432P
+ PS=0.88U PD=0.6U
* device instance _2362 m90 *1 665.005,772.2 nfet_05v0
XM_2362 n_I3672 n_I3671 n_I3674 VSS nfet_05v0 L=0.6U W=0.36U AS=0.0432P
+ AD=0.369P PS=0.6U PD=2.77U
* device instance _2363 m90 *1 655.495,782.81 pfet_05v0
XM_2363 n_I3684 n_I3679 n_I3680 VDD_DEC pfet_05v0 L=0.5U W=0.36U AS=0.3456P
+ AD=0.0612P PS=2.64U PD=0.7U
* device instance _2364 m90 *1 654.655,782.81 pfet_05v0
XM_2364 n_I3684 n_I3679 VDD_DEC VDD_DEC pfet_05v0 L=0.5U W=0.36U AS=0.379P
+ AD=0.0612P PS=2.37U PD=0.7U
* device instance _2365 m90 *1 653.005,782.49 pfet_05v0
XM_2365 n_36 n_I3680 VDD_DEC VDD_DEC pfet_05v0 L=0.5U W=1.22U AS=0.379P
+ AD=0.5368P PS=2.37U PD=3.32U
* device instance _2366 m90 *1 659.735,782.92 pfet_05v0
XM_2366 VDD_DEC n_I2076 n_I3678 VDD_DEC pfet_05v0 L=0.5U W=0.36U AS=0.3852P
+ AD=0.1116P PS=2.86U PD=0.98U
* device instance _2367 m90 *1 658.615,782.92 pfet_05v0
XM_2367 n_I3683 n_I3678 VDD_DEC VDD_DEC pfet_05v0 L=0.5U W=0.36U AS=0.1116P
+ AD=0.0612P PS=0.98U PD=0.7U
* device instance _2368 m90 *1 657.775,782.92 pfet_05v0
XM_2368 n_I3683 n_I3678 n_I3679 VDD_DEC pfet_05v0 L=0.5U W=0.36U AS=0.3852P
+ AD=0.0612P PS=2.86U PD=0.7U
* device instance _2369 m90 *1 655.445,780.042 nfet_05v0
XM_2369 n_I3682 n_I3679 n_I3680 VSS nfet_05v0 L=0.6U W=0.365U AS=0.3705P
+ AD=0.0438P PS=2.77U PD=0.605U
* device instance _2370 m90 *1 654.605,780.042 nfet_05v0
XM_2370 VSS n_I3679 n_I3682 VSS nfet_05v0 L=0.6U W=0.365U AS=0.0438P
+ AD=0.282625P PS=0.605U PD=1.87U
* device instance _2371 m90 *1 652.955,780.27 nfet_05v0
XM_2371 n_36 n_I3680 VSS VSS nfet_05v0 L=0.6U W=0.82U AS=0.282625P AD=0.3608P
+ PS=1.87U PD=2.52U
* device instance _2372 m90 *1 659.685,780.04 nfet_05v0
XM_2372 VSS n_I2076 n_I3678 VSS nfet_05v0 L=0.6U W=0.36U AS=0.333P AD=0.0936P
+ PS=2.57U PD=0.88U
* device instance _2373 m90 *1 658.565,780.04 nfet_05v0
XM_2373 n_I3681 n_I3678 VSS VSS nfet_05v0 L=0.6U W=0.36U AS=0.0936P AD=0.0432P
+ PS=0.88U PD=0.6U
* device instance _2374 m90 *1 657.725,780.04 nfet_05v0
XM_2374 n_I3679 n_I3678 n_I3681 VSS nfet_05v0 L=0.6U W=0.36U AS=0.0432P
+ AD=0.369P PS=0.6U PD=2.77U
* device instance _2375 r180 *1 658.295,784.07 pfet_05v0
XM_2375 n_I3691 n_I3686 n_I3687 VDD_DEC pfet_05v0 L=0.5U W=0.36U AS=0.3456P
+ AD=0.0612P PS=2.64U PD=0.7U
* device instance _2376 r180 *1 657.455,784.07 pfet_05v0
XM_2376 n_I3691 n_I3686 VDD_DEC VDD_DEC pfet_05v0 L=0.5U W=0.36U AS=0.379P
+ AD=0.0612P PS=2.37U PD=0.7U
* device instance _2377 r180 *1 655.805,784.39 pfet_05v0
XM_2377 n_37 n_I3687 VDD_DEC VDD_DEC pfet_05v0 L=0.5U W=1.22U AS=0.379P
+ AD=0.5368P PS=2.37U PD=3.32U
* device instance _2378 r180 *1 662.535,783.96 pfet_05v0
XM_2378 VDD_DEC n_I2327 n_I3685 VDD_DEC pfet_05v0 L=0.5U W=0.36U AS=0.3852P
+ AD=0.1116P PS=2.86U PD=0.98U
* device instance _2379 r180 *1 661.415,783.96 pfet_05v0
XM_2379 n_I3690 n_I3685 VDD_DEC VDD_DEC pfet_05v0 L=0.5U W=0.36U AS=0.1116P
+ AD=0.0612P PS=0.98U PD=0.7U
* device instance _2380 r180 *1 660.575,783.96 pfet_05v0
XM_2380 n_I3690 n_I3685 n_I3686 VDD_DEC pfet_05v0 L=0.5U W=0.36U AS=0.3852P
+ AD=0.0612P PS=2.86U PD=0.7U
* device instance _2381 r180 *1 658.245,786.838 nfet_05v0
XM_2381 n_I3689 n_I3686 n_I3687 VSS nfet_05v0 L=0.6U W=0.365U AS=0.3705P
+ AD=0.0438P PS=2.77U PD=0.605U
* device instance _2382 r180 *1 657.405,786.838 nfet_05v0
XM_2382 VSS n_I3686 n_I3689 VSS nfet_05v0 L=0.6U W=0.365U AS=0.0438P
+ AD=0.282625P PS=0.605U PD=1.87U
* device instance _2383 r180 *1 655.755,786.61 nfet_05v0
XM_2383 n_37 n_I3687 VSS VSS nfet_05v0 L=0.6U W=0.82U AS=0.282625P AD=0.3608P
+ PS=1.87U PD=2.52U
* device instance _2384 r180 *1 662.485,786.84 nfet_05v0
XM_2384 VSS n_I2327 n_I3685 VSS nfet_05v0 L=0.6U W=0.36U AS=0.333P AD=0.0936P
+ PS=2.57U PD=0.88U
* device instance _2385 r180 *1 661.365,786.84 nfet_05v0
XM_2385 n_I3688 n_I3685 VSS VSS nfet_05v0 L=0.6U W=0.36U AS=0.0936P AD=0.0432P
+ PS=0.88U PD=0.6U
* device instance _2386 r180 *1 660.525,786.84 nfet_05v0
XM_2386 n_I3686 n_I3685 n_I3688 VSS nfet_05v0 L=0.6U W=0.36U AS=0.0432P
+ AD=0.369P PS=0.6U PD=2.77U
* device instance _2387 r180 *1 666.135,776.23 pfet_05v0
XM_2387 n_I3698 n_I3693 n_I3694 VDD_DEC pfet_05v0 L=0.5U W=0.36U AS=0.3456P
+ AD=0.0612P PS=2.64U PD=0.7U
* device instance _2388 r180 *1 665.295,776.23 pfet_05v0
XM_2388 n_I3698 n_I3693 VDD_DEC VDD_DEC pfet_05v0 L=0.5U W=0.36U AS=0.379P
+ AD=0.0612P PS=2.37U PD=0.7U
* device instance _2389 r180 *1 663.645,776.55 pfet_05v0
XM_2389 n_38 n_I3694 VDD_DEC VDD_DEC pfet_05v0 L=0.5U W=1.22U AS=0.379P
+ AD=0.5368P PS=2.37U PD=3.32U
* device instance _2390 r180 *1 670.375,776.12 pfet_05v0
XM_2390 VDD_DEC n_I2081 n_I3692 VDD_DEC pfet_05v0 L=0.5U W=0.36U AS=0.3852P
+ AD=0.1116P PS=2.86U PD=0.98U
* device instance _2391 r180 *1 669.255,776.12 pfet_05v0
XM_2391 n_I3697 n_I3692 VDD_DEC VDD_DEC pfet_05v0 L=0.5U W=0.36U AS=0.1116P
+ AD=0.0612P PS=0.98U PD=0.7U
* device instance _2392 r180 *1 668.415,776.12 pfet_05v0
XM_2392 n_I3697 n_I3692 n_I3693 VDD_DEC pfet_05v0 L=0.5U W=0.36U AS=0.3852P
+ AD=0.0612P PS=2.86U PD=0.7U
* device instance _2393 r180 *1 666.085,778.998 nfet_05v0
XM_2393 n_I3696 n_I3693 n_I3694 VSS nfet_05v0 L=0.6U W=0.365U AS=0.3705P
+ AD=0.0438P PS=2.77U PD=0.605U
* device instance _2394 r180 *1 665.245,778.998 nfet_05v0
XM_2394 VSS n_I3693 n_I3696 VSS nfet_05v0 L=0.6U W=0.365U AS=0.0438P
+ AD=0.282625P PS=0.605U PD=1.87U
* device instance _2395 r180 *1 663.595,778.77 nfet_05v0
XM_2395 n_38 n_I3694 VSS VSS nfet_05v0 L=0.6U W=0.82U AS=0.282625P AD=0.3608P
+ PS=1.87U PD=2.52U
* device instance _2396 r180 *1 670.325,779 nfet_05v0
XM_2396 VSS n_I2081 n_I3692 VSS nfet_05v0 L=0.6U W=0.36U AS=0.333P AD=0.0936P
+ PS=2.57U PD=0.88U
* device instance _2397 r180 *1 669.205,779 nfet_05v0
XM_2397 n_I3695 n_I3692 VSS VSS nfet_05v0 L=0.6U W=0.36U AS=0.0936P AD=0.0432P
+ PS=0.88U PD=0.6U
* device instance _2398 r180 *1 668.365,779 nfet_05v0
XM_2398 n_I3693 n_I3692 n_I3695 VSS nfet_05v0 L=0.6U W=0.36U AS=0.0432P
+ AD=0.369P PS=0.6U PD=2.77U
* device instance _2399 m90 *1 657.735,790.65 pfet_05v0
XM_2399 n_I3705 n_I3700 n_I3701 VDD_DEC pfet_05v0 L=0.5U W=0.36U AS=0.3456P
+ AD=0.0612P PS=2.64U PD=0.7U
* device instance _2400 m90 *1 656.895,790.65 pfet_05v0
XM_2400 n_I3705 n_I3700 VDD_DEC VDD_DEC pfet_05v0 L=0.5U W=0.36U AS=0.379P
+ AD=0.0612P PS=2.37U PD=0.7U
* device instance _2401 m90 *1 655.245,790.33 pfet_05v0
XM_2401 n_39 n_I3701 VDD_DEC VDD_DEC pfet_05v0 L=0.5U W=1.22U AS=0.379P
+ AD=0.5368P PS=2.37U PD=3.32U
* device instance _2402 m90 *1 661.975,790.76 pfet_05v0
XM_2402 VDD_DEC n_I2168 n_I3699 VDD_DEC pfet_05v0 L=0.5U W=0.36U AS=0.3852P
+ AD=0.1116P PS=2.86U PD=0.98U
* device instance _2403 m90 *1 660.855,790.76 pfet_05v0
XM_2403 n_I3704 n_I3699 VDD_DEC VDD_DEC pfet_05v0 L=0.5U W=0.36U AS=0.1116P
+ AD=0.0612P PS=0.98U PD=0.7U
* device instance _2404 m90 *1 660.015,790.76 pfet_05v0
XM_2404 n_I3704 n_I3699 n_I3700 VDD_DEC pfet_05v0 L=0.5U W=0.36U AS=0.3852P
+ AD=0.0612P PS=2.86U PD=0.7U
* device instance _2405 m90 *1 657.685,787.882 nfet_05v0
XM_2405 n_I3703 n_I3700 n_I3701 VSS nfet_05v0 L=0.6U W=0.365U AS=0.3705P
+ AD=0.0438P PS=2.77U PD=0.605U
* device instance _2406 m90 *1 656.845,787.882 nfet_05v0
XM_2406 VSS n_I3700 n_I3703 VSS nfet_05v0 L=0.6U W=0.365U AS=0.0438P
+ AD=0.282625P PS=0.605U PD=1.87U
* device instance _2407 m90 *1 655.195,788.11 nfet_05v0
XM_2407 n_39 n_I3701 VSS VSS nfet_05v0 L=0.6U W=0.82U AS=0.282625P AD=0.3608P
+ PS=1.87U PD=2.52U
* device instance _2408 m90 *1 661.925,787.88 nfet_05v0
XM_2408 VSS n_I2168 n_I3699 VSS nfet_05v0 L=0.6U W=0.36U AS=0.333P AD=0.0936P
+ PS=2.57U PD=0.88U
* device instance _2409 m90 *1 660.805,787.88 nfet_05v0
XM_2409 n_I3702 n_I3699 VSS VSS nfet_05v0 L=0.6U W=0.36U AS=0.0936P AD=0.0432P
+ PS=0.88U PD=0.6U
* device instance _2410 m90 *1 659.965,787.88 nfet_05v0
XM_2410 n_I3700 n_I3699 n_I3702 VSS nfet_05v0 L=0.6U W=0.36U AS=0.0432P
+ AD=0.369P PS=0.6U PD=2.77U
* device instance _2411 r180 *1 657.175,791.91 pfet_05v0
XM_2411 n_I3712 n_I3707 n_I3708 VDD_DEC pfet_05v0 L=0.5U W=0.36U AS=0.3456P
+ AD=0.0612P PS=2.64U PD=0.7U
* device instance _2412 r180 *1 656.335,791.91 pfet_05v0
XM_2412 n_I3712 n_I3707 VDD_DEC VDD_DEC pfet_05v0 L=0.5U W=0.36U AS=0.379P
+ AD=0.0612P PS=2.37U PD=0.7U
* device instance _2413 r180 *1 654.685,792.23 pfet_05v0
XM_2413 n_40 n_I3708 VDD_DEC VDD_DEC pfet_05v0 L=0.5U W=1.22U AS=0.379P
+ AD=0.5368P PS=2.37U PD=3.32U
* device instance _2414 r180 *1 661.415,791.8 pfet_05v0
XM_2414 VDD_DEC n_I2343 n_I3706 VDD_DEC pfet_05v0 L=0.5U W=0.36U AS=0.3852P
+ AD=0.1116P PS=2.86U PD=0.98U
* device instance _2415 r180 *1 660.295,791.8 pfet_05v0
XM_2415 n_I3711 n_I3706 VDD_DEC VDD_DEC pfet_05v0 L=0.5U W=0.36U AS=0.1116P
+ AD=0.0612P PS=0.98U PD=0.7U
* device instance _2416 r180 *1 659.455,791.8 pfet_05v0
XM_2416 n_I3711 n_I3706 n_I3707 VDD_DEC pfet_05v0 L=0.5U W=0.36U AS=0.3852P
+ AD=0.0612P PS=2.86U PD=0.7U
* device instance _2417 r180 *1 657.125,794.678 nfet_05v0
XM_2417 n_I3710 n_I3707 n_I3708 VSS nfet_05v0 L=0.6U W=0.365U AS=0.3705P
+ AD=0.0438P PS=2.77U PD=0.605U
* device instance _2418 r180 *1 656.285,794.678 nfet_05v0
XM_2418 VSS n_I3707 n_I3710 VSS nfet_05v0 L=0.6U W=0.365U AS=0.0438P
+ AD=0.282625P PS=0.605U PD=1.87U
* device instance _2419 r180 *1 654.635,794.45 nfet_05v0
XM_2419 n_40 n_I3708 VSS VSS nfet_05v0 L=0.6U W=0.82U AS=0.282625P AD=0.3608P
+ PS=1.87U PD=2.52U
* device instance _2420 r180 *1 661.365,794.68 nfet_05v0
XM_2420 VSS n_I2343 n_I3706 VSS nfet_05v0 L=0.6U W=0.36U AS=0.333P AD=0.0936P
+ PS=2.57U PD=0.88U
* device instance _2421 r180 *1 660.245,794.68 nfet_05v0
XM_2421 n_I3709 n_I3706 VSS VSS nfet_05v0 L=0.6U W=0.36U AS=0.0936P AD=0.0432P
+ PS=0.88U PD=0.6U
* device instance _2422 r180 *1 659.405,794.68 nfet_05v0
XM_2422 n_I3707 n_I3706 n_I3709 VSS nfet_05v0 L=0.6U W=0.36U AS=0.0432P
+ AD=0.369P PS=0.6U PD=2.77U
* device instance _2423 r180 *1 637.575,815.43 pfet_05v0
XM_2423 n_I3719 n_I3714 n_I3715 VDD_DEC pfet_05v0 L=0.5U W=0.36U AS=0.3456P
+ AD=0.0612P PS=2.64U PD=0.7U
* device instance _2424 r180 *1 636.735,815.43 pfet_05v0
XM_2424 n_I3719 n_I3714 VDD_DEC VDD_DEC pfet_05v0 L=0.5U W=0.36U AS=0.379P
+ AD=0.0612P PS=2.37U PD=0.7U
* device instance _2425 r180 *1 635.085,815.75 pfet_05v0
XM_2425 n_6 n_I3715 VDD_DEC VDD_DEC pfet_05v0 L=0.5U W=1.22U AS=0.379P
+ AD=0.5368P PS=2.37U PD=3.32U
* device instance _2426 r180 *1 641.815,815.32 pfet_05v0
XM_2426 VDD_DEC n_I2408 n_I3713 VDD_DEC pfet_05v0 L=0.5U W=0.36U AS=0.3852P
+ AD=0.1116P PS=2.86U PD=0.98U
* device instance _2427 r180 *1 640.695,815.32 pfet_05v0
XM_2427 n_I3718 n_I3713 VDD_DEC VDD_DEC pfet_05v0 L=0.5U W=0.36U AS=0.1116P
+ AD=0.0612P PS=0.98U PD=0.7U
* device instance _2428 r180 *1 639.855,815.32 pfet_05v0
XM_2428 n_I3718 n_I3713 n_I3714 VDD_DEC pfet_05v0 L=0.5U W=0.36U AS=0.3852P
+ AD=0.0612P PS=2.86U PD=0.7U
* device instance _2429 r180 *1 637.525,818.198 nfet_05v0
XM_2429 n_I3717 n_I3714 n_I3715 VSS nfet_05v0 L=0.6U W=0.365U AS=0.3705P
+ AD=0.0438P PS=2.77U PD=0.605U
* device instance _2430 r180 *1 636.685,818.198 nfet_05v0
XM_2430 VSS n_I3714 n_I3717 VSS nfet_05v0 L=0.6U W=0.365U AS=0.0438P
+ AD=0.282625P PS=0.605U PD=1.87U
* device instance _2431 r180 *1 635.035,817.97 nfet_05v0
XM_2431 n_6 n_I3715 VSS VSS nfet_05v0 L=0.6U W=0.82U AS=0.282625P AD=0.3608P
+ PS=1.87U PD=2.52U
* device instance _2432 r180 *1 641.765,818.2 nfet_05v0
XM_2432 VSS n_I2408 n_I3713 VSS nfet_05v0 L=0.6U W=0.36U AS=0.333P AD=0.0936P
+ PS=2.57U PD=0.88U
* device instance _2433 r180 *1 640.645,818.2 nfet_05v0
XM_2433 n_I3716 n_I3713 VSS VSS nfet_05v0 L=0.6U W=0.36U AS=0.0936P AD=0.0432P
+ PS=0.88U PD=0.6U
* device instance _2434 r180 *1 639.805,818.2 nfet_05v0
XM_2434 n_I3714 n_I3713 n_I3716 VSS nfet_05v0 L=0.6U W=0.36U AS=0.0432P
+ AD=0.369P PS=0.6U PD=2.77U
* device instance _2435 r180 *1 657.735,799.75 pfet_05v0
XM_2435 n_I3726 n_I3721 n_I3722 VDD_DEC pfet_05v0 L=0.5U W=0.36U AS=0.3456P
+ AD=0.0612P PS=2.64U PD=0.7U
* device instance _2436 r180 *1 656.895,799.75 pfet_05v0
XM_2436 n_I3726 n_I3721 VDD_DEC VDD_DEC pfet_05v0 L=0.5U W=0.36U AS=0.379P
+ AD=0.0612P PS=2.37U PD=0.7U
* device instance _2437 r180 *1 655.245,800.07 pfet_05v0
XM_2437 n_7 n_I3722 VDD_DEC VDD_DEC pfet_05v0 L=0.5U W=1.22U AS=0.379P
+ AD=0.5368P PS=2.37U PD=3.32U
* device instance _2438 r180 *1 661.975,799.64 pfet_05v0
XM_2438 VDD_DEC n_I2080 n_I3720 VDD_DEC pfet_05v0 L=0.5U W=0.36U AS=0.3852P
+ AD=0.1116P PS=2.86U PD=0.98U
* device instance _2439 r180 *1 660.855,799.64 pfet_05v0
XM_2439 n_I3725 n_I3720 VDD_DEC VDD_DEC pfet_05v0 L=0.5U W=0.36U AS=0.1116P
+ AD=0.0612P PS=0.98U PD=0.7U
* device instance _2440 r180 *1 660.015,799.64 pfet_05v0
XM_2440 n_I3725 n_I3720 n_I3721 VDD_DEC pfet_05v0 L=0.5U W=0.36U AS=0.3852P
+ AD=0.0612P PS=2.86U PD=0.7U
* device instance _2441 r180 *1 657.685,802.518 nfet_05v0
XM_2441 n_I3724 n_I3721 n_I3722 VSS nfet_05v0 L=0.6U W=0.365U AS=0.3705P
+ AD=0.0438P PS=2.77U PD=0.605U
* device instance _2442 r180 *1 656.845,802.518 nfet_05v0
XM_2442 VSS n_I3721 n_I3724 VSS nfet_05v0 L=0.6U W=0.365U AS=0.0438P
+ AD=0.282625P PS=0.605U PD=1.87U
* device instance _2443 r180 *1 655.195,802.29 nfet_05v0
XM_2443 n_7 n_I3722 VSS VSS nfet_05v0 L=0.6U W=0.82U AS=0.282625P AD=0.3608P
+ PS=1.87U PD=2.52U
* device instance _2444 r180 *1 661.925,802.52 nfet_05v0
XM_2444 VSS n_I2080 n_I3720 VSS nfet_05v0 L=0.6U W=0.36U AS=0.333P AD=0.0936P
+ PS=2.57U PD=0.88U
* device instance _2445 r180 *1 660.805,802.52 nfet_05v0
XM_2445 n_I3723 n_I3720 VSS VSS nfet_05v0 L=0.6U W=0.36U AS=0.0936P AD=0.0432P
+ PS=0.88U PD=0.6U
* device instance _2446 r180 *1 659.965,802.52 nfet_05v0
XM_2446 n_I3721 n_I3720 n_I3723 VSS nfet_05v0 L=0.6U W=0.36U AS=0.0432P
+ AD=0.369P PS=0.6U PD=2.77U
* device instance _2447 r180 *1 666.135,791.91 pfet_05v0
XM_2447 n_I3733 n_I3728 n_I3729 VDD_DEC pfet_05v0 L=0.5U W=0.36U AS=0.3456P
+ AD=0.0612P PS=2.64U PD=0.7U
* device instance _2448 r180 *1 665.295,791.91 pfet_05v0
XM_2448 n_I3733 n_I3728 VDD_DEC VDD_DEC pfet_05v0 L=0.5U W=0.36U AS=0.379P
+ AD=0.0612P PS=2.37U PD=0.7U
* device instance _2449 r180 *1 663.645,792.23 pfet_05v0
XM_2449 n_8 n_I3729 VDD_DEC VDD_DEC pfet_05v0 L=0.5U W=1.22U AS=0.379P
+ AD=0.5368P PS=2.37U PD=3.32U
* device instance _2450 r180 *1 670.375,791.8 pfet_05v0
XM_2450 VDD_DEC n_I2215 n_I3727 VDD_DEC pfet_05v0 L=0.5U W=0.36U AS=0.3852P
+ AD=0.1116P PS=2.86U PD=0.98U
* device instance _2451 r180 *1 669.255,791.8 pfet_05v0
XM_2451 n_I3732 n_I3727 VDD_DEC VDD_DEC pfet_05v0 L=0.5U W=0.36U AS=0.1116P
+ AD=0.0612P PS=0.98U PD=0.7U
* device instance _2452 r180 *1 668.415,791.8 pfet_05v0
XM_2452 n_I3732 n_I3727 n_I3728 VDD_DEC pfet_05v0 L=0.5U W=0.36U AS=0.3852P
+ AD=0.0612P PS=2.86U PD=0.7U
* device instance _2453 r180 *1 666.085,794.678 nfet_05v0
XM_2453 n_I3731 n_I3728 n_I3729 VSS nfet_05v0 L=0.6U W=0.365U AS=0.3705P
+ AD=0.0438P PS=2.77U PD=0.605U
* device instance _2454 r180 *1 665.245,794.678 nfet_05v0
XM_2454 VSS n_I3728 n_I3731 VSS nfet_05v0 L=0.6U W=0.365U AS=0.0438P
+ AD=0.282625P PS=0.605U PD=1.87U
* device instance _2455 r180 *1 663.595,794.45 nfet_05v0
XM_2455 n_8 n_I3729 VSS VSS nfet_05v0 L=0.6U W=0.82U AS=0.282625P AD=0.3608P
+ PS=1.87U PD=2.52U
* device instance _2456 r180 *1 670.325,794.68 nfet_05v0
XM_2456 VSS n_I2215 n_I3727 VSS nfet_05v0 L=0.6U W=0.36U AS=0.333P AD=0.0936P
+ PS=2.57U PD=0.88U
* device instance _2457 r180 *1 669.205,794.68 nfet_05v0
XM_2457 n_I3730 n_I3727 VSS VSS nfet_05v0 L=0.6U W=0.36U AS=0.0936P AD=0.0432P
+ PS=0.88U PD=0.6U
* device instance _2458 r180 *1 668.365,794.68 nfet_05v0
XM_2458 n_I3728 n_I3727 n_I3730 VSS nfet_05v0 L=0.6U W=0.36U AS=0.0432P
+ AD=0.369P PS=0.6U PD=2.77U
* device instance _2459 r180 *1 648.215,815.43 pfet_05v0
XM_2459 n_I3740 n_I3735 n_I3736 VDD_DEC pfet_05v0 L=0.5U W=0.36U AS=0.3456P
+ AD=0.0612P PS=2.64U PD=0.7U
* device instance _2460 r180 *1 647.375,815.43 pfet_05v0
XM_2460 n_I3740 n_I3735 VDD_DEC VDD_DEC pfet_05v0 L=0.5U W=0.36U AS=0.379P
+ AD=0.0612P PS=2.37U PD=0.7U
* device instance _2461 r180 *1 645.725,815.75 pfet_05v0
XM_2461 n_10 n_I3736 VDD_DEC VDD_DEC pfet_05v0 L=0.5U W=1.22U AS=0.379P
+ AD=0.5368P PS=2.37U PD=3.32U
* device instance _2462 r180 *1 652.455,815.32 pfet_05v0
XM_2462 VDD_DEC n_I2417 n_I3734 VDD_DEC pfet_05v0 L=0.5U W=0.36U AS=0.3852P
+ AD=0.1116P PS=2.86U PD=0.98U
* device instance _2463 r180 *1 651.335,815.32 pfet_05v0
XM_2463 n_I3739 n_I3734 VDD_DEC VDD_DEC pfet_05v0 L=0.5U W=0.36U AS=0.1116P
+ AD=0.0612P PS=0.98U PD=0.7U
* device instance _2464 r180 *1 650.495,815.32 pfet_05v0
XM_2464 n_I3739 n_I3734 n_I3735 VDD_DEC pfet_05v0 L=0.5U W=0.36U AS=0.3852P
+ AD=0.0612P PS=2.86U PD=0.7U
* device instance _2465 r180 *1 648.165,818.198 nfet_05v0
XM_2465 n_I3738 n_I3735 n_I3736 VSS nfet_05v0 L=0.6U W=0.365U AS=0.3705P
+ AD=0.0438P PS=2.77U PD=0.605U
* device instance _2466 r180 *1 647.325,818.198 nfet_05v0
XM_2466 VSS n_I3735 n_I3738 VSS nfet_05v0 L=0.6U W=0.365U AS=0.0438P
+ AD=0.282625P PS=0.605U PD=1.87U
* device instance _2467 r180 *1 645.675,817.97 nfet_05v0
XM_2467 n_10 n_I3736 VSS VSS nfet_05v0 L=0.6U W=0.82U AS=0.282625P AD=0.3608P
+ PS=1.87U PD=2.52U
* device instance _2468 r180 *1 652.405,818.2 nfet_05v0
XM_2468 VSS n_I2417 n_I3734 VSS nfet_05v0 L=0.6U W=0.36U AS=0.333P AD=0.0936P
+ PS=2.57U PD=0.88U
* device instance _2469 r180 *1 651.285,818.2 nfet_05v0
XM_2469 n_I3737 n_I3734 VSS VSS nfet_05v0 L=0.6U W=0.36U AS=0.0936P AD=0.0432P
+ PS=0.88U PD=0.6U
* device instance _2470 r180 *1 650.445,818.2 nfet_05v0
XM_2470 n_I3735 n_I3734 n_I3737 VSS nfet_05v0 L=0.6U W=0.36U AS=0.0432P
+ AD=0.369P PS=0.6U PD=2.77U
* device instance _2471 r180 *1 666.695,799.75 pfet_05v0
XM_2471 n_I3747 n_I3742 n_I3743 VDD_DEC pfet_05v0 L=0.5U W=0.36U AS=0.3456P
+ AD=0.0612P PS=2.64U PD=0.7U
* device instance _2472 r180 *1 665.855,799.75 pfet_05v0
XM_2472 n_I3747 n_I3742 VDD_DEC VDD_DEC pfet_05v0 L=0.5U W=0.36U AS=0.379P
+ AD=0.0612P PS=2.37U PD=0.7U
* device instance _2473 r180 *1 664.205,800.07 pfet_05v0
XM_2473 n_11 n_I3743 VDD_DEC VDD_DEC pfet_05v0 L=0.5U W=1.22U AS=0.379P
+ AD=0.5368P PS=2.37U PD=3.32U
* device instance _2474 r180 *1 670.935,799.64 pfet_05v0
XM_2474 VDD_DEC n_I2425 n_I3741 VDD_DEC pfet_05v0 L=0.5U W=0.36U AS=0.3852P
+ AD=0.1116P PS=2.86U PD=0.98U
* device instance _2475 r180 *1 669.815,799.64 pfet_05v0
XM_2475 n_I3746 n_I3741 VDD_DEC VDD_DEC pfet_05v0 L=0.5U W=0.36U AS=0.1116P
+ AD=0.0612P PS=0.98U PD=0.7U
* device instance _2476 r180 *1 668.975,799.64 pfet_05v0
XM_2476 n_I3746 n_I3741 n_I3742 VDD_DEC pfet_05v0 L=0.5U W=0.36U AS=0.3852P
+ AD=0.0612P PS=2.86U PD=0.7U
* device instance _2477 r180 *1 666.645,802.518 nfet_05v0
XM_2477 n_I3745 n_I3742 n_I3743 VSS nfet_05v0 L=0.6U W=0.365U AS=0.3705P
+ AD=0.0438P PS=2.77U PD=0.605U
* device instance _2478 r180 *1 665.805,802.518 nfet_05v0
XM_2478 VSS n_I3742 n_I3745 VSS nfet_05v0 L=0.6U W=0.365U AS=0.0438P
+ AD=0.282625P PS=0.605U PD=1.87U
* device instance _2479 r180 *1 664.155,802.29 nfet_05v0
XM_2479 n_11 n_I3743 VSS VSS nfet_05v0 L=0.6U W=0.82U AS=0.282625P AD=0.3608P
+ PS=1.87U PD=2.52U
* device instance _2480 r180 *1 670.885,802.52 nfet_05v0
XM_2480 VSS n_I2425 n_I3741 VSS nfet_05v0 L=0.6U W=0.36U AS=0.333P AD=0.0936P
+ PS=2.57U PD=0.88U
* device instance _2481 r180 *1 669.765,802.52 nfet_05v0
XM_2481 n_I3744 n_I3741 VSS VSS nfet_05v0 L=0.6U W=0.36U AS=0.0936P AD=0.0432P
+ PS=0.88U PD=0.6U
* device instance _2482 r180 *1 668.925,802.52 nfet_05v0
XM_2482 n_I3742 n_I3741 n_I3744 VSS nfet_05v0 L=0.6U W=0.36U AS=0.0432P
+ AD=0.369P PS=0.6U PD=2.77U
* device instance _2483 r180 *1 662.215,807.59 pfet_05v0
XM_2483 n_I3754 n_I3749 n_I3750 VDD_DEC pfet_05v0 L=0.5U W=0.36U AS=0.3456P
+ AD=0.0612P PS=2.64U PD=0.7U
* device instance _2484 r180 *1 661.375,807.59 pfet_05v0
XM_2484 n_I3754 n_I3749 VDD_DEC VDD_DEC pfet_05v0 L=0.5U W=0.36U AS=0.379P
+ AD=0.0612P PS=2.37U PD=0.7U
* device instance _2485 r180 *1 659.725,807.91 pfet_05v0
XM_2485 n_12 n_I3750 VDD_DEC VDD_DEC pfet_05v0 L=0.5U W=1.22U AS=0.379P
+ AD=0.5368P PS=2.37U PD=3.32U
* device instance _2486 r180 *1 666.455,807.48 pfet_05v0
XM_2486 VDD_DEC n_I2328 n_I3748 VDD_DEC pfet_05v0 L=0.5U W=0.36U AS=0.3852P
+ AD=0.1116P PS=2.86U PD=0.98U
* device instance _2487 r180 *1 665.335,807.48 pfet_05v0
XM_2487 n_I3753 n_I3748 VDD_DEC VDD_DEC pfet_05v0 L=0.5U W=0.36U AS=0.1116P
+ AD=0.0612P PS=0.98U PD=0.7U
* device instance _2488 r180 *1 664.495,807.48 pfet_05v0
XM_2488 n_I3753 n_I3748 n_I3749 VDD_DEC pfet_05v0 L=0.5U W=0.36U AS=0.3852P
+ AD=0.0612P PS=2.86U PD=0.7U
* device instance _2489 r180 *1 662.165,810.358 nfet_05v0
XM_2489 n_I3752 n_I3749 n_I3750 VSS nfet_05v0 L=0.6U W=0.365U AS=0.3705P
+ AD=0.0438P PS=2.77U PD=0.605U
* device instance _2490 r180 *1 661.325,810.358 nfet_05v0
XM_2490 VSS n_I3749 n_I3752 VSS nfet_05v0 L=0.6U W=0.365U AS=0.0438P
+ AD=0.282625P PS=0.605U PD=1.87U
* device instance _2491 r180 *1 659.675,810.13 nfet_05v0
XM_2491 n_12 n_I3750 VSS VSS nfet_05v0 L=0.6U W=0.82U AS=0.282625P AD=0.3608P
+ PS=1.87U PD=2.52U
* device instance _2492 r180 *1 666.405,810.36 nfet_05v0
XM_2492 VSS n_I2328 n_I3748 VSS nfet_05v0 L=0.6U W=0.36U AS=0.333P AD=0.0936P
+ PS=2.57U PD=0.88U
* device instance _2493 r180 *1 665.285,810.36 nfet_05v0
XM_2493 n_I3751 n_I3748 VSS VSS nfet_05v0 L=0.6U W=0.36U AS=0.0936P AD=0.0432P
+ PS=0.88U PD=0.6U
* device instance _2494 r180 *1 664.445,810.36 nfet_05v0
XM_2494 n_I3749 n_I3748 n_I3751 VSS nfet_05v0 L=0.6U W=0.36U AS=0.0432P
+ AD=0.369P PS=0.6U PD=2.77U
* device instance _2495 m90 *1 651.015,822.01 pfet_05v0
XM_2495 n_I3761 n_I3756 n_I3757 VDD_DEC pfet_05v0 L=0.5U W=0.36U AS=0.3456P
+ AD=0.0612P PS=2.64U PD=0.7U
* device instance _2496 m90 *1 650.175,822.01 pfet_05v0
XM_2496 n_I3761 n_I3756 VDD_DEC VDD_DEC pfet_05v0 L=0.5U W=0.36U AS=0.379P
+ AD=0.0612P PS=2.37U PD=0.7U
* device instance _2497 m90 *1 648.525,821.69 pfet_05v0
XM_2497 n_13 n_I3757 VDD_DEC VDD_DEC pfet_05v0 L=0.5U W=1.22U AS=0.379P
+ AD=0.5368P PS=2.37U PD=3.32U
* device instance _2498 m90 *1 655.255,822.12 pfet_05v0
XM_2498 VDD_DEC n_I2258 n_I3755 VDD_DEC pfet_05v0 L=0.5U W=0.36U AS=0.3852P
+ AD=0.1116P PS=2.86U PD=0.98U
* device instance _2499 m90 *1 654.135,822.12 pfet_05v0
XM_2499 n_I3760 n_I3755 VDD_DEC VDD_DEC pfet_05v0 L=0.5U W=0.36U AS=0.1116P
+ AD=0.0612P PS=0.98U PD=0.7U
* device instance _2500 m90 *1 653.295,822.12 pfet_05v0
XM_2500 n_I3760 n_I3755 n_I3756 VDD_DEC pfet_05v0 L=0.5U W=0.36U AS=0.3852P
+ AD=0.0612P PS=2.86U PD=0.7U
* device instance _2501 m90 *1 650.965,819.242 nfet_05v0
XM_2501 n_I3759 n_I3756 n_I3757 VSS nfet_05v0 L=0.6U W=0.365U AS=0.3705P
+ AD=0.0438P PS=2.77U PD=0.605U
* device instance _2502 m90 *1 650.125,819.242 nfet_05v0
XM_2502 VSS n_I3756 n_I3759 VSS nfet_05v0 L=0.6U W=0.365U AS=0.0438P
+ AD=0.282625P PS=0.605U PD=1.87U
* device instance _2503 m90 *1 648.475,819.47 nfet_05v0
XM_2503 n_13 n_I3757 VSS VSS nfet_05v0 L=0.6U W=0.82U AS=0.282625P AD=0.3608P
+ PS=1.87U PD=2.52U
* device instance _2504 m90 *1 655.205,819.24 nfet_05v0
XM_2504 VSS n_I2258 n_I3755 VSS nfet_05v0 L=0.6U W=0.36U AS=0.333P AD=0.0936P
+ PS=2.57U PD=0.88U
* device instance _2505 m90 *1 654.085,819.24 nfet_05v0
XM_2505 n_I3758 n_I3755 VSS VSS nfet_05v0 L=0.6U W=0.36U AS=0.0936P AD=0.0432P
+ PS=0.88U PD=0.6U
* device instance _2506 m90 *1 653.245,819.24 nfet_05v0
XM_2506 n_I3756 n_I3755 n_I3758 VSS nfet_05v0 L=0.6U W=0.36U AS=0.0432P
+ AD=0.369P PS=0.6U PD=2.77U
* device instance _2507 r180 *1 648.215,823.27 pfet_05v0
XM_2507 n_I3768 n_I3763 n_I3764 VDD_DEC pfet_05v0 L=0.5U W=0.36U AS=0.3456P
+ AD=0.0612P PS=2.64U PD=0.7U
* device instance _2508 r180 *1 647.375,823.27 pfet_05v0
XM_2508 n_I3768 n_I3763 VDD_DEC VDD_DEC pfet_05v0 L=0.5U W=0.36U AS=0.379P
+ AD=0.0612P PS=2.37U PD=0.7U
* device instance _2509 r180 *1 645.725,823.59 pfet_05v0
XM_2509 n_14 n_I3764 VDD_DEC VDD_DEC pfet_05v0 L=0.5U W=1.22U AS=0.379P
+ AD=0.5368P PS=2.37U PD=3.32U
* device instance _2510 r180 *1 652.455,823.16 pfet_05v0
XM_2510 VDD_DEC n_I2326 n_I3762 VDD_DEC pfet_05v0 L=0.5U W=0.36U AS=0.3852P
+ AD=0.1116P PS=2.86U PD=0.98U
* device instance _2511 r180 *1 651.335,823.16 pfet_05v0
XM_2511 n_I3767 n_I3762 VDD_DEC VDD_DEC pfet_05v0 L=0.5U W=0.36U AS=0.1116P
+ AD=0.0612P PS=0.98U PD=0.7U
* device instance _2512 r180 *1 650.495,823.16 pfet_05v0
XM_2512 n_I3767 n_I3762 n_I3763 VDD_DEC pfet_05v0 L=0.5U W=0.36U AS=0.3852P
+ AD=0.0612P PS=2.86U PD=0.7U
* device instance _2513 r180 *1 648.165,826.038 nfet_05v0
XM_2513 n_I3766 n_I3763 n_I3764 VSS nfet_05v0 L=0.6U W=0.365U AS=0.3705P
+ AD=0.0438P PS=2.77U PD=0.605U
* device instance _2514 r180 *1 647.325,826.038 nfet_05v0
XM_2514 VSS n_I3763 n_I3766 VSS nfet_05v0 L=0.6U W=0.365U AS=0.0438P
+ AD=0.282625P PS=0.605U PD=1.87U
* device instance _2515 r180 *1 645.675,825.81 nfet_05v0
XM_2515 n_14 n_I3764 VSS VSS nfet_05v0 L=0.6U W=0.82U AS=0.282625P AD=0.3608P
+ PS=1.87U PD=2.52U
* device instance _2516 r180 *1 652.405,826.04 nfet_05v0
XM_2516 VSS n_I2326 n_I3762 VSS nfet_05v0 L=0.6U W=0.36U AS=0.333P AD=0.0936P
+ PS=2.57U PD=0.88U
* device instance _2517 r180 *1 651.285,826.04 nfet_05v0
XM_2517 n_I3765 n_I3762 VSS VSS nfet_05v0 L=0.6U W=0.36U AS=0.0936P AD=0.0432P
+ PS=0.88U PD=0.6U
* device instance _2518 r180 *1 650.445,826.04 nfet_05v0
XM_2518 n_I3763 n_I3762 n_I3765 VSS nfet_05v0 L=0.6U W=0.36U AS=0.0432P
+ AD=0.369P PS=0.6U PD=2.77U
* device instance _2519 r180 *1 657.175,815.43 pfet_05v0
XM_2519 n_I3775 n_I3770 n_I3771 VDD_DEC pfet_05v0 L=0.5U W=0.36U AS=0.3456P
+ AD=0.0612P PS=2.64U PD=0.7U
* device instance _2520 r180 *1 656.335,815.43 pfet_05v0
XM_2520 n_I3775 n_I3770 VDD_DEC VDD_DEC pfet_05v0 L=0.5U W=0.36U AS=0.379P
+ AD=0.0612P PS=2.37U PD=0.7U
* device instance _2521 r180 *1 654.685,815.75 pfet_05v0
XM_2521 n_15 n_I3771 VDD_DEC VDD_DEC pfet_05v0 L=0.5U W=1.22U AS=0.379P
+ AD=0.5368P PS=2.37U PD=3.32U
* device instance _2522 r180 *1 661.415,815.32 pfet_05v0
XM_2522 VDD_DEC n_I2386 n_I3769 VDD_DEC pfet_05v0 L=0.5U W=0.36U AS=0.3852P
+ AD=0.1116P PS=2.86U PD=0.98U
* device instance _2523 r180 *1 660.295,815.32 pfet_05v0
XM_2523 n_I3774 n_I3769 VDD_DEC VDD_DEC pfet_05v0 L=0.5U W=0.36U AS=0.1116P
+ AD=0.0612P PS=0.98U PD=0.7U
* device instance _2524 r180 *1 659.455,815.32 pfet_05v0
XM_2524 n_I3774 n_I3769 n_I3770 VDD_DEC pfet_05v0 L=0.5U W=0.36U AS=0.3852P
+ AD=0.0612P PS=2.86U PD=0.7U
* device instance _2525 r180 *1 657.125,818.198 nfet_05v0
XM_2525 n_I3773 n_I3770 n_I3771 VSS nfet_05v0 L=0.6U W=0.365U AS=0.3705P
+ AD=0.0438P PS=2.77U PD=0.605U
* device instance _2526 r180 *1 656.285,818.198 nfet_05v0
XM_2526 VSS n_I3770 n_I3773 VSS nfet_05v0 L=0.6U W=0.365U AS=0.0438P
+ AD=0.282625P PS=0.605U PD=1.87U
* device instance _2527 r180 *1 654.635,817.97 nfet_05v0
XM_2527 n_15 n_I3771 VSS VSS nfet_05v0 L=0.6U W=0.82U AS=0.282625P AD=0.3608P
+ PS=1.87U PD=2.52U
* device instance _2528 r180 *1 661.365,818.2 nfet_05v0
XM_2528 VSS n_I2386 n_I3769 VSS nfet_05v0 L=0.6U W=0.36U AS=0.333P AD=0.0936P
+ PS=2.57U PD=0.88U
* device instance _2529 r180 *1 660.245,818.2 nfet_05v0
XM_2529 n_I3772 n_I3769 VSS VSS nfet_05v0 L=0.6U W=0.36U AS=0.0936P AD=0.0432P
+ PS=0.88U PD=0.6U
* device instance _2530 r180 *1 659.405,818.2 nfet_05v0
XM_2530 n_I3770 n_I3769 n_I3772 VSS nfet_05v0 L=0.6U W=0.36U AS=0.0432P
+ AD=0.369P PS=0.6U PD=2.77U
* device instance _2531 m90 *1 648.775,829.85 pfet_05v0
XM_2531 n_I3782 n_I3777 n_I3778 VDD_DEC pfet_05v0 L=0.5U W=0.36U AS=0.3456P
+ AD=0.0612P PS=2.64U PD=0.7U
* device instance _2532 m90 *1 647.935,829.85 pfet_05v0
XM_2532 n_I3782 n_I3777 VDD_DEC VDD_DEC pfet_05v0 L=0.5U W=0.36U AS=0.379P
+ AD=0.0612P PS=2.37U PD=0.7U
* device instance _2533 m90 *1 646.285,829.53 pfet_05v0
XM_2533 n_16 n_I3778 VDD_DEC VDD_DEC pfet_05v0 L=0.5U W=1.22U AS=0.379P
+ AD=0.5368P PS=2.37U PD=3.32U
* device instance _2534 m90 *1 653.015,829.96 pfet_05v0
XM_2534 VDD_DEC n_I2289 n_I3776 VDD_DEC pfet_05v0 L=0.5U W=0.36U AS=0.3852P
+ AD=0.1116P PS=2.86U PD=0.98U
* device instance _2535 m90 *1 651.895,829.96 pfet_05v0
XM_2535 n_I3781 n_I3776 VDD_DEC VDD_DEC pfet_05v0 L=0.5U W=0.36U AS=0.1116P
+ AD=0.0612P PS=0.98U PD=0.7U
* device instance _2536 m90 *1 651.055,829.96 pfet_05v0
XM_2536 n_I3781 n_I3776 n_I3777 VDD_DEC pfet_05v0 L=0.5U W=0.36U AS=0.3852P
+ AD=0.0612P PS=2.86U PD=0.7U
* device instance _2537 m90 *1 648.725,827.082 nfet_05v0
XM_2537 n_I3780 n_I3777 n_I3778 VSS nfet_05v0 L=0.6U W=0.365U AS=0.3705P
+ AD=0.0438P PS=2.77U PD=0.605U
* device instance _2538 m90 *1 647.885,827.082 nfet_05v0
XM_2538 VSS n_I3777 n_I3780 VSS nfet_05v0 L=0.6U W=0.365U AS=0.0438P
+ AD=0.282625P PS=0.605U PD=1.87U
* device instance _2539 m90 *1 646.235,827.31 nfet_05v0
XM_2539 n_16 n_I3778 VSS VSS nfet_05v0 L=0.6U W=0.82U AS=0.282625P AD=0.3608P
+ PS=1.87U PD=2.52U
* device instance _2540 m90 *1 652.965,827.08 nfet_05v0
XM_2540 VSS n_I2289 n_I3776 VSS nfet_05v0 L=0.6U W=0.36U AS=0.333P AD=0.0936P
+ PS=2.57U PD=0.88U
* device instance _2541 m90 *1 651.845,827.08 nfet_05v0
XM_2541 n_I3779 n_I3776 VSS VSS nfet_05v0 L=0.6U W=0.36U AS=0.0936P AD=0.0432P
+ PS=0.88U PD=0.6U
* device instance _2542 m90 *1 651.005,827.08 nfet_05v0
XM_2542 n_I3777 n_I3776 n_I3779 VSS nfet_05v0 L=0.6U W=0.36U AS=0.0432P
+ AD=0.369P PS=0.6U PD=2.77U
* device instance _2543 r180 *1 652.135,831.11 pfet_05v0
XM_2543 n_I3789 n_I3784 n_I3785 VDD_DEC pfet_05v0 L=0.5U W=0.36U AS=0.3456P
+ AD=0.0612P PS=2.64U PD=0.7U
* device instance _2544 r180 *1 651.295,831.11 pfet_05v0
XM_2544 n_I3789 n_I3784 VDD_DEC VDD_DEC pfet_05v0 L=0.5U W=0.36U AS=0.379P
+ AD=0.0612P PS=2.37U PD=0.7U
* device instance _2545 r180 *1 649.645,831.43 pfet_05v0
XM_2545 n_19 n_I3785 VDD_DEC VDD_DEC pfet_05v0 L=0.5U W=1.22U AS=0.379P
+ AD=0.5368P PS=2.37U PD=3.32U
* device instance _2546 r180 *1 656.375,831 pfet_05v0
XM_2546 VDD_DEC n_I2369 n_I3783 VDD_DEC pfet_05v0 L=0.5U W=0.36U AS=0.3852P
+ AD=0.1116P PS=2.86U PD=0.98U
* device instance _2547 r180 *1 655.255,831 pfet_05v0
XM_2547 n_I3788 n_I3783 VDD_DEC VDD_DEC pfet_05v0 L=0.5U W=0.36U AS=0.1116P
+ AD=0.0612P PS=0.98U PD=0.7U
* device instance _2548 r180 *1 654.415,831 pfet_05v0
XM_2548 n_I3788 n_I3783 n_I3784 VDD_DEC pfet_05v0 L=0.5U W=0.36U AS=0.3852P
+ AD=0.0612P PS=2.86U PD=0.7U
* device instance _2549 r180 *1 652.085,833.878 nfet_05v0
XM_2549 n_I3787 n_I3784 n_I3785 VSS nfet_05v0 L=0.6U W=0.365U AS=0.3705P
+ AD=0.0438P PS=2.77U PD=0.605U
* device instance _2550 r180 *1 651.245,833.878 nfet_05v0
XM_2550 VSS n_I3784 n_I3787 VSS nfet_05v0 L=0.6U W=0.365U AS=0.0438P
+ AD=0.282625P PS=0.605U PD=1.87U
* device instance _2551 r180 *1 649.595,833.65 nfet_05v0
XM_2551 n_19 n_I3785 VSS VSS nfet_05v0 L=0.6U W=0.82U AS=0.282625P AD=0.3608P
+ PS=1.87U PD=2.52U
* device instance _2552 r180 *1 656.325,833.88 nfet_05v0
XM_2552 VSS n_I2369 n_I3783 VSS nfet_05v0 L=0.6U W=0.36U AS=0.333P AD=0.0936P
+ PS=2.57U PD=0.88U
* device instance _2553 r180 *1 655.205,833.88 nfet_05v0
XM_2553 n_I3786 n_I3783 VSS VSS nfet_05v0 L=0.6U W=0.36U AS=0.0936P AD=0.0432P
+ PS=0.88U PD=0.6U
* device instance _2554 r180 *1 654.365,833.88 nfet_05v0
XM_2554 n_I3784 n_I3783 n_I3786 VSS nfet_05v0 L=0.6U W=0.36U AS=0.0432P
+ AD=0.369P PS=0.6U PD=2.77U
* device instance _2555 m90 *1 657.735,829.85 pfet_05v0
XM_2555 n_I3796 n_I3791 n_I3792 VDD_DEC pfet_05v0 L=0.5U W=0.36U AS=0.3456P
+ AD=0.0612P PS=2.64U PD=0.7U
* device instance _2556 m90 *1 656.895,829.85 pfet_05v0
XM_2556 n_I3796 n_I3791 VDD_DEC VDD_DEC pfet_05v0 L=0.5U W=0.36U AS=0.379P
+ AD=0.0612P PS=2.37U PD=0.7U
* device instance _2557 m90 *1 655.245,829.53 pfet_05v0
XM_2557 n_20 n_I3792 VDD_DEC VDD_DEC pfet_05v0 L=0.5U W=1.22U AS=0.379P
+ AD=0.5368P PS=2.37U PD=3.32U
* device instance _2558 m90 *1 661.975,829.96 pfet_05v0
XM_2558 VDD_DEC n_I2259 n_I3790 VDD_DEC pfet_05v0 L=0.5U W=0.36U AS=0.3852P
+ AD=0.1116P PS=2.86U PD=0.98U
* device instance _2559 m90 *1 660.855,829.96 pfet_05v0
XM_2559 n_I3795 n_I3790 VDD_DEC VDD_DEC pfet_05v0 L=0.5U W=0.36U AS=0.1116P
+ AD=0.0612P PS=0.98U PD=0.7U
* device instance _2560 m90 *1 660.015,829.96 pfet_05v0
XM_2560 n_I3795 n_I3790 n_I3791 VDD_DEC pfet_05v0 L=0.5U W=0.36U AS=0.3852P
+ AD=0.0612P PS=2.86U PD=0.7U
* device instance _2561 m90 *1 657.685,827.082 nfet_05v0
XM_2561 n_I3794 n_I3791 n_I3792 VSS nfet_05v0 L=0.6U W=0.365U AS=0.3705P
+ AD=0.0438P PS=2.77U PD=0.605U
* device instance _2562 m90 *1 656.845,827.082 nfet_05v0
XM_2562 VSS n_I3791 n_I3794 VSS nfet_05v0 L=0.6U W=0.365U AS=0.0438P
+ AD=0.282625P PS=0.605U PD=1.87U
* device instance _2563 m90 *1 655.195,827.31 nfet_05v0
XM_2563 n_20 n_I3792 VSS VSS nfet_05v0 L=0.6U W=0.82U AS=0.282625P AD=0.3608P
+ PS=1.87U PD=2.52U
* device instance _2564 m90 *1 661.925,827.08 nfet_05v0
XM_2564 VSS n_I2259 n_I3790 VSS nfet_05v0 L=0.6U W=0.36U AS=0.333P AD=0.0936P
+ PS=2.57U PD=0.88U
* device instance _2565 m90 *1 660.805,827.08 nfet_05v0
XM_2565 n_I3793 n_I3790 VSS VSS nfet_05v0 L=0.6U W=0.36U AS=0.0936P AD=0.0432P
+ PS=0.88U PD=0.6U
* device instance _2566 m90 *1 659.965,827.08 nfet_05v0
XM_2566 n_I3791 n_I3790 n_I3793 VSS nfet_05v0 L=0.6U W=0.36U AS=0.0432P
+ AD=0.369P PS=0.6U PD=2.77U
* device instance _2567 r180 *1 666.135,823.27 pfet_05v0
XM_2567 n_I3803 n_I3798 n_I3799 VDD_DEC pfet_05v0 L=0.5U W=0.36U AS=0.3456P
+ AD=0.0612P PS=2.64U PD=0.7U
* device instance _2568 r180 *1 665.295,823.27 pfet_05v0
XM_2568 n_I3803 n_I3798 VDD_DEC VDD_DEC pfet_05v0 L=0.5U W=0.36U AS=0.379P
+ AD=0.0612P PS=2.37U PD=0.7U
* device instance _2569 r180 *1 663.645,823.59 pfet_05v0
XM_2569 n_21 n_I3799 VDD_DEC VDD_DEC pfet_05v0 L=0.5U W=1.22U AS=0.379P
+ AD=0.5368P PS=2.37U PD=3.32U
* device instance _2570 r180 *1 670.375,823.16 pfet_05v0
XM_2570 VDD_DEC n_I2421 n_I3797 VDD_DEC pfet_05v0 L=0.5U W=0.36U AS=0.3852P
+ AD=0.1116P PS=2.86U PD=0.98U
* device instance _2571 r180 *1 669.255,823.16 pfet_05v0
XM_2571 n_I3802 n_I3797 VDD_DEC VDD_DEC pfet_05v0 L=0.5U W=0.36U AS=0.1116P
+ AD=0.0612P PS=0.98U PD=0.7U
* device instance _2572 r180 *1 668.415,823.16 pfet_05v0
XM_2572 n_I3802 n_I3797 n_I3798 VDD_DEC pfet_05v0 L=0.5U W=0.36U AS=0.3852P
+ AD=0.0612P PS=2.86U PD=0.7U
* device instance _2573 r180 *1 666.085,826.038 nfet_05v0
XM_2573 n_I3801 n_I3798 n_I3799 VSS nfet_05v0 L=0.6U W=0.365U AS=0.3705P
+ AD=0.0438P PS=2.77U PD=0.605U
* device instance _2574 r180 *1 665.245,826.038 nfet_05v0
XM_2574 VSS n_I3798 n_I3801 VSS nfet_05v0 L=0.6U W=0.365U AS=0.0438P
+ AD=0.282625P PS=0.605U PD=1.87U
* device instance _2575 r180 *1 663.595,825.81 nfet_05v0
XM_2575 n_21 n_I3799 VSS VSS nfet_05v0 L=0.6U W=0.82U AS=0.282625P AD=0.3608P
+ PS=1.87U PD=2.52U
* device instance _2576 r180 *1 670.325,826.04 nfet_05v0
XM_2576 VSS n_I2421 n_I3797 VSS nfet_05v0 L=0.6U W=0.36U AS=0.333P AD=0.0936P
+ PS=2.57U PD=0.88U
* device instance _2577 r180 *1 669.205,826.04 nfet_05v0
XM_2577 n_I3800 n_I3797 VSS VSS nfet_05v0 L=0.6U W=0.36U AS=0.0936P AD=0.0432P
+ PS=0.88U PD=0.6U
* device instance _2578 r180 *1 668.365,826.04 nfet_05v0
XM_2578 n_I3798 n_I3797 n_I3800 VSS nfet_05v0 L=0.6U W=0.36U AS=0.0432P
+ AD=0.369P PS=0.6U PD=2.77U
* device instance _2579 r0 *1 493.225,774.97 pfet_05v0
XM_2579 n_I3810 n_I3805 n_I3806 VDD_DEC pfet_05v0 L=0.5U W=0.36U AS=0.3456P
+ AD=0.0612P PS=2.64U PD=0.7U
* device instance _2580 r0 *1 494.065,774.97 pfet_05v0
XM_2580 n_I3810 n_I3805 VDD_DEC VDD_DEC pfet_05v0 L=0.5U W=0.36U AS=0.379P
+ AD=0.0612P PS=2.37U PD=0.7U
* device instance _2581 r0 *1 495.715,774.65 pfet_05v0
XM_2581 n_276 n_I3806 VDD_DEC VDD_DEC pfet_05v0 L=0.5U W=1.22U AS=0.379P
+ AD=0.5368P PS=2.37U PD=3.32U
* device instance _2582 r0 *1 488.985,775.08 pfet_05v0
XM_2582 VDD_DEC n_I2019 n_I3804 VDD_DEC pfet_05v0 L=0.5U W=0.36U AS=0.3852P
+ AD=0.1116P PS=2.86U PD=0.98U
* device instance _2583 r0 *1 490.105,775.08 pfet_05v0
XM_2583 n_I3809 n_I3804 VDD_DEC VDD_DEC pfet_05v0 L=0.5U W=0.36U AS=0.1116P
+ AD=0.0612P PS=0.98U PD=0.7U
* device instance _2584 r0 *1 490.945,775.08 pfet_05v0
XM_2584 n_I3809 n_I3804 n_I3805 VDD_DEC pfet_05v0 L=0.5U W=0.36U AS=0.3852P
+ AD=0.0612P PS=2.86U PD=0.7U
* device instance _2585 r0 *1 493.275,772.202 nfet_05v0
XM_2585 n_I3808 n_I3805 n_I3806 VSS nfet_05v0 L=0.6U W=0.365U AS=0.3705P
+ AD=0.0438P PS=2.77U PD=0.605U
* device instance _2586 r0 *1 494.115,772.202 nfet_05v0
XM_2586 VSS n_I3805 n_I3808 VSS nfet_05v0 L=0.6U W=0.365U AS=0.0438P
+ AD=0.282625P PS=0.605U PD=1.87U
* device instance _2587 r0 *1 495.765,772.43 nfet_05v0
XM_2587 n_276 n_I3806 VSS VSS nfet_05v0 L=0.6U W=0.82U AS=0.282625P AD=0.3608P
+ PS=1.87U PD=2.52U
* device instance _2588 r0 *1 489.035,772.2 nfet_05v0
XM_2588 VSS n_I2019 n_I3804 VSS nfet_05v0 L=0.6U W=0.36U AS=0.333P AD=0.0936P
+ PS=2.57U PD=0.88U
* device instance _2589 r0 *1 490.155,772.2 nfet_05v0
XM_2589 n_I3807 n_I3804 VSS VSS nfet_05v0 L=0.6U W=0.36U AS=0.0936P AD=0.0432P
+ PS=0.88U PD=0.6U
* device instance _2590 r0 *1 490.995,772.2 nfet_05v0
XM_2590 n_I3805 n_I3804 n_I3807 VSS nfet_05v0 L=0.6U W=0.36U AS=0.0432P
+ AD=0.369P PS=0.6U PD=2.77U
* device instance _2591 r0 *1 493.785,790.65 pfet_05v0
XM_2591 n_I3817 n_I3812 n_I3813 VDD_DEC pfet_05v0 L=0.5U W=0.36U AS=0.3456P
+ AD=0.0612P PS=2.64U PD=0.7U
* device instance _2592 r0 *1 494.625,790.65 pfet_05v0
XM_2592 n_I3817 n_I3812 VDD_DEC VDD_DEC pfet_05v0 L=0.5U W=0.36U AS=0.379P
+ AD=0.0612P PS=2.37U PD=0.7U
* device instance _2593 r0 *1 496.275,790.33 pfet_05v0
XM_2593 n_265 n_I3813 VDD_DEC VDD_DEC pfet_05v0 L=0.5U W=1.22U AS=0.379P
+ AD=0.5368P PS=2.37U PD=3.32U
* device instance _2594 r0 *1 489.545,790.76 pfet_05v0
XM_2594 VDD_DEC n_I2159 n_I3811 VDD_DEC pfet_05v0 L=0.5U W=0.36U AS=0.3852P
+ AD=0.1116P PS=2.86U PD=0.98U
* device instance _2595 r0 *1 490.665,790.76 pfet_05v0
XM_2595 n_I3816 n_I3811 VDD_DEC VDD_DEC pfet_05v0 L=0.5U W=0.36U AS=0.1116P
+ AD=0.0612P PS=0.98U PD=0.7U
* device instance _2596 r0 *1 491.505,790.76 pfet_05v0
XM_2596 n_I3816 n_I3811 n_I3812 VDD_DEC pfet_05v0 L=0.5U W=0.36U AS=0.3852P
+ AD=0.0612P PS=2.86U PD=0.7U
* device instance _2597 r0 *1 493.835,787.882 nfet_05v0
XM_2597 n_I3815 n_I3812 n_I3813 VSS nfet_05v0 L=0.6U W=0.365U AS=0.3705P
+ AD=0.0438P PS=2.77U PD=0.605U
* device instance _2598 r0 *1 494.675,787.882 nfet_05v0
XM_2598 VSS n_I3812 n_I3815 VSS nfet_05v0 L=0.6U W=0.365U AS=0.0438P
+ AD=0.282625P PS=0.605U PD=1.87U
* device instance _2599 r0 *1 496.325,788.11 nfet_05v0
XM_2599 n_265 n_I3813 VSS VSS nfet_05v0 L=0.6U W=0.82U AS=0.282625P AD=0.3608P
+ PS=1.87U PD=2.52U
* device instance _2600 r0 *1 489.595,787.88 nfet_05v0
XM_2600 VSS n_I2159 n_I3811 VSS nfet_05v0 L=0.6U W=0.36U AS=0.333P AD=0.0936P
+ PS=2.57U PD=0.88U
* device instance _2601 r0 *1 490.715,787.88 nfet_05v0
XM_2601 n_I3814 n_I3811 VSS VSS nfet_05v0 L=0.6U W=0.36U AS=0.0936P AD=0.0432P
+ PS=0.88U PD=0.6U
* device instance _2602 r0 *1 491.555,787.88 nfet_05v0
XM_2602 n_I3812 n_I3811 n_I3814 VSS nfet_05v0 L=0.6U W=0.36U AS=0.0432P
+ AD=0.369P PS=0.6U PD=2.77U
* device instance _2603 m0 *1 495.465,784.07 pfet_05v0
XM_2603 n_I3824 n_I3819 n_I3820 VDD_DEC pfet_05v0 L=0.5U W=0.36U AS=0.3456P
+ AD=0.0612P PS=2.64U PD=0.7U
* device instance _2604 m0 *1 496.305,784.07 pfet_05v0
XM_2604 n_I3824 n_I3819 VDD_DEC VDD_DEC pfet_05v0 L=0.5U W=0.36U AS=0.379P
+ AD=0.0612P PS=2.37U PD=0.7U
* device instance _2605 m0 *1 497.955,784.39 pfet_05v0
XM_2605 n_268 n_I3820 VDD_DEC VDD_DEC pfet_05v0 L=0.5U W=1.22U AS=0.379P
+ AD=0.5368P PS=2.37U PD=3.32U
* device instance _2606 m0 *1 491.225,783.96 pfet_05v0
XM_2606 VDD_DEC n_I2122 n_I3818 VDD_DEC pfet_05v0 L=0.5U W=0.36U AS=0.3852P
+ AD=0.1116P PS=2.86U PD=0.98U
* device instance _2607 m0 *1 492.345,783.96 pfet_05v0
XM_2607 n_I3823 n_I3818 VDD_DEC VDD_DEC pfet_05v0 L=0.5U W=0.36U AS=0.1116P
+ AD=0.0612P PS=0.98U PD=0.7U
* device instance _2608 m0 *1 493.185,783.96 pfet_05v0
XM_2608 n_I3823 n_I3818 n_I3819 VDD_DEC pfet_05v0 L=0.5U W=0.36U AS=0.3852P
+ AD=0.0612P PS=2.86U PD=0.7U
* device instance _2609 m0 *1 495.515,786.838 nfet_05v0
XM_2609 n_I3822 n_I3819 n_I3820 VSS nfet_05v0 L=0.6U W=0.365U AS=0.3705P
+ AD=0.0438P PS=2.77U PD=0.605U
* device instance _2610 m0 *1 496.355,786.838 nfet_05v0
XM_2610 VSS n_I3819 n_I3822 VSS nfet_05v0 L=0.6U W=0.365U AS=0.0438P
+ AD=0.282625P PS=0.605U PD=1.87U
* device instance _2611 m0 *1 498.005,786.61 nfet_05v0
XM_2611 n_268 n_I3820 VSS VSS nfet_05v0 L=0.6U W=0.82U AS=0.282625P AD=0.3608P
+ PS=1.87U PD=2.52U
* device instance _2612 m0 *1 491.275,786.84 nfet_05v0
XM_2612 VSS n_I2122 n_I3818 VSS nfet_05v0 L=0.6U W=0.36U AS=0.333P AD=0.0936P
+ PS=2.57U PD=0.88U
* device instance _2613 m0 *1 492.395,786.84 nfet_05v0
XM_2613 n_I3821 n_I3818 VSS VSS nfet_05v0 L=0.6U W=0.36U AS=0.0936P AD=0.0432P
+ PS=0.88U PD=0.6U
* device instance _2614 m0 *1 493.235,786.84 nfet_05v0
XM_2614 n_I3819 n_I3818 n_I3821 VSS nfet_05v0 L=0.6U W=0.36U AS=0.0432P
+ AD=0.369P PS=0.6U PD=2.77U
* device instance _2615 r0 *1 493.785,782.81 pfet_05v0
XM_2615 n_I3831 n_I3826 n_I3827 VDD_DEC pfet_05v0 L=0.5U W=0.36U AS=0.3456P
+ AD=0.0612P PS=2.64U PD=0.7U
* device instance _2616 r0 *1 494.625,782.81 pfet_05v0
XM_2616 n_I3831 n_I3826 VDD_DEC VDD_DEC pfet_05v0 L=0.5U W=0.36U AS=0.379P
+ AD=0.0612P PS=2.37U PD=0.7U
* device instance _2617 r0 *1 496.275,782.49 pfet_05v0
XM_2617 n_270 n_I3827 VDD_DEC VDD_DEC pfet_05v0 L=0.5U W=1.22U AS=0.379P
+ AD=0.5368P PS=2.37U PD=3.32U
* device instance _2618 r0 *1 489.545,782.92 pfet_05v0
XM_2618 VDD_DEC n_I2052 n_I3825 VDD_DEC pfet_05v0 L=0.5U W=0.36U AS=0.3852P
+ AD=0.1116P PS=2.86U PD=0.98U
* device instance _2619 r0 *1 490.665,782.92 pfet_05v0
XM_2619 n_I3830 n_I3825 VDD_DEC VDD_DEC pfet_05v0 L=0.5U W=0.36U AS=0.1116P
+ AD=0.0612P PS=0.98U PD=0.7U
* device instance _2620 r0 *1 491.505,782.92 pfet_05v0
XM_2620 n_I3830 n_I3825 n_I3826 VDD_DEC pfet_05v0 L=0.5U W=0.36U AS=0.3852P
+ AD=0.0612P PS=2.86U PD=0.7U
* device instance _2621 r0 *1 493.835,780.042 nfet_05v0
XM_2621 n_I3829 n_I3826 n_I3827 VSS nfet_05v0 L=0.6U W=0.365U AS=0.3705P
+ AD=0.0438P PS=2.77U PD=0.605U
* device instance _2622 r0 *1 494.675,780.042 nfet_05v0
XM_2622 VSS n_I3826 n_I3829 VSS nfet_05v0 L=0.6U W=0.365U AS=0.0438P
+ AD=0.282625P PS=0.605U PD=1.87U
* device instance _2623 r0 *1 496.325,780.27 nfet_05v0
XM_2623 n_270 n_I3827 VSS VSS nfet_05v0 L=0.6U W=0.82U AS=0.282625P AD=0.3608P
+ PS=1.87U PD=2.52U
* device instance _2624 r0 *1 489.595,780.04 nfet_05v0
XM_2624 VSS n_I2052 n_I3825 VSS nfet_05v0 L=0.6U W=0.36U AS=0.333P AD=0.0936P
+ PS=2.57U PD=0.88U
* device instance _2625 r0 *1 490.715,780.04 nfet_05v0
XM_2625 n_I3828 n_I3825 VSS VSS nfet_05v0 L=0.6U W=0.36U AS=0.0936P AD=0.0432P
+ PS=0.88U PD=0.6U
* device instance _2626 r0 *1 491.555,780.04 nfet_05v0
XM_2626 n_I3826 n_I3825 n_I3828 VSS nfet_05v0 L=0.6U W=0.36U AS=0.0432P
+ AD=0.369P PS=0.6U PD=2.77U
* device instance _2627 m90 *1 579.335,806.33 pfet_05v0
XM_2627 n_I3838 n_I3833 n_I3834 VDD_DEC pfet_05v0 L=0.5U W=0.36U AS=0.3456P
+ AD=0.0612P PS=2.64U PD=0.7U
* device instance _2628 m90 *1 578.495,806.33 pfet_05v0
XM_2628 n_I3838 n_I3833 VDD_DEC VDD_DEC pfet_05v0 L=0.5U W=0.36U AS=0.379P
+ AD=0.0612P PS=2.37U PD=0.7U
* device instance _2629 m90 *1 576.845,806.01 pfet_05v0
XM_2629 n_I2206 n_I3834 VDD_DEC VDD_DEC pfet_05v0 L=0.5U W=1.22U AS=0.379P
+ AD=0.5368P PS=2.37U PD=3.32U
* device instance _2630 m90 *1 583.575,806.44 pfet_05v0
XM_2630 VDD_DEC n_I2311 n_I3832 VDD_DEC pfet_05v0 L=0.5U W=0.36U AS=0.3852P
+ AD=0.1116P PS=2.86U PD=0.98U
* device instance _2631 m90 *1 582.455,806.44 pfet_05v0
XM_2631 n_I3837 n_I3832 VDD_DEC VDD_DEC pfet_05v0 L=0.5U W=0.36U AS=0.1116P
+ AD=0.0612P PS=0.98U PD=0.7U
* device instance _2632 m90 *1 581.615,806.44 pfet_05v0
XM_2632 n_I3837 n_I3832 n_I3833 VDD_DEC pfet_05v0 L=0.5U W=0.36U AS=0.3852P
+ AD=0.0612P PS=2.86U PD=0.7U
* device instance _2633 m90 *1 579.285,803.562 nfet_05v0
XM_2633 n_I3836 n_I3833 n_I3834 VSS nfet_05v0 L=0.6U W=0.365U AS=0.3705P
+ AD=0.0438P PS=2.77U PD=0.605U
* device instance _2634 m90 *1 578.445,803.562 nfet_05v0
XM_2634 VSS n_I3833 n_I3836 VSS nfet_05v0 L=0.6U W=0.365U AS=0.0438P
+ AD=0.282625P PS=0.605U PD=1.87U
* device instance _2635 m90 *1 576.795,803.79 nfet_05v0
XM_2635 n_I2206 n_I3834 VSS VSS nfet_05v0 L=0.6U W=0.82U AS=0.282625P AD=0.3608P
+ PS=1.87U PD=2.52U
* device instance _2636 m90 *1 583.525,803.56 nfet_05v0
XM_2636 VSS n_I2311 n_I3832 VSS nfet_05v0 L=0.6U W=0.36U AS=0.333P AD=0.0936P
+ PS=2.57U PD=0.88U
* device instance _2637 m90 *1 582.405,803.56 nfet_05v0
XM_2637 n_I3835 n_I3832 VSS VSS nfet_05v0 L=0.6U W=0.36U AS=0.0936P AD=0.0432P
+ PS=0.88U PD=0.6U
* device instance _2638 m90 *1 581.565,803.56 nfet_05v0
XM_2638 n_I3833 n_I3832 n_I3835 VSS nfet_05v0 L=0.6U W=0.36U AS=0.0432P
+ AD=0.369P PS=0.6U PD=2.77U
* device instance _2639 m90 *1 512.135,798.49 pfet_05v0
XM_2639 n_I3845 n_I3840 n_I3841 VDD_DEC pfet_05v0 L=0.5U W=0.36U AS=0.3456P
+ AD=0.0612P PS=2.64U PD=0.7U
* device instance _2640 m90 *1 511.295,798.49 pfet_05v0
XM_2640 n_I3845 n_I3840 VDD_DEC VDD_DEC pfet_05v0 L=0.5U W=0.36U AS=0.379P
+ AD=0.0612P PS=2.37U PD=0.7U
* device instance _2641 m90 *1 509.645,798.17 pfet_05v0
XM_2641 n_I2195 n_I3841 VDD_DEC VDD_DEC pfet_05v0 L=0.5U W=1.22U AS=0.379P
+ AD=0.5368P PS=2.37U PD=3.32U
* device instance _2642 m90 *1 516.375,798.6 pfet_05v0
XM_2642 VDD_DEC n_I2200 n_I3839 VDD_DEC pfet_05v0 L=0.5U W=0.36U AS=0.3852P
+ AD=0.1116P PS=2.86U PD=0.98U
* device instance _2643 m90 *1 515.255,798.6 pfet_05v0
XM_2643 n_I3844 n_I3839 VDD_DEC VDD_DEC pfet_05v0 L=0.5U W=0.36U AS=0.1116P
+ AD=0.0612P PS=0.98U PD=0.7U
* device instance _2644 m90 *1 514.415,798.6 pfet_05v0
XM_2644 n_I3844 n_I3839 n_I3840 VDD_DEC pfet_05v0 L=0.5U W=0.36U AS=0.3852P
+ AD=0.0612P PS=2.86U PD=0.7U
* device instance _2645 m90 *1 512.085,795.722 nfet_05v0
XM_2645 n_I3843 n_I3840 n_I3841 VSS nfet_05v0 L=0.6U W=0.365U AS=0.3705P
+ AD=0.0438P PS=2.77U PD=0.605U
* device instance _2646 m90 *1 511.245,795.722 nfet_05v0
XM_2646 VSS n_I3840 n_I3843 VSS nfet_05v0 L=0.6U W=0.365U AS=0.0438P
+ AD=0.282625P PS=0.605U PD=1.87U
* device instance _2647 m90 *1 509.595,795.95 nfet_05v0
XM_2647 n_I2195 n_I3841 VSS VSS nfet_05v0 L=0.6U W=0.82U AS=0.282625P AD=0.3608P
+ PS=1.87U PD=2.52U
* device instance _2648 m90 *1 516.325,795.72 nfet_05v0
XM_2648 VSS n_I2200 n_I3839 VSS nfet_05v0 L=0.6U W=0.36U AS=0.333P AD=0.0936P
+ PS=2.57U PD=0.88U
* device instance _2649 m90 *1 515.205,795.72 nfet_05v0
XM_2649 n_I3842 n_I3839 VSS VSS nfet_05v0 L=0.6U W=0.36U AS=0.0936P AD=0.0432P
+ PS=0.88U PD=0.6U
* device instance _2650 m90 *1 514.365,795.72 nfet_05v0
XM_2650 n_I3840 n_I3839 n_I3842 VSS nfet_05v0 L=0.6U W=0.36U AS=0.0432P
+ AD=0.369P PS=0.6U PD=2.77U
* device instance _2651 m90 *1 666.695,837.69 pfet_05v0
XM_2651 n_I3852 n_I3847 n_I3848 VDD_DEC pfet_05v0 L=0.5U W=0.36U AS=0.3456P
+ AD=0.0612P PS=2.64U PD=0.7U
* device instance _2652 m90 *1 665.855,837.69 pfet_05v0
XM_2652 n_I3852 n_I3847 VDD_DEC VDD_DEC pfet_05v0 L=0.5U W=0.36U AS=0.379P
+ AD=0.0612P PS=2.37U PD=0.7U
* device instance _2653 m90 *1 664.205,837.37 pfet_05v0
XM_2653 n_I2344 n_I3848 VDD_DEC VDD_DEC pfet_05v0 L=0.5U W=1.22U AS=0.379P
+ AD=0.5368P PS=2.37U PD=3.32U
* device instance _2654 m90 *1 670.935,837.8 pfet_05v0
XM_2654 VDD_DEC D[6] n_I3846 VDD_DEC pfet_05v0 L=0.5U W=0.36U AS=0.3852P
+ AD=0.1116P PS=2.86U PD=0.98U
* device instance _2655 m90 *1 669.815,837.8 pfet_05v0
XM_2655 n_I3851 n_I3846 VDD_DEC VDD_DEC pfet_05v0 L=0.5U W=0.36U AS=0.1116P
+ AD=0.0612P PS=0.98U PD=0.7U
* device instance _2656 m90 *1 668.975,837.8 pfet_05v0
XM_2656 n_I3851 n_I3846 n_I3847 VDD_DEC pfet_05v0 L=0.5U W=0.36U AS=0.3852P
+ AD=0.0612P PS=2.86U PD=0.7U
* device instance _2657 m90 *1 666.645,834.922 nfet_05v0
XM_2657 n_I3850 n_I3847 n_I3848 VSS nfet_05v0 L=0.6U W=0.365U AS=0.3705P
+ AD=0.0438P PS=2.77U PD=0.605U
* device instance _2658 m90 *1 665.805,834.922 nfet_05v0
XM_2658 VSS n_I3847 n_I3850 VSS nfet_05v0 L=0.6U W=0.365U AS=0.0438P
+ AD=0.282625P PS=0.605U PD=1.87U
* device instance _2659 m90 *1 664.155,835.15 nfet_05v0
XM_2659 n_I2344 n_I3848 VSS VSS nfet_05v0 L=0.6U W=0.82U AS=0.282625P AD=0.3608P
+ PS=1.87U PD=2.52U
* device instance _2660 m90 *1 670.885,834.92 nfet_05v0
XM_2660 VSS D[6] n_I3846 VSS nfet_05v0 L=0.6U W=0.36U AS=0.333P AD=0.0936P
+ PS=2.57U PD=0.88U
* device instance _2661 m90 *1 669.765,834.92 nfet_05v0
XM_2661 n_I3849 n_I3846 VSS VSS nfet_05v0 L=0.6U W=0.36U AS=0.0936P AD=0.0432P
+ PS=0.88U PD=0.6U
* device instance _2662 m90 *1 668.925,834.92 nfet_05v0
XM_2662 n_I3847 n_I3846 n_I3849 VSS nfet_05v0 L=0.6U W=0.36U AS=0.0432P
+ AD=0.369P PS=0.6U PD=2.77U
* device instance _2663 m90 *1 555.815,837.69 pfet_05v0
XM_2663 n_I3859 n_I3854 n_I3855 VDD_DEC pfet_05v0 L=0.5U W=0.36U AS=0.3456P
+ AD=0.0612P PS=2.64U PD=0.7U
* device instance _2664 m90 *1 554.975,837.69 pfet_05v0
XM_2664 n_I3859 n_I3854 VDD_DEC VDD_DEC pfet_05v0 L=0.5U W=0.36U AS=0.379P
+ AD=0.0612P PS=2.37U PD=0.7U
* device instance _2665 m90 *1 553.325,837.37 pfet_05v0
XM_2665 n_I2418 n_I3855 VDD_DEC VDD_DEC pfet_05v0 L=0.5U W=1.22U AS=0.379P
+ AD=0.5368P PS=2.37U PD=3.32U
* device instance _2666 m90 *1 560.055,837.8 pfet_05v0
XM_2666 VDD_DEC D[2] n_I3853 VDD_DEC pfet_05v0 L=0.5U W=0.36U AS=0.3852P
+ AD=0.1116P PS=2.86U PD=0.98U
* device instance _2667 m90 *1 558.935,837.8 pfet_05v0
XM_2667 n_I3858 n_I3853 VDD_DEC VDD_DEC pfet_05v0 L=0.5U W=0.36U AS=0.1116P
+ AD=0.0612P PS=0.98U PD=0.7U
* device instance _2668 m90 *1 558.095,837.8 pfet_05v0
XM_2668 n_I3858 n_I3853 n_I3854 VDD_DEC pfet_05v0 L=0.5U W=0.36U AS=0.3852P
+ AD=0.0612P PS=2.86U PD=0.7U
* device instance _2669 m90 *1 555.765,834.922 nfet_05v0
XM_2669 n_I3857 n_I3854 n_I3855 VSS nfet_05v0 L=0.6U W=0.365U AS=0.3705P
+ AD=0.0438P PS=2.77U PD=0.605U
* device instance _2670 m90 *1 554.925,834.922 nfet_05v0
XM_2670 VSS n_I3854 n_I3857 VSS nfet_05v0 L=0.6U W=0.365U AS=0.0438P
+ AD=0.282625P PS=0.605U PD=1.87U
* device instance _2671 m90 *1 553.275,835.15 nfet_05v0
XM_2671 n_I2418 n_I3855 VSS VSS nfet_05v0 L=0.6U W=0.82U AS=0.282625P AD=0.3608P
+ PS=1.87U PD=2.52U
* device instance _2672 m90 *1 560.005,834.92 nfet_05v0
XM_2672 VSS D[2] n_I3853 VSS nfet_05v0 L=0.6U W=0.36U AS=0.333P AD=0.0936P
+ PS=2.57U PD=0.88U
* device instance _2673 m90 *1 558.885,834.92 nfet_05v0
XM_2673 n_I3856 n_I3853 VSS VSS nfet_05v0 L=0.6U W=0.36U AS=0.0936P AD=0.0432P
+ PS=0.88U PD=0.6U
* device instance _2674 m90 *1 558.045,834.92 nfet_05v0
XM_2674 n_I3854 n_I3853 n_I3856 VSS nfet_05v0 L=0.6U W=0.36U AS=0.0432P
+ AD=0.369P PS=0.6U PD=2.77U
* device instance _2675 m90 *1 648.775,790.65 pfet_05v0
XM_2675 n_I3866 n_I3861 n_I3862 VDD_DEC pfet_05v0 L=0.5U W=0.36U AS=0.3456P
+ AD=0.0612P PS=2.64U PD=0.7U
* device instance _2676 m90 *1 647.935,790.65 pfet_05v0
XM_2676 n_I3866 n_I3861 VDD_DEC VDD_DEC pfet_05v0 L=0.5U W=0.36U AS=0.379P
+ AD=0.0612P PS=2.37U PD=0.7U
* device instance _2677 m90 *1 646.285,790.33 pfet_05v0
XM_2677 n_I2176 n_I3862 VDD_DEC VDD_DEC pfet_05v0 L=0.5U W=1.22U AS=0.379P
+ AD=0.5368P PS=2.37U PD=3.32U
* device instance _2678 m90 *1 653.015,790.76 pfet_05v0
XM_2678 VDD_DEC n_I2214 n_I3860 VDD_DEC pfet_05v0 L=0.5U W=0.36U AS=0.3852P
+ AD=0.1116P PS=2.86U PD=0.98U
* device instance _2679 m90 *1 651.895,790.76 pfet_05v0
XM_2679 n_I3865 n_I3860 VDD_DEC VDD_DEC pfet_05v0 L=0.5U W=0.36U AS=0.1116P
+ AD=0.0612P PS=0.98U PD=0.7U
* device instance _2680 m90 *1 651.055,790.76 pfet_05v0
XM_2680 n_I3865 n_I3860 n_I3861 VDD_DEC pfet_05v0 L=0.5U W=0.36U AS=0.3852P
+ AD=0.0612P PS=2.86U PD=0.7U
* device instance _2681 m90 *1 648.725,787.882 nfet_05v0
XM_2681 n_I3864 n_I3861 n_I3862 VSS nfet_05v0 L=0.6U W=0.365U AS=0.3705P
+ AD=0.0438P PS=2.77U PD=0.605U
* device instance _2682 m90 *1 647.885,787.882 nfet_05v0
XM_2682 VSS n_I3861 n_I3864 VSS nfet_05v0 L=0.6U W=0.365U AS=0.0438P
+ AD=0.282625P PS=0.605U PD=1.87U
* device instance _2683 m90 *1 646.235,788.11 nfet_05v0
XM_2683 n_I2176 n_I3862 VSS VSS nfet_05v0 L=0.6U W=0.82U AS=0.282625P AD=0.3608P
+ PS=1.87U PD=2.52U
* device instance _2684 m90 *1 652.965,787.88 nfet_05v0
XM_2684 VSS n_I2214 n_I3860 VSS nfet_05v0 L=0.6U W=0.36U AS=0.333P AD=0.0936P
+ PS=2.57U PD=0.88U
* device instance _2685 m90 *1 651.845,787.88 nfet_05v0
XM_2685 n_I3863 n_I3860 VSS VSS nfet_05v0 L=0.6U W=0.36U AS=0.0936P AD=0.0432P
+ PS=0.88U PD=0.6U
* device instance _2686 m90 *1 651.005,787.88 nfet_05v0
XM_2686 n_I3861 n_I3860 n_I3863 VSS nfet_05v0 L=0.6U W=0.36U AS=0.0432P
+ AD=0.369P PS=0.6U PD=2.77U
* device instance _2687 m90 *1 642.055,822.01 pfet_05v0
XM_2687 n_I3873 n_I3868 n_I3869 VDD_DEC pfet_05v0 L=0.5U W=0.36U AS=0.3456P
+ AD=0.0612P PS=2.64U PD=0.7U
* device instance _2688 m90 *1 641.215,822.01 pfet_05v0
XM_2688 n_I3873 n_I3868 VDD_DEC VDD_DEC pfet_05v0 L=0.5U W=0.36U AS=0.379P
+ AD=0.0612P PS=2.37U PD=0.7U
* device instance _2689 m90 *1 639.565,821.69 pfet_05v0
XM_2689 n_I2337 n_I3869 VDD_DEC VDD_DEC pfet_05v0 L=0.5U W=1.22U AS=0.379P
+ AD=0.5368P PS=2.37U PD=3.32U
* device instance _2690 m90 *1 646.295,822.12 pfet_05v0
XM_2690 VDD_DEC n_I2404 n_I3867 VDD_DEC pfet_05v0 L=0.5U W=0.36U AS=0.3852P
+ AD=0.1116P PS=2.86U PD=0.98U
* device instance _2691 m90 *1 645.175,822.12 pfet_05v0
XM_2691 n_I3872 n_I3867 VDD_DEC VDD_DEC pfet_05v0 L=0.5U W=0.36U AS=0.1116P
+ AD=0.0612P PS=0.98U PD=0.7U
* device instance _2692 m90 *1 644.335,822.12 pfet_05v0
XM_2692 n_I3872 n_I3867 n_I3868 VDD_DEC pfet_05v0 L=0.5U W=0.36U AS=0.3852P
+ AD=0.0612P PS=2.86U PD=0.7U
* device instance _2693 m90 *1 642.005,819.242 nfet_05v0
XM_2693 n_I3871 n_I3868 n_I3869 VSS nfet_05v0 L=0.6U W=0.365U AS=0.3705P
+ AD=0.0438P PS=2.77U PD=0.605U
* device instance _2694 m90 *1 641.165,819.242 nfet_05v0
XM_2694 VSS n_I3868 n_I3871 VSS nfet_05v0 L=0.6U W=0.365U AS=0.0438P
+ AD=0.282625P PS=0.605U PD=1.87U
* device instance _2695 m90 *1 639.515,819.47 nfet_05v0
XM_2695 n_I2337 n_I3869 VSS VSS nfet_05v0 L=0.6U W=0.82U AS=0.282625P AD=0.3608P
+ PS=1.87U PD=2.52U
* device instance _2696 m90 *1 646.245,819.24 nfet_05v0
XM_2696 VSS n_I2404 n_I3867 VSS nfet_05v0 L=0.6U W=0.36U AS=0.333P AD=0.0936P
+ PS=2.57U PD=0.88U
* device instance _2697 m90 *1 645.125,819.24 nfet_05v0
XM_2697 n_I3870 n_I3867 VSS VSS nfet_05v0 L=0.6U W=0.36U AS=0.0936P AD=0.0432P
+ PS=0.88U PD=0.6U
* device instance _2698 m90 *1 644.285,819.24 nfet_05v0
XM_2698 n_I3868 n_I3867 n_I3870 VSS nfet_05v0 L=0.6U W=0.36U AS=0.0432P
+ AD=0.369P PS=0.6U PD=2.77U
* device instance _2699 m90 *1 578.215,814.17 pfet_05v0
XM_2699 n_I3880 n_I3875 n_I3876 VDD_DEC pfet_05v0 L=0.5U W=0.36U AS=0.3456P
+ AD=0.0612P PS=2.64U PD=0.7U
* device instance _2700 m90 *1 577.375,814.17 pfet_05v0
XM_2700 n_I3880 n_I3875 VDD_DEC VDD_DEC pfet_05v0 L=0.5U W=0.36U AS=0.379P
+ AD=0.0612P PS=2.37U PD=0.7U
* device instance _2701 m90 *1 575.725,813.85 pfet_05v0
XM_2701 n_I2169 n_I3876 VDD_DEC VDD_DEC pfet_05v0 L=0.5U W=1.22U AS=0.379P
+ AD=0.5368P PS=2.37U PD=3.32U
* device instance _2702 m90 *1 582.455,814.28 pfet_05v0
XM_2702 VDD_DEC n_I2207 n_I3874 VDD_DEC pfet_05v0 L=0.5U W=0.36U AS=0.3852P
+ AD=0.1116P PS=2.86U PD=0.98U
* device instance _2703 m90 *1 581.335,814.28 pfet_05v0
XM_2703 n_I3879 n_I3874 VDD_DEC VDD_DEC pfet_05v0 L=0.5U W=0.36U AS=0.1116P
+ AD=0.0612P PS=0.98U PD=0.7U
* device instance _2704 m90 *1 580.495,814.28 pfet_05v0
XM_2704 n_I3879 n_I3874 n_I3875 VDD_DEC pfet_05v0 L=0.5U W=0.36U AS=0.3852P
+ AD=0.0612P PS=2.86U PD=0.7U
* device instance _2705 m90 *1 578.165,811.402 nfet_05v0
XM_2705 n_I3878 n_I3875 n_I3876 VSS nfet_05v0 L=0.6U W=0.365U AS=0.3705P
+ AD=0.0438P PS=2.77U PD=0.605U
* device instance _2706 m90 *1 577.325,811.402 nfet_05v0
XM_2706 VSS n_I3875 n_I3878 VSS nfet_05v0 L=0.6U W=0.365U AS=0.0438P
+ AD=0.282625P PS=0.605U PD=1.87U
* device instance _2707 m90 *1 575.675,811.63 nfet_05v0
XM_2707 n_I2169 n_I3876 VSS VSS nfet_05v0 L=0.6U W=0.82U AS=0.282625P AD=0.3608P
+ PS=1.87U PD=2.52U
* device instance _2708 m90 *1 582.405,811.4 nfet_05v0
XM_2708 VSS n_I2207 n_I3874 VSS nfet_05v0 L=0.6U W=0.36U AS=0.333P AD=0.0936P
+ PS=2.57U PD=0.88U
* device instance _2709 m90 *1 581.285,811.4 nfet_05v0
XM_2709 n_I3877 n_I3874 VSS VSS nfet_05v0 L=0.6U W=0.36U AS=0.0936P AD=0.0432P
+ PS=0.88U PD=0.6U
* device instance _2710 m90 *1 580.445,811.4 nfet_05v0
XM_2710 n_I3875 n_I3874 n_I3877 VSS nfet_05v0 L=0.6U W=0.36U AS=0.0432P
+ AD=0.369P PS=0.6U PD=2.77U
* device instance _2711 m90 *1 564.775,822.01 pfet_05v0
XM_2711 n_I3887 n_I3882 n_I3883 VDD_DEC pfet_05v0 L=0.5U W=0.36U AS=0.3456P
+ AD=0.0612P PS=2.64U PD=0.7U
* device instance _2712 m90 *1 563.935,822.01 pfet_05v0
XM_2712 n_I3887 n_I3882 VDD_DEC VDD_DEC pfet_05v0 L=0.5U W=0.36U AS=0.379P
+ AD=0.0612P PS=2.37U PD=0.7U
* device instance _2713 m90 *1 562.285,821.69 pfet_05v0
XM_2713 n_I2358 n_I3883 VDD_DEC VDD_DEC pfet_05v0 L=0.5U W=1.22U AS=0.379P
+ AD=0.5368P PS=2.37U PD=3.32U
* device instance _2714 m90 *1 569.015,822.12 pfet_05v0
XM_2714 VDD_DEC n_I2401 n_I3881 VDD_DEC pfet_05v0 L=0.5U W=0.36U AS=0.3852P
+ AD=0.1116P PS=2.86U PD=0.98U
* device instance _2715 m90 *1 567.895,822.12 pfet_05v0
XM_2715 n_I3886 n_I3881 VDD_DEC VDD_DEC pfet_05v0 L=0.5U W=0.36U AS=0.1116P
+ AD=0.0612P PS=0.98U PD=0.7U
* device instance _2716 m90 *1 567.055,822.12 pfet_05v0
XM_2716 n_I3886 n_I3881 n_I3882 VDD_DEC pfet_05v0 L=0.5U W=0.36U AS=0.3852P
+ AD=0.0612P PS=2.86U PD=0.7U
* device instance _2717 m90 *1 564.725,819.242 nfet_05v0
XM_2717 n_I3885 n_I3882 n_I3883 VSS nfet_05v0 L=0.6U W=0.365U AS=0.3705P
+ AD=0.0438P PS=2.77U PD=0.605U
* device instance _2718 m90 *1 563.885,819.242 nfet_05v0
XM_2718 VSS n_I3882 n_I3885 VSS nfet_05v0 L=0.6U W=0.365U AS=0.0438P
+ AD=0.282625P PS=0.605U PD=1.87U
* device instance _2719 m90 *1 562.235,819.47 nfet_05v0
XM_2719 n_I2358 n_I3883 VSS VSS nfet_05v0 L=0.6U W=0.82U AS=0.282625P AD=0.3608P
+ PS=1.87U PD=2.52U
* device instance _2720 m90 *1 568.965,819.24 nfet_05v0
XM_2720 VSS n_I2401 n_I3881 VSS nfet_05v0 L=0.6U W=0.36U AS=0.333P AD=0.0936P
+ PS=2.57U PD=0.88U
* device instance _2721 m90 *1 567.845,819.24 nfet_05v0
XM_2721 n_I3884 n_I3881 VSS VSS nfet_05v0 L=0.6U W=0.36U AS=0.0936P AD=0.0432P
+ PS=0.88U PD=0.6U
* device instance _2722 m90 *1 567.005,819.24 nfet_05v0
XM_2722 n_I3882 n_I3881 n_I3884 VSS nfet_05v0 L=0.6U W=0.36U AS=0.0432P
+ AD=0.369P PS=0.6U PD=2.77U
* device instance _2723 m90 *1 579.335,782.81 pfet_05v0
XM_2723 n_I3894 n_I3889 n_I3890 VDD_DEC pfet_05v0 L=0.5U W=0.36U AS=0.3456P
+ AD=0.0612P PS=2.64U PD=0.7U
* device instance _2724 m90 *1 578.495,782.81 pfet_05v0
XM_2724 n_I3894 n_I3889 VDD_DEC VDD_DEC pfet_05v0 L=0.5U W=0.36U AS=0.379P
+ AD=0.0612P PS=2.37U PD=0.7U
* device instance _2725 m90 *1 576.845,782.49 pfet_05v0
XM_2725 n_84 n_I3890 VDD_DEC VDD_DEC pfet_05v0 L=0.5U W=1.22U AS=0.379P
+ AD=0.5368P PS=2.37U PD=3.32U
* device instance _2726 m90 *1 583.575,782.92 pfet_05v0
XM_2726 VDD_DEC n_I2066 n_I3888 VDD_DEC pfet_05v0 L=0.5U W=0.36U AS=0.3852P
+ AD=0.1116P PS=2.86U PD=0.98U
* device instance _2727 m90 *1 582.455,782.92 pfet_05v0
XM_2727 n_I3893 n_I3888 VDD_DEC VDD_DEC pfet_05v0 L=0.5U W=0.36U AS=0.1116P
+ AD=0.0612P PS=0.98U PD=0.7U
* device instance _2728 m90 *1 581.615,782.92 pfet_05v0
XM_2728 n_I3893 n_I3888 n_I3889 VDD_DEC pfet_05v0 L=0.5U W=0.36U AS=0.3852P
+ AD=0.0612P PS=2.86U PD=0.7U
* device instance _2729 m90 *1 579.285,780.042 nfet_05v0
XM_2729 n_I3892 n_I3889 n_I3890 VSS nfet_05v0 L=0.6U W=0.365U AS=0.3705P
+ AD=0.0438P PS=2.77U PD=0.605U
* device instance _2730 m90 *1 578.445,780.042 nfet_05v0
XM_2730 VSS n_I3889 n_I3892 VSS nfet_05v0 L=0.6U W=0.365U AS=0.0438P
+ AD=0.282625P PS=0.605U PD=1.87U
* device instance _2731 m90 *1 576.795,780.27 nfet_05v0
XM_2731 n_84 n_I3890 VSS VSS nfet_05v0 L=0.6U W=0.82U AS=0.282625P AD=0.3608P
+ PS=1.87U PD=2.52U
* device instance _2732 m90 *1 583.525,780.04 nfet_05v0
XM_2732 VSS n_I2066 n_I3888 VSS nfet_05v0 L=0.6U W=0.36U AS=0.333P AD=0.0936P
+ PS=2.57U PD=0.88U
* device instance _2733 m90 *1 582.405,780.04 nfet_05v0
XM_2733 n_I3891 n_I3888 VSS VSS nfet_05v0 L=0.6U W=0.36U AS=0.0936P AD=0.0432P
+ PS=0.88U PD=0.6U
* device instance _2734 m90 *1 581.565,780.04 nfet_05v0
XM_2734 n_I3889 n_I3888 n_I3891 VSS nfet_05v0 L=0.6U W=0.36U AS=0.0432P
+ AD=0.369P PS=0.6U PD=2.77U
* device instance _2735 m90 *1 527.815,814.17 pfet_05v0
XM_2735 n_I3901 n_I3896 n_I3897 VDD_DEC pfet_05v0 L=0.5U W=0.36U AS=0.3456P
+ AD=0.0612P PS=2.64U PD=0.7U
* device instance _2736 m90 *1 526.975,814.17 pfet_05v0
XM_2736 n_I3901 n_I3896 VDD_DEC VDD_DEC pfet_05v0 L=0.5U W=0.36U AS=0.379P
+ AD=0.0612P PS=2.37U PD=0.7U
* device instance _2737 m90 *1 525.325,813.85 pfet_05v0
XM_2737 n_I2248 n_I3897 VDD_DEC VDD_DEC pfet_05v0 L=0.5U W=1.22U AS=0.379P
+ AD=0.5368P PS=2.37U PD=3.32U
* device instance _2738 m90 *1 532.055,814.28 pfet_05v0
XM_2738 VDD_DEC n_I2358 n_I3895 VDD_DEC pfet_05v0 L=0.5U W=0.36U AS=0.3852P
+ AD=0.1116P PS=2.86U PD=0.98U
* device instance _2739 m90 *1 530.935,814.28 pfet_05v0
XM_2739 n_I3900 n_I3895 VDD_DEC VDD_DEC pfet_05v0 L=0.5U W=0.36U AS=0.1116P
+ AD=0.0612P PS=0.98U PD=0.7U
* device instance _2740 m90 *1 530.095,814.28 pfet_05v0
XM_2740 n_I3900 n_I3895 n_I3896 VDD_DEC pfet_05v0 L=0.5U W=0.36U AS=0.3852P
+ AD=0.0612P PS=2.86U PD=0.7U
* device instance _2741 m90 *1 527.765,811.402 nfet_05v0
XM_2741 n_I3899 n_I3896 n_I3897 VSS nfet_05v0 L=0.6U W=0.365U AS=0.3705P
+ AD=0.0438P PS=2.77U PD=0.605U
* device instance _2742 m90 *1 526.925,811.402 nfet_05v0
XM_2742 VSS n_I3896 n_I3899 VSS nfet_05v0 L=0.6U W=0.365U AS=0.0438P
+ AD=0.282625P PS=0.605U PD=1.87U
* device instance _2743 m90 *1 525.275,811.63 nfet_05v0
XM_2743 n_I2248 n_I3897 VSS VSS nfet_05v0 L=0.6U W=0.82U AS=0.282625P AD=0.3608P
+ PS=1.87U PD=2.52U
* device instance _2744 m90 *1 532.005,811.4 nfet_05v0
XM_2744 VSS n_I2358 n_I3895 VSS nfet_05v0 L=0.6U W=0.36U AS=0.333P AD=0.0936P
+ PS=2.57U PD=0.88U
* device instance _2745 m90 *1 530.885,811.4 nfet_05v0
XM_2745 n_I3898 n_I3895 VSS VSS nfet_05v0 L=0.6U W=0.36U AS=0.0936P AD=0.0432P
+ PS=0.88U PD=0.6U
* device instance _2746 m90 *1 530.045,811.4 nfet_05v0
XM_2746 n_I3896 n_I3895 n_I3898 VSS nfet_05v0 L=0.6U W=0.36U AS=0.0432P
+ AD=0.369P PS=0.6U PD=2.77U
* device instance _2747 m90 *1 651.015,814.17 pfet_05v0
XM_2747 n_I3908 n_I3903 n_I3904 VDD_DEC pfet_05v0 L=0.5U W=0.36U AS=0.3456P
+ AD=0.0612P PS=2.64U PD=0.7U
* device instance _2748 m90 *1 650.175,814.17 pfet_05v0
XM_2748 n_I3908 n_I3903 VDD_DEC VDD_DEC pfet_05v0 L=0.5U W=0.36U AS=0.379P
+ AD=0.0612P PS=2.37U PD=0.7U
* device instance _2749 m90 *1 648.525,813.85 pfet_05v0
XM_2749 n_I2236 n_I3904 VDD_DEC VDD_DEC pfet_05v0 L=0.5U W=1.22U AS=0.379P
+ AD=0.5368P PS=2.37U PD=3.32U
* device instance _2750 m90 *1 655.255,814.28 pfet_05v0
XM_2750 VDD_DEC n_I2342 n_I3902 VDD_DEC pfet_05v0 L=0.5U W=0.36U AS=0.3852P
+ AD=0.1116P PS=2.86U PD=0.98U
* device instance _2751 m90 *1 654.135,814.28 pfet_05v0
XM_2751 n_I3907 n_I3902 VDD_DEC VDD_DEC pfet_05v0 L=0.5U W=0.36U AS=0.1116P
+ AD=0.0612P PS=0.98U PD=0.7U
* device instance _2752 m90 *1 653.295,814.28 pfet_05v0
XM_2752 n_I3907 n_I3902 n_I3903 VDD_DEC pfet_05v0 L=0.5U W=0.36U AS=0.3852P
+ AD=0.0612P PS=2.86U PD=0.7U
* device instance _2753 m90 *1 650.965,811.402 nfet_05v0
XM_2753 n_I3906 n_I3903 n_I3904 VSS nfet_05v0 L=0.6U W=0.365U AS=0.3705P
+ AD=0.0438P PS=2.77U PD=0.605U
* device instance _2754 m90 *1 650.125,811.402 nfet_05v0
XM_2754 VSS n_I3903 n_I3906 VSS nfet_05v0 L=0.6U W=0.365U AS=0.0438P
+ AD=0.282625P PS=0.605U PD=1.87U
* device instance _2755 m90 *1 648.475,811.63 nfet_05v0
XM_2755 n_I2236 n_I3904 VSS VSS nfet_05v0 L=0.6U W=0.82U AS=0.282625P AD=0.3608P
+ PS=1.87U PD=2.52U
* device instance _2756 m90 *1 655.205,811.4 nfet_05v0
XM_2756 VSS n_I2342 n_I3902 VSS nfet_05v0 L=0.6U W=0.36U AS=0.333P AD=0.0936P
+ PS=2.57U PD=0.88U
* device instance _2757 m90 *1 654.085,811.4 nfet_05v0
XM_2757 n_I3905 n_I3902 VSS VSS nfet_05v0 L=0.6U W=0.36U AS=0.0936P AD=0.0432P
+ PS=0.88U PD=0.6U
* device instance _2758 m90 *1 653.245,811.4 nfet_05v0
XM_2758 n_I3903 n_I3902 n_I3905 VSS nfet_05v0 L=0.6U W=0.36U AS=0.0432P
+ AD=0.369P PS=0.6U PD=2.77U
* device instance _2759 m90 *1 555.815,822.01 pfet_05v0
XM_2759 n_I3915 n_I3910 n_I3911 VDD_DEC pfet_05v0 L=0.5U W=0.36U AS=0.3456P
+ AD=0.0612P PS=2.64U PD=0.7U
* device instance _2760 m90 *1 554.975,822.01 pfet_05v0
XM_2760 n_I3915 n_I3910 VDD_DEC VDD_DEC pfet_05v0 L=0.5U W=0.36U AS=0.379P
+ AD=0.0612P PS=2.37U PD=0.7U
* device instance _2761 m90 *1 553.325,821.69 pfet_05v0
XM_2761 n_I2333 n_I3911 VDD_DEC VDD_DEC pfet_05v0 L=0.5U W=1.22U AS=0.379P
+ AD=0.5368P PS=2.37U PD=3.32U
* device instance _2762 m90 *1 560.055,822.12 pfet_05v0
XM_2762 VDD_DEC n_I2358 n_I3909 VDD_DEC pfet_05v0 L=0.5U W=0.36U AS=0.3852P
+ AD=0.1116P PS=2.86U PD=0.98U
* device instance _2763 m90 *1 558.935,822.12 pfet_05v0
XM_2763 n_I3914 n_I3909 VDD_DEC VDD_DEC pfet_05v0 L=0.5U W=0.36U AS=0.1116P
+ AD=0.0612P PS=0.98U PD=0.7U
* device instance _2764 m90 *1 558.095,822.12 pfet_05v0
XM_2764 n_I3914 n_I3909 n_I3910 VDD_DEC pfet_05v0 L=0.5U W=0.36U AS=0.3852P
+ AD=0.0612P PS=2.86U PD=0.7U
* device instance _2765 m90 *1 555.765,819.242 nfet_05v0
XM_2765 n_I3913 n_I3910 n_I3911 VSS nfet_05v0 L=0.6U W=0.365U AS=0.3705P
+ AD=0.0438P PS=2.77U PD=0.605U
* device instance _2766 m90 *1 554.925,819.242 nfet_05v0
XM_2766 VSS n_I3910 n_I3913 VSS nfet_05v0 L=0.6U W=0.365U AS=0.0438P
+ AD=0.282625P PS=0.605U PD=1.87U
* device instance _2767 m90 *1 553.275,819.47 nfet_05v0
XM_2767 n_I2333 n_I3911 VSS VSS nfet_05v0 L=0.6U W=0.82U AS=0.282625P AD=0.3608P
+ PS=1.87U PD=2.52U
* device instance _2768 m90 *1 560.005,819.24 nfet_05v0
XM_2768 VSS n_I2358 n_I3909 VSS nfet_05v0 L=0.6U W=0.36U AS=0.333P AD=0.0936P
+ PS=2.57U PD=0.88U
* device instance _2769 m90 *1 558.885,819.24 nfet_05v0
XM_2769 n_I3912 n_I3909 VSS VSS nfet_05v0 L=0.6U W=0.36U AS=0.0936P AD=0.0432P
+ PS=0.88U PD=0.6U
* device instance _2770 m90 *1 558.045,819.24 nfet_05v0
XM_2770 n_I3910 n_I3909 n_I3912 VSS nfet_05v0 L=0.6U W=0.36U AS=0.0432P
+ AD=0.369P PS=0.6U PD=2.77U
* device instance _2771 m90 *1 602.295,814.17 pfet_05v0
XM_2771 n_I3922 n_I3917 n_I3918 VDD_DEC pfet_05v0 L=0.5U W=0.36U AS=0.3456P
+ AD=0.0612P PS=2.64U PD=0.7U
* device instance _2772 m90 *1 601.455,814.17 pfet_05v0
XM_2772 n_I3922 n_I3917 VDD_DEC VDD_DEC pfet_05v0 L=0.5U W=0.36U AS=0.379P
+ AD=0.0612P PS=2.37U PD=0.7U
* device instance _2773 m90 *1 599.805,813.85 pfet_05v0
XM_2773 n_I2252 n_I3918 VDD_DEC VDD_DEC pfet_05v0 L=0.5U W=1.22U AS=0.379P
+ AD=0.5368P PS=2.37U PD=3.32U
* device instance _2774 m90 *1 606.535,814.28 pfet_05v0
XM_2774 VDD_DEC n_I2338 n_I3916 VDD_DEC pfet_05v0 L=0.5U W=0.36U AS=0.3852P
+ AD=0.1116P PS=2.86U PD=0.98U
* device instance _2775 m90 *1 605.415,814.28 pfet_05v0
XM_2775 n_I3921 n_I3916 VDD_DEC VDD_DEC pfet_05v0 L=0.5U W=0.36U AS=0.1116P
+ AD=0.0612P PS=0.98U PD=0.7U
* device instance _2776 m90 *1 604.575,814.28 pfet_05v0
XM_2776 n_I3921 n_I3916 n_I3917 VDD_DEC pfet_05v0 L=0.5U W=0.36U AS=0.3852P
+ AD=0.0612P PS=2.86U PD=0.7U
* device instance _2777 m90 *1 602.245,811.402 nfet_05v0
XM_2777 n_I3920 n_I3917 n_I3918 VSS nfet_05v0 L=0.6U W=0.365U AS=0.3705P
+ AD=0.0438P PS=2.77U PD=0.605U
* device instance _2778 m90 *1 601.405,811.402 nfet_05v0
XM_2778 VSS n_I3917 n_I3920 VSS nfet_05v0 L=0.6U W=0.365U AS=0.0438P
+ AD=0.282625P PS=0.605U PD=1.87U
* device instance _2779 m90 *1 599.755,811.63 nfet_05v0
XM_2779 n_I2252 n_I3918 VSS VSS nfet_05v0 L=0.6U W=0.82U AS=0.282625P AD=0.3608P
+ PS=1.87U PD=2.52U
* device instance _2780 m90 *1 606.485,811.4 nfet_05v0
XM_2780 VSS n_I2338 n_I3916 VSS nfet_05v0 L=0.6U W=0.36U AS=0.333P AD=0.0936P
+ PS=2.57U PD=0.88U
* device instance _2781 m90 *1 605.365,811.4 nfet_05v0
XM_2781 n_I3919 n_I3916 VSS VSS nfet_05v0 L=0.6U W=0.36U AS=0.0936P AD=0.0432P
+ PS=0.88U PD=0.6U
* device instance _2782 m90 *1 604.525,811.4 nfet_05v0
XM_2782 n_I3917 n_I3916 n_I3919 VSS nfet_05v0 L=0.6U W=0.36U AS=0.0432P
+ AD=0.369P PS=0.6U PD=2.77U
* device instance _2783 m90 *1 532.855,790.65 pfet_05v0
XM_2783 n_I3929 n_I3924 n_I3925 VDD_DEC pfet_05v0 L=0.5U W=0.36U AS=0.3456P
+ AD=0.0612P PS=2.64U PD=0.7U
* device instance _2784 m90 *1 532.015,790.65 pfet_05v0
XM_2784 n_I3929 n_I3924 VDD_DEC VDD_DEC pfet_05v0 L=0.5U W=0.36U AS=0.379P
+ AD=0.0612P PS=2.37U PD=0.7U
* device instance _2785 m90 *1 530.365,790.33 pfet_05v0
XM_2785 n_I2199 n_I3925 VDD_DEC VDD_DEC pfet_05v0 L=0.5U W=1.22U AS=0.379P
+ AD=0.5368P PS=2.37U PD=3.32U
* device instance _2786 m90 *1 537.095,790.76 pfet_05v0
XM_2786 VDD_DEC n_I2332 n_I3923 VDD_DEC pfet_05v0 L=0.5U W=0.36U AS=0.3852P
+ AD=0.1116P PS=2.86U PD=0.98U
* device instance _2787 m90 *1 535.975,790.76 pfet_05v0
XM_2787 n_I3928 n_I3923 VDD_DEC VDD_DEC pfet_05v0 L=0.5U W=0.36U AS=0.1116P
+ AD=0.0612P PS=0.98U PD=0.7U
* device instance _2788 m90 *1 535.135,790.76 pfet_05v0
XM_2788 n_I3928 n_I3923 n_I3924 VDD_DEC pfet_05v0 L=0.5U W=0.36U AS=0.3852P
+ AD=0.0612P PS=2.86U PD=0.7U
* device instance _2789 m90 *1 532.805,787.882 nfet_05v0
XM_2789 n_I3927 n_I3924 n_I3925 VSS nfet_05v0 L=0.6U W=0.365U AS=0.3705P
+ AD=0.0438P PS=2.77U PD=0.605U
* device instance _2790 m90 *1 531.965,787.882 nfet_05v0
XM_2790 VSS n_I3924 n_I3927 VSS nfet_05v0 L=0.6U W=0.365U AS=0.0438P
+ AD=0.282625P PS=0.605U PD=1.87U
* device instance _2791 m90 *1 530.315,788.11 nfet_05v0
XM_2791 n_I2199 n_I3925 VSS VSS nfet_05v0 L=0.6U W=0.82U AS=0.282625P AD=0.3608P
+ PS=1.87U PD=2.52U
* device instance _2792 m90 *1 537.045,787.88 nfet_05v0
XM_2792 VSS n_I2332 n_I3923 VSS nfet_05v0 L=0.6U W=0.36U AS=0.333P AD=0.0936P
+ PS=2.57U PD=0.88U
* device instance _2793 m90 *1 535.925,787.88 nfet_05v0
XM_2793 n_I3926 n_I3923 VSS VSS nfet_05v0 L=0.6U W=0.36U AS=0.0936P AD=0.0432P
+ PS=0.88U PD=0.6U
* device instance _2794 m90 *1 535.085,787.88 nfet_05v0
XM_2794 n_I3924 n_I3923 n_I3926 VSS nfet_05v0 L=0.6U W=0.36U AS=0.0432P
+ AD=0.369P PS=0.6U PD=2.77U
* device instance _2795 m90 *1 642.055,814.17 pfet_05v0
XM_2795 n_I3936 n_I3931 n_I3932 VDD_DEC pfet_05v0 L=0.5U W=0.36U AS=0.3456P
+ AD=0.0612P PS=2.64U PD=0.7U
* device instance _2796 m90 *1 641.215,814.17 pfet_05v0
XM_2796 n_I3936 n_I3931 VDD_DEC VDD_DEC pfet_05v0 L=0.5U W=0.36U AS=0.379P
+ AD=0.0612P PS=2.37U PD=0.7U
* device instance _2797 m90 *1 639.565,813.85 pfet_05v0
XM_2797 n_I2288 n_I3932 VDD_DEC VDD_DEC pfet_05v0 L=0.5U W=1.22U AS=0.379P
+ AD=0.5368P PS=2.37U PD=3.32U
* device instance _2798 m90 *1 646.295,814.28 pfet_05v0
XM_2798 VDD_DEC n_I2337 n_I3930 VDD_DEC pfet_05v0 L=0.5U W=0.36U AS=0.3852P
+ AD=0.1116P PS=2.86U PD=0.98U
* device instance _2799 m90 *1 645.175,814.28 pfet_05v0
XM_2799 n_I3935 n_I3930 VDD_DEC VDD_DEC pfet_05v0 L=0.5U W=0.36U AS=0.1116P
+ AD=0.0612P PS=0.98U PD=0.7U
* device instance _2800 m90 *1 644.335,814.28 pfet_05v0
XM_2800 n_I3935 n_I3930 n_I3931 VDD_DEC pfet_05v0 L=0.5U W=0.36U AS=0.3852P
+ AD=0.0612P PS=2.86U PD=0.7U
* device instance _2801 m90 *1 642.005,811.402 nfet_05v0
XM_2801 n_I3934 n_I3931 n_I3932 VSS nfet_05v0 L=0.6U W=0.365U AS=0.3705P
+ AD=0.0438P PS=2.77U PD=0.605U
* device instance _2802 m90 *1 641.165,811.402 nfet_05v0
XM_2802 VSS n_I3931 n_I3934 VSS nfet_05v0 L=0.6U W=0.365U AS=0.0438P
+ AD=0.282625P PS=0.605U PD=1.87U
* device instance _2803 m90 *1 639.515,811.63 nfet_05v0
XM_2803 n_I2288 n_I3932 VSS VSS nfet_05v0 L=0.6U W=0.82U AS=0.282625P AD=0.3608P
+ PS=1.87U PD=2.52U
* device instance _2804 m90 *1 646.245,811.4 nfet_05v0
XM_2804 VSS n_I2337 n_I3930 VSS nfet_05v0 L=0.6U W=0.36U AS=0.333P AD=0.0936P
+ PS=2.57U PD=0.88U
* device instance _2805 m90 *1 645.125,811.4 nfet_05v0
XM_2805 n_I3933 n_I3930 VSS VSS nfet_05v0 L=0.6U W=0.36U AS=0.0936P AD=0.0432P
+ PS=0.88U PD=0.6U
* device instance _2806 m90 *1 644.285,811.4 nfet_05v0
XM_2806 n_I3931 n_I3930 n_I3933 VSS nfet_05v0 L=0.6U W=0.36U AS=0.0432P
+ AD=0.369P PS=0.6U PD=2.77U
* device instance _2807 m90 *1 604.535,822.01 pfet_05v0
XM_2807 n_I3943 n_I3938 n_I3939 VDD_DEC pfet_05v0 L=0.5U W=0.36U AS=0.3456P
+ AD=0.0612P PS=2.64U PD=0.7U
* device instance _2808 m90 *1 603.695,822.01 pfet_05v0
XM_2808 n_I3943 n_I3938 VDD_DEC VDD_DEC pfet_05v0 L=0.5U W=0.36U AS=0.379P
+ AD=0.0612P PS=2.37U PD=0.7U
* device instance _2809 m90 *1 602.045,821.69 pfet_05v0
XM_2809 n_I2338 n_I3939 VDD_DEC VDD_DEC pfet_05v0 L=0.5U W=1.22U AS=0.379P
+ AD=0.5368P PS=2.37U PD=3.32U
* device instance _2810 m90 *1 608.775,822.12 pfet_05v0
XM_2810 VDD_DEC n_I2175 n_I3937 VDD_DEC pfet_05v0 L=0.5U W=0.36U AS=0.3852P
+ AD=0.1116P PS=2.86U PD=0.98U
* device instance _2811 m90 *1 607.655,822.12 pfet_05v0
XM_2811 n_I3942 n_I3937 VDD_DEC VDD_DEC pfet_05v0 L=0.5U W=0.36U AS=0.1116P
+ AD=0.0612P PS=0.98U PD=0.7U
* device instance _2812 m90 *1 606.815,822.12 pfet_05v0
XM_2812 n_I3942 n_I3937 n_I3938 VDD_DEC pfet_05v0 L=0.5U W=0.36U AS=0.3852P
+ AD=0.0612P PS=2.86U PD=0.7U
* device instance _2813 m90 *1 604.485,819.242 nfet_05v0
XM_2813 n_I3941 n_I3938 n_I3939 VSS nfet_05v0 L=0.6U W=0.365U AS=0.3705P
+ AD=0.0438P PS=2.77U PD=0.605U
* device instance _2814 m90 *1 603.645,819.242 nfet_05v0
XM_2814 VSS n_I3938 n_I3941 VSS nfet_05v0 L=0.6U W=0.365U AS=0.0438P
+ AD=0.282625P PS=0.605U PD=1.87U
* device instance _2815 m90 *1 601.995,819.47 nfet_05v0
XM_2815 n_I2338 n_I3939 VSS VSS nfet_05v0 L=0.6U W=0.82U AS=0.282625P AD=0.3608P
+ PS=1.87U PD=2.52U
* device instance _2816 m90 *1 608.725,819.24 nfet_05v0
XM_2816 VSS n_I2175 n_I3937 VSS nfet_05v0 L=0.6U W=0.36U AS=0.333P AD=0.0936P
+ PS=2.57U PD=0.88U
* device instance _2817 m90 *1 607.605,819.24 nfet_05v0
XM_2817 n_I3940 n_I3937 VSS VSS nfet_05v0 L=0.6U W=0.36U AS=0.0936P AD=0.0432P
+ PS=0.88U PD=0.6U
* device instance _2818 m90 *1 606.765,819.24 nfet_05v0
XM_2818 n_I3938 n_I3937 n_I3940 VSS nfet_05v0 L=0.6U W=0.36U AS=0.0432P
+ AD=0.369P PS=0.6U PD=2.77U
* device instance _2819 m90 *1 563.655,814.17 pfet_05v0
XM_2819 n_I3950 n_I3945 n_I3946 VDD_DEC pfet_05v0 L=0.5U W=0.36U AS=0.3456P
+ AD=0.0612P PS=2.64U PD=0.7U
* device instance _2820 m90 *1 562.815,814.17 pfet_05v0
XM_2820 n_I3950 n_I3945 VDD_DEC VDD_DEC pfet_05v0 L=0.5U W=0.36U AS=0.379P
+ AD=0.0612P PS=2.37U PD=0.7U
* device instance _2821 m90 *1 561.165,813.85 pfet_05v0
XM_2821 n_I2202 n_I3946 VDD_DEC VDD_DEC pfet_05v0 L=0.5U W=1.22U AS=0.379P
+ AD=0.5368P PS=2.37U PD=3.32U
* device instance _2822 m90 *1 567.895,814.28 pfet_05v0
XM_2822 VDD_DEC n_I2206 n_I3944 VDD_DEC pfet_05v0 L=0.5U W=0.36U AS=0.3852P
+ AD=0.1116P PS=2.86U PD=0.98U
* device instance _2823 m90 *1 566.775,814.28 pfet_05v0
XM_2823 n_I3949 n_I3944 VDD_DEC VDD_DEC pfet_05v0 L=0.5U W=0.36U AS=0.1116P
+ AD=0.0612P PS=0.98U PD=0.7U
* device instance _2824 m90 *1 565.935,814.28 pfet_05v0
XM_2824 n_I3949 n_I3944 n_I3945 VDD_DEC pfet_05v0 L=0.5U W=0.36U AS=0.3852P
+ AD=0.0612P PS=2.86U PD=0.7U
* device instance _2825 m90 *1 563.605,811.402 nfet_05v0
XM_2825 n_I3948 n_I3945 n_I3946 VSS nfet_05v0 L=0.6U W=0.365U AS=0.3705P
+ AD=0.0438P PS=2.77U PD=0.605U
* device instance _2826 m90 *1 562.765,811.402 nfet_05v0
XM_2826 VSS n_I3945 n_I3948 VSS nfet_05v0 L=0.6U W=0.365U AS=0.0438P
+ AD=0.282625P PS=0.605U PD=1.87U
* device instance _2827 m90 *1 561.115,811.63 nfet_05v0
XM_2827 n_I2202 n_I3946 VSS VSS nfet_05v0 L=0.6U W=0.82U AS=0.282625P AD=0.3608P
+ PS=1.87U PD=2.52U
* device instance _2828 m90 *1 567.845,811.4 nfet_05v0
XM_2828 VSS n_I2206 n_I3944 VSS nfet_05v0 L=0.6U W=0.36U AS=0.333P AD=0.0936P
+ PS=2.57U PD=0.88U
* device instance _2829 m90 *1 566.725,811.4 nfet_05v0
XM_2829 n_I3947 n_I3944 VSS VSS nfet_05v0 L=0.6U W=0.36U AS=0.0936P AD=0.0432P
+ PS=0.88U PD=0.6U
* device instance _2830 m90 *1 565.885,811.4 nfet_05v0
XM_2830 n_I3945 n_I3944 n_I3947 VSS nfet_05v0 L=0.6U W=0.36U AS=0.0432P
+ AD=0.369P PS=0.6U PD=2.77U
* device instance _2831 m90 *1 555.255,798.49 pfet_05v0
XM_2831 n_I3957 n_I3952 n_I3953 VDD_DEC pfet_05v0 L=0.5U W=0.36U AS=0.3456P
+ AD=0.0612P PS=2.64U PD=0.7U
* device instance _2832 m90 *1 554.415,798.49 pfet_05v0
XM_2832 n_I3957 n_I3952 VDD_DEC VDD_DEC pfet_05v0 L=0.5U W=0.36U AS=0.379P
+ AD=0.0612P PS=2.37U PD=0.7U
* device instance _2833 m90 *1 552.765,798.17 pfet_05v0
XM_2833 n_I2359 n_I3953 VDD_DEC VDD_DEC pfet_05v0 L=0.5U W=1.22U AS=0.379P
+ AD=0.5368P PS=2.37U PD=3.32U
* device instance _2834 m90 *1 559.495,798.6 pfet_05v0
XM_2834 VDD_DEC n_I2203 n_I3951 VDD_DEC pfet_05v0 L=0.5U W=0.36U AS=0.3852P
+ AD=0.1116P PS=2.86U PD=0.98U
* device instance _2835 m90 *1 558.375,798.6 pfet_05v0
XM_2835 n_I3956 n_I3951 VDD_DEC VDD_DEC pfet_05v0 L=0.5U W=0.36U AS=0.1116P
+ AD=0.0612P PS=0.98U PD=0.7U
* device instance _2836 m90 *1 557.535,798.6 pfet_05v0
XM_2836 n_I3956 n_I3951 n_I3952 VDD_DEC pfet_05v0 L=0.5U W=0.36U AS=0.3852P
+ AD=0.0612P PS=2.86U PD=0.7U
* device instance _2837 m90 *1 555.205,795.722 nfet_05v0
XM_2837 n_I3955 n_I3952 n_I3953 VSS nfet_05v0 L=0.6U W=0.365U AS=0.3705P
+ AD=0.0438P PS=2.77U PD=0.605U
* device instance _2838 m90 *1 554.365,795.722 nfet_05v0
XM_2838 VSS n_I3952 n_I3955 VSS nfet_05v0 L=0.6U W=0.365U AS=0.0438P
+ AD=0.282625P PS=0.605U PD=1.87U
* device instance _2839 m90 *1 552.715,795.95 nfet_05v0
XM_2839 n_I2359 n_I3953 VSS VSS nfet_05v0 L=0.6U W=0.82U AS=0.282625P AD=0.3608P
+ PS=1.87U PD=2.52U
* device instance _2840 m90 *1 559.445,795.72 nfet_05v0
XM_2840 VSS n_I2203 n_I3951 VSS nfet_05v0 L=0.6U W=0.36U AS=0.333P AD=0.0936P
+ PS=2.57U PD=0.88U
* device instance _2841 m90 *1 558.325,795.72 nfet_05v0
XM_2841 n_I3954 n_I3951 VSS VSS nfet_05v0 L=0.6U W=0.36U AS=0.0936P AD=0.0432P
+ PS=0.88U PD=0.6U
* device instance _2842 m90 *1 557.485,795.72 nfet_05v0
XM_2842 n_I3952 n_I3951 n_I3954 VSS nfet_05v0 L=0.6U W=0.36U AS=0.0432P
+ AD=0.369P PS=0.6U PD=2.77U
* device instance _2843 m90 *1 561.415,790.65 pfet_05v0
XM_2843 n_I3964 n_I3959 n_I3960 VDD_DEC pfet_05v0 L=0.5U W=0.36U AS=0.3456P
+ AD=0.0612P PS=2.64U PD=0.7U
* device instance _2844 m90 *1 560.575,790.65 pfet_05v0
XM_2844 n_I3964 n_I3959 VDD_DEC VDD_DEC pfet_05v0 L=0.5U W=0.36U AS=0.379P
+ AD=0.0612P PS=2.37U PD=0.7U
* device instance _2845 m90 *1 558.925,790.33 pfet_05v0
XM_2845 n_153 n_I3960 VDD_DEC VDD_DEC pfet_05v0 L=0.5U W=1.22U AS=0.379P
+ AD=0.5368P PS=2.37U PD=3.32U
* device instance _2846 m90 *1 565.655,790.76 pfet_05v0
XM_2846 VDD_DEC n_I2163 n_I3958 VDD_DEC pfet_05v0 L=0.5U W=0.36U AS=0.3852P
+ AD=0.1116P PS=2.86U PD=0.98U
* device instance _2847 m90 *1 564.535,790.76 pfet_05v0
XM_2847 n_I3963 n_I3958 VDD_DEC VDD_DEC pfet_05v0 L=0.5U W=0.36U AS=0.1116P
+ AD=0.0612P PS=0.98U PD=0.7U
* device instance _2848 m90 *1 563.695,790.76 pfet_05v0
XM_2848 n_I3963 n_I3958 n_I3959 VDD_DEC pfet_05v0 L=0.5U W=0.36U AS=0.3852P
+ AD=0.0612P PS=2.86U PD=0.7U
* device instance _2849 m90 *1 561.365,787.882 nfet_05v0
XM_2849 n_I3962 n_I3959 n_I3960 VSS nfet_05v0 L=0.6U W=0.365U AS=0.3705P
+ AD=0.0438P PS=2.77U PD=0.605U
* device instance _2850 m90 *1 560.525,787.882 nfet_05v0
XM_2850 VSS n_I3959 n_I3962 VSS nfet_05v0 L=0.6U W=0.365U AS=0.0438P
+ AD=0.282625P PS=0.605U PD=1.87U
* device instance _2851 m90 *1 558.875,788.11 nfet_05v0
XM_2851 n_153 n_I3960 VSS VSS nfet_05v0 L=0.6U W=0.82U AS=0.282625P AD=0.3608P
+ PS=1.87U PD=2.52U
* device instance _2852 m90 *1 565.605,787.88 nfet_05v0
XM_2852 VSS n_I2163 n_I3958 VSS nfet_05v0 L=0.6U W=0.36U AS=0.333P AD=0.0936P
+ PS=2.57U PD=0.88U
* device instance _2853 m90 *1 564.485,787.88 nfet_05v0
XM_2853 n_I3961 n_I3958 VSS VSS nfet_05v0 L=0.6U W=0.36U AS=0.0936P AD=0.0432P
+ PS=0.88U PD=0.6U
* device instance _2854 m90 *1 563.645,787.88 nfet_05v0
XM_2854 n_I3959 n_I3958 n_I3961 VSS nfet_05v0 L=0.6U W=0.36U AS=0.0432P
+ AD=0.369P PS=0.6U PD=2.77U
* device instance _2855 m90 *1 637.575,806.33 pfet_05v0
XM_2855 n_I3971 n_I3966 n_I3967 VDD_DEC pfet_05v0 L=0.5U W=0.36U AS=0.3456P
+ AD=0.0612P PS=2.64U PD=0.7U
* device instance _2856 m90 *1 636.735,806.33 pfet_05v0
XM_2856 n_I3971 n_I3966 VDD_DEC VDD_DEC pfet_05v0 L=0.5U W=0.36U AS=0.379P
+ AD=0.0612P PS=2.37U PD=0.7U
* device instance _2857 m90 *1 635.085,806.01 pfet_05v0
XM_2857 n_I2240 n_I3967 VDD_DEC VDD_DEC pfet_05v0 L=0.5U W=1.22U AS=0.379P
+ AD=0.5368P PS=2.37U PD=3.32U
* device instance _2858 m90 *1 641.815,806.44 pfet_05v0
XM_2858 VDD_DEC n_I2288 n_I3965 VDD_DEC pfet_05v0 L=0.5U W=0.36U AS=0.3852P
+ AD=0.1116P PS=2.86U PD=0.98U
* device instance _2859 m90 *1 640.695,806.44 pfet_05v0
XM_2859 n_I3970 n_I3965 VDD_DEC VDD_DEC pfet_05v0 L=0.5U W=0.36U AS=0.1116P
+ AD=0.0612P PS=0.98U PD=0.7U
* device instance _2860 m90 *1 639.855,806.44 pfet_05v0
XM_2860 n_I3970 n_I3965 n_I3966 VDD_DEC pfet_05v0 L=0.5U W=0.36U AS=0.3852P
+ AD=0.0612P PS=2.86U PD=0.7U
* device instance _2861 m90 *1 637.525,803.562 nfet_05v0
XM_2861 n_I3969 n_I3966 n_I3967 VSS nfet_05v0 L=0.6U W=0.365U AS=0.3705P
+ AD=0.0438P PS=2.77U PD=0.605U
* device instance _2862 m90 *1 636.685,803.562 nfet_05v0
XM_2862 VSS n_I3966 n_I3969 VSS nfet_05v0 L=0.6U W=0.365U AS=0.0438P
+ AD=0.282625P PS=0.605U PD=1.87U
* device instance _2863 m90 *1 635.035,803.79 nfet_05v0
XM_2863 n_I2240 n_I3967 VSS VSS nfet_05v0 L=0.6U W=0.82U AS=0.282625P AD=0.3608P
+ PS=1.87U PD=2.52U
* device instance _2864 m90 *1 641.765,803.56 nfet_05v0
XM_2864 VSS n_I2288 n_I3965 VSS nfet_05v0 L=0.6U W=0.36U AS=0.333P AD=0.0936P
+ PS=2.57U PD=0.88U
* device instance _2865 m90 *1 640.645,803.56 nfet_05v0
XM_2865 n_I3968 n_I3965 VSS VSS nfet_05v0 L=0.6U W=0.36U AS=0.0936P AD=0.0432P
+ PS=0.88U PD=0.6U
* device instance _2866 m90 *1 639.805,803.56 nfet_05v0
XM_2866 n_I3966 n_I3965 n_I3968 VSS nfet_05v0 L=0.6U W=0.36U AS=0.0432P
+ AD=0.369P PS=0.6U PD=2.77U
* device instance _2867 m90 *1 586.615,837.69 pfet_05v0
XM_2867 n_I3978 n_I3973 n_I3974 VDD_DEC pfet_05v0 L=0.5U W=0.36U AS=0.3456P
+ AD=0.0612P PS=2.64U PD=0.7U
* device instance _2868 m90 *1 585.775,837.69 pfet_05v0
XM_2868 n_I3978 n_I3973 VDD_DEC VDD_DEC pfet_05v0 L=0.5U W=0.36U AS=0.379P
+ AD=0.0612P PS=2.37U PD=0.7U
* device instance _2869 m90 *1 584.125,837.37 pfet_05v0
XM_2869 n_I2334 n_I3974 VDD_DEC VDD_DEC pfet_05v0 L=0.5U W=1.22U AS=0.379P
+ AD=0.5368P PS=2.37U PD=3.32U
* device instance _2870 m90 *1 590.855,837.8 pfet_05v0
XM_2870 VDD_DEC D[3] n_I3972 VDD_DEC pfet_05v0 L=0.5U W=0.36U AS=0.3852P
+ AD=0.1116P PS=2.86U PD=0.98U
* device instance _2871 m90 *1 589.735,837.8 pfet_05v0
XM_2871 n_I3977 n_I3972 VDD_DEC VDD_DEC pfet_05v0 L=0.5U W=0.36U AS=0.1116P
+ AD=0.0612P PS=0.98U PD=0.7U
* device instance _2872 m90 *1 588.895,837.8 pfet_05v0
XM_2872 n_I3977 n_I3972 n_I3973 VDD_DEC pfet_05v0 L=0.5U W=0.36U AS=0.3852P
+ AD=0.0612P PS=2.86U PD=0.7U
* device instance _2873 m90 *1 586.565,834.922 nfet_05v0
XM_2873 n_I3976 n_I3973 n_I3974 VSS nfet_05v0 L=0.6U W=0.365U AS=0.3705P
+ AD=0.0438P PS=2.77U PD=0.605U
* device instance _2874 m90 *1 585.725,834.922 nfet_05v0
XM_2874 VSS n_I3973 n_I3976 VSS nfet_05v0 L=0.6U W=0.365U AS=0.0438P
+ AD=0.282625P PS=0.605U PD=1.87U
* device instance _2875 m90 *1 584.075,835.15 nfet_05v0
XM_2875 n_I2334 n_I3974 VSS VSS nfet_05v0 L=0.6U W=0.82U AS=0.282625P AD=0.3608P
+ PS=1.87U PD=2.52U
* device instance _2876 m90 *1 590.805,834.92 nfet_05v0
XM_2876 VSS D[3] n_I3972 VSS nfet_05v0 L=0.6U W=0.36U AS=0.333P AD=0.0936P
+ PS=2.57U PD=0.88U
* device instance _2877 m90 *1 589.685,834.92 nfet_05v0
XM_2877 n_I3975 n_I3972 VSS VSS nfet_05v0 L=0.6U W=0.36U AS=0.0936P AD=0.0432P
+ PS=0.88U PD=0.6U
* device instance _2878 m90 *1 588.845,834.92 nfet_05v0
XM_2878 n_I3973 n_I3972 n_I3975 VSS nfet_05v0 L=0.6U W=0.36U AS=0.0432P
+ AD=0.369P PS=0.6U PD=2.77U
* device instance _2879 m0 *1 650.025,791.91 pfet_05v0
XM_2879 n_I3985 n_I3980 n_I3981 VDD_DEC pfet_05v0 L=0.5U W=0.36U AS=0.3456P
+ AD=0.0612P PS=2.64U PD=0.7U
* device instance _2880 m0 *1 650.865,791.91 pfet_05v0
XM_2880 n_I3985 n_I3980 VDD_DEC VDD_DEC pfet_05v0 L=0.5U W=0.36U AS=0.379P
+ AD=0.0612P PS=2.37U PD=0.7U
* device instance _2881 m0 *1 652.515,792.23 pfet_05v0
XM_2881 n_I2242 n_I3981 VDD_DEC VDD_DEC pfet_05v0 L=0.5U W=1.22U AS=0.379P
+ AD=0.5368P PS=2.37U PD=3.32U
* device instance _2882 m0 *1 645.785,791.8 pfet_05v0
XM_2882 VDD_DEC n_I2207 n_I3979 VDD_DEC pfet_05v0 L=0.5U W=0.36U AS=0.3852P
+ AD=0.1116P PS=2.86U PD=0.98U
* device instance _2883 m0 *1 646.905,791.8 pfet_05v0
XM_2883 n_I3984 n_I3979 VDD_DEC VDD_DEC pfet_05v0 L=0.5U W=0.36U AS=0.1116P
+ AD=0.0612P PS=0.98U PD=0.7U
* device instance _2884 m0 *1 647.745,791.8 pfet_05v0
XM_2884 n_I3984 n_I3979 n_I3980 VDD_DEC pfet_05v0 L=0.5U W=0.36U AS=0.3852P
+ AD=0.0612P PS=2.86U PD=0.7U
* device instance _2885 m0 *1 650.075,794.678 nfet_05v0
XM_2885 n_I3983 n_I3980 n_I3981 VSS nfet_05v0 L=0.6U W=0.365U AS=0.3705P
+ AD=0.0438P PS=2.77U PD=0.605U
* device instance _2886 m0 *1 650.915,794.678 nfet_05v0
XM_2886 VSS n_I3980 n_I3983 VSS nfet_05v0 L=0.6U W=0.365U AS=0.0438P
+ AD=0.282625P PS=0.605U PD=1.87U
* device instance _2887 m0 *1 652.565,794.45 nfet_05v0
XM_2887 n_I2242 n_I3981 VSS VSS nfet_05v0 L=0.6U W=0.82U AS=0.282625P AD=0.3608P
+ PS=1.87U PD=2.52U
* device instance _2888 m0 *1 645.835,794.68 nfet_05v0
XM_2888 VSS n_I2207 n_I3979 VSS nfet_05v0 L=0.6U W=0.36U AS=0.333P AD=0.0936P
+ PS=2.57U PD=0.88U
* device instance _2889 m0 *1 646.955,794.68 nfet_05v0
XM_2889 n_I3982 n_I3979 VSS VSS nfet_05v0 L=0.6U W=0.36U AS=0.0936P AD=0.0432P
+ PS=0.88U PD=0.6U
* device instance _2890 m0 *1 647.795,794.68 nfet_05v0
XM_2890 n_I3980 n_I3979 n_I3982 VSS nfet_05v0 L=0.6U W=0.36U AS=0.0432P
+ AD=0.369P PS=0.6U PD=2.77U
* device instance _2891 m0 *1 639.945,791.91 pfet_05v0
XM_2891 n_I3992 n_I3987 n_I3988 VDD_DEC pfet_05v0 L=0.5U W=0.36U AS=0.3456P
+ AD=0.0612P PS=2.64U PD=0.7U
* device instance _2892 m0 *1 640.785,791.91 pfet_05v0
XM_2892 n_I3992 n_I3987 VDD_DEC VDD_DEC pfet_05v0 L=0.5U W=0.36U AS=0.379P
+ AD=0.0612P PS=2.37U PD=0.7U
* device instance _2893 m0 *1 642.435,792.23 pfet_05v0
XM_2893 n_I2140 n_I3988 VDD_DEC VDD_DEC pfet_05v0 L=0.5U W=1.22U AS=0.379P
+ AD=0.5368P PS=2.37U PD=3.32U
* device instance _2894 m0 *1 635.705,791.8 pfet_05v0
XM_2894 VDD_DEC n_I2214 n_I3986 VDD_DEC pfet_05v0 L=0.5U W=0.36U AS=0.3852P
+ AD=0.1116P PS=2.86U PD=0.98U
* device instance _2895 m0 *1 636.825,791.8 pfet_05v0
XM_2895 n_I3991 n_I3986 VDD_DEC VDD_DEC pfet_05v0 L=0.5U W=0.36U AS=0.1116P
+ AD=0.0612P PS=0.98U PD=0.7U
* device instance _2896 m0 *1 637.665,791.8 pfet_05v0
XM_2896 n_I3991 n_I3986 n_I3987 VDD_DEC pfet_05v0 L=0.5U W=0.36U AS=0.3852P
+ AD=0.0612P PS=2.86U PD=0.7U
* device instance _2897 m0 *1 639.995,794.678 nfet_05v0
XM_2897 n_I3990 n_I3987 n_I3988 VSS nfet_05v0 L=0.6U W=0.365U AS=0.3705P
+ AD=0.0438P PS=2.77U PD=0.605U
* device instance _2898 m0 *1 640.835,794.678 nfet_05v0
XM_2898 VSS n_I3987 n_I3990 VSS nfet_05v0 L=0.6U W=0.365U AS=0.0438P
+ AD=0.282625P PS=0.605U PD=1.87U
* device instance _2899 m0 *1 642.485,794.45 nfet_05v0
XM_2899 n_I2140 n_I3988 VSS VSS nfet_05v0 L=0.6U W=0.82U AS=0.282625P AD=0.3608P
+ PS=1.87U PD=2.52U
* device instance _2900 m0 *1 635.755,794.68 nfet_05v0
XM_2900 VSS n_I2214 n_I3986 VSS nfet_05v0 L=0.6U W=0.36U AS=0.333P AD=0.0936P
+ PS=2.57U PD=0.88U
* device instance _2901 m0 *1 636.875,794.68 nfet_05v0
XM_2901 n_I3989 n_I3986 VSS VSS nfet_05v0 L=0.6U W=0.36U AS=0.0936P AD=0.0432P
+ PS=0.88U PD=0.6U
* device instance _2902 m0 *1 637.715,794.68 nfet_05v0
XM_2902 n_I3987 n_I3986 n_I3989 VSS nfet_05v0 L=0.6U W=0.36U AS=0.0432P
+ AD=0.369P PS=0.6U PD=2.77U
* device instance _2903 m0 *1 561.545,776.23 pfet_05v0
XM_2903 n_I3999 n_I3994 n_I3995 VDD_DEC pfet_05v0 L=0.5U W=0.36U AS=0.3456P
+ AD=0.0612P PS=2.64U PD=0.7U
* device instance _2904 m0 *1 562.385,776.23 pfet_05v0
XM_2904 n_I3999 n_I3994 VDD_DEC VDD_DEC pfet_05v0 L=0.5U W=0.36U AS=0.379P
+ AD=0.0612P PS=2.37U PD=0.7U
* device instance _2905 m0 *1 564.035,776.55 pfet_05v0
XM_2905 n_171 n_I3995 VDD_DEC VDD_DEC pfet_05v0 L=0.5U W=1.22U AS=0.379P
+ AD=0.5368P PS=2.37U PD=3.32U
* device instance _2906 m0 *1 557.305,776.12 pfet_05v0
XM_2906 VDD_DEC n_I2063 n_I3993 VDD_DEC pfet_05v0 L=0.5U W=0.36U AS=0.3852P
+ AD=0.1116P PS=2.86U PD=0.98U
* device instance _2907 m0 *1 558.425,776.12 pfet_05v0
XM_2907 n_I3998 n_I3993 VDD_DEC VDD_DEC pfet_05v0 L=0.5U W=0.36U AS=0.1116P
+ AD=0.0612P PS=0.98U PD=0.7U
* device instance _2908 m0 *1 559.265,776.12 pfet_05v0
XM_2908 n_I3998 n_I3993 n_I3994 VDD_DEC pfet_05v0 L=0.5U W=0.36U AS=0.3852P
+ AD=0.0612P PS=2.86U PD=0.7U
* device instance _2909 m0 *1 561.595,778.998 nfet_05v0
XM_2909 n_I3997 n_I3994 n_I3995 VSS nfet_05v0 L=0.6U W=0.365U AS=0.3705P
+ AD=0.0438P PS=2.77U PD=0.605U
* device instance _2910 m0 *1 562.435,778.998 nfet_05v0
XM_2910 VSS n_I3994 n_I3997 VSS nfet_05v0 L=0.6U W=0.365U AS=0.0438P
+ AD=0.282625P PS=0.605U PD=1.87U
* device instance _2911 m0 *1 564.085,778.77 nfet_05v0
XM_2911 n_171 n_I3995 VSS VSS nfet_05v0 L=0.6U W=0.82U AS=0.282625P AD=0.3608P
+ PS=1.87U PD=2.52U
* device instance _2912 m0 *1 557.355,779 nfet_05v0
XM_2912 VSS n_I2063 n_I3993 VSS nfet_05v0 L=0.6U W=0.36U AS=0.333P AD=0.0936P
+ PS=2.57U PD=0.88U
* device instance _2913 m0 *1 558.475,779 nfet_05v0
XM_2913 n_I3996 n_I3993 VSS VSS nfet_05v0 L=0.6U W=0.36U AS=0.0936P AD=0.0432P
+ PS=0.88U PD=0.6U
* device instance _2914 m0 *1 559.315,779 nfet_05v0
XM_2914 n_I3994 n_I3993 n_I3996 VSS nfet_05v0 L=0.6U W=0.36U AS=0.0432P
+ AD=0.369P PS=0.6U PD=2.77U
* device instance _2915 m0 *1 573.305,776.23 pfet_05v0
XM_2915 n_I4006 n_I4001 n_I4002 VDD_DEC pfet_05v0 L=0.5U W=0.36U AS=0.3456P
+ AD=0.0612P PS=2.64U PD=0.7U
* device instance _2916 m0 *1 574.145,776.23 pfet_05v0
XM_2916 n_I4006 n_I4001 VDD_DEC VDD_DEC pfet_05v0 L=0.5U W=0.36U AS=0.379P
+ AD=0.0612P PS=2.37U PD=0.7U
* device instance _2917 m0 *1 575.795,776.55 pfet_05v0
XM_2917 n_192 n_I4002 VDD_DEC VDD_DEC pfet_05v0 L=0.5U W=1.22U AS=0.379P
+ AD=0.5368P PS=2.37U PD=3.32U
* device instance _2918 m0 *1 569.065,776.12 pfet_05v0
XM_2918 VDD_DEC n_I2065 n_I4000 VDD_DEC pfet_05v0 L=0.5U W=0.36U AS=0.3852P
+ AD=0.1116P PS=2.86U PD=0.98U
* device instance _2919 m0 *1 570.185,776.12 pfet_05v0
XM_2919 n_I4005 n_I4000 VDD_DEC VDD_DEC pfet_05v0 L=0.5U W=0.36U AS=0.1116P
+ AD=0.0612P PS=0.98U PD=0.7U
* device instance _2920 m0 *1 571.025,776.12 pfet_05v0
XM_2920 n_I4005 n_I4000 n_I4001 VDD_DEC pfet_05v0 L=0.5U W=0.36U AS=0.3852P
+ AD=0.0612P PS=2.86U PD=0.7U
* device instance _2921 m0 *1 573.355,778.998 nfet_05v0
XM_2921 n_I4004 n_I4001 n_I4002 VSS nfet_05v0 L=0.6U W=0.365U AS=0.3705P
+ AD=0.0438P PS=2.77U PD=0.605U
* device instance _2922 m0 *1 574.195,778.998 nfet_05v0
XM_2922 VSS n_I4001 n_I4004 VSS nfet_05v0 L=0.6U W=0.365U AS=0.0438P
+ AD=0.282625P PS=0.605U PD=1.87U
* device instance _2923 m0 *1 575.845,778.77 nfet_05v0
XM_2923 n_192 n_I4002 VSS VSS nfet_05v0 L=0.6U W=0.82U AS=0.282625P AD=0.3608P
+ PS=1.87U PD=2.52U
* device instance _2924 m0 *1 569.115,779 nfet_05v0
XM_2924 VSS n_I2065 n_I4000 VSS nfet_05v0 L=0.6U W=0.36U AS=0.333P AD=0.0936P
+ PS=2.57U PD=0.88U
* device instance _2925 m0 *1 570.235,779 nfet_05v0
XM_2925 n_I4003 n_I4000 VSS VSS nfet_05v0 L=0.6U W=0.36U AS=0.0936P AD=0.0432P
+ PS=0.88U PD=0.6U
* device instance _2926 m0 *1 571.075,779 nfet_05v0
XM_2926 n_I4001 n_I4000 n_I4003 VSS nfet_05v0 L=0.6U W=0.36U AS=0.0432P
+ AD=0.369P PS=0.6U PD=2.77U
* device instance _2927 m0 *1 552.585,784.07 pfet_05v0
XM_2927 n_I4013 n_I4008 n_I4009 VDD_DEC pfet_05v0 L=0.5U W=0.36U AS=0.3456P
+ AD=0.0612P PS=2.64U PD=0.7U
* device instance _2928 m0 *1 553.425,784.07 pfet_05v0
XM_2928 n_I4013 n_I4008 VDD_DEC VDD_DEC pfet_05v0 L=0.5U W=0.36U AS=0.379P
+ AD=0.0612P PS=2.37U PD=0.7U
* device instance _2929 m0 *1 555.075,784.39 pfet_05v0
XM_2929 n_191 n_I4009 VDD_DEC VDD_DEC pfet_05v0 L=0.5U W=1.22U AS=0.379P
+ AD=0.5368P PS=2.37U PD=3.32U
* device instance _2930 m0 *1 548.345,783.96 pfet_05v0
XM_2930 VDD_DEC n_I2130 n_I4007 VDD_DEC pfet_05v0 L=0.5U W=0.36U AS=0.3852P
+ AD=0.1116P PS=2.86U PD=0.98U
* device instance _2931 m0 *1 549.465,783.96 pfet_05v0
XM_2931 n_I4012 n_I4007 VDD_DEC VDD_DEC pfet_05v0 L=0.5U W=0.36U AS=0.1116P
+ AD=0.0612P PS=0.98U PD=0.7U
* device instance _2932 m0 *1 550.305,783.96 pfet_05v0
XM_2932 n_I4012 n_I4007 n_I4008 VDD_DEC pfet_05v0 L=0.5U W=0.36U AS=0.3852P
+ AD=0.0612P PS=2.86U PD=0.7U
* device instance _2933 m0 *1 552.635,786.838 nfet_05v0
XM_2933 n_I4011 n_I4008 n_I4009 VSS nfet_05v0 L=0.6U W=0.365U AS=0.3705P
+ AD=0.0438P PS=2.77U PD=0.605U
* device instance _2934 m0 *1 553.475,786.838 nfet_05v0
XM_2934 VSS n_I4008 n_I4011 VSS nfet_05v0 L=0.6U W=0.365U AS=0.0438P
+ AD=0.282625P PS=0.605U PD=1.87U
* device instance _2935 m0 *1 555.125,786.61 nfet_05v0
XM_2935 n_191 n_I4009 VSS VSS nfet_05v0 L=0.6U W=0.82U AS=0.282625P AD=0.3608P
+ PS=1.87U PD=2.52U
* device instance _2936 m0 *1 548.395,786.84 nfet_05v0
XM_2936 VSS n_I2130 n_I4007 VSS nfet_05v0 L=0.6U W=0.36U AS=0.333P AD=0.0936P
+ PS=2.57U PD=0.88U
* device instance _2937 m0 *1 549.515,786.84 nfet_05v0
XM_2937 n_I4010 n_I4007 VSS VSS nfet_05v0 L=0.6U W=0.36U AS=0.0936P AD=0.0432P
+ PS=0.88U PD=0.6U
* device instance _2938 m0 *1 550.355,786.84 nfet_05v0
XM_2938 n_I4008 n_I4007 n_I4010 VSS nfet_05v0 L=0.6U W=0.36U AS=0.0432P
+ AD=0.369P PS=0.6U PD=2.77U
* device instance _2939 m0 *1 628.185,807.59 pfet_05v0
XM_2939 n_I4020 n_I4015 n_I4016 VDD_DEC pfet_05v0 L=0.5U W=0.36U AS=0.3456P
+ AD=0.0612P PS=2.64U PD=0.7U
* device instance _2940 m0 *1 629.025,807.59 pfet_05v0
XM_2940 n_I4020 n_I4015 VDD_DEC VDD_DEC pfet_05v0 L=0.5U W=0.36U AS=0.379P
+ AD=0.0612P PS=2.37U PD=0.7U
* device instance _2941 m0 *1 630.675,807.91 pfet_05v0
XM_2941 n_9 n_I4016 VDD_DEC VDD_DEC pfet_05v0 L=0.5U W=1.22U AS=0.379P
+ AD=0.5368P PS=2.37U PD=3.32U
* device instance _2942 m0 *1 623.945,807.48 pfet_05v0
XM_2942 VDD_DEC n_I2244 n_I4014 VDD_DEC pfet_05v0 L=0.5U W=0.36U AS=0.3852P
+ AD=0.1116P PS=2.86U PD=0.98U
* device instance _2943 m0 *1 625.065,807.48 pfet_05v0
XM_2943 n_I4019 n_I4014 VDD_DEC VDD_DEC pfet_05v0 L=0.5U W=0.36U AS=0.1116P
+ AD=0.0612P PS=0.98U PD=0.7U
* device instance _2944 m0 *1 625.905,807.48 pfet_05v0
XM_2944 n_I4019 n_I4014 n_I4015 VDD_DEC pfet_05v0 L=0.5U W=0.36U AS=0.3852P
+ AD=0.0612P PS=2.86U PD=0.7U
* device instance _2945 m0 *1 628.235,810.358 nfet_05v0
XM_2945 n_I4018 n_I4015 n_I4016 VSS nfet_05v0 L=0.6U W=0.365U AS=0.3705P
+ AD=0.0438P PS=2.77U PD=0.605U
* device instance _2946 m0 *1 629.075,810.358 nfet_05v0
XM_2946 VSS n_I4015 n_I4018 VSS nfet_05v0 L=0.6U W=0.365U AS=0.0438P
+ AD=0.282625P PS=0.605U PD=1.87U
* device instance _2947 m0 *1 630.725,810.13 nfet_05v0
XM_2947 n_9 n_I4016 VSS VSS nfet_05v0 L=0.6U W=0.82U AS=0.282625P AD=0.3608P
+ PS=1.87U PD=2.52U
* device instance _2948 m0 *1 623.995,810.36 nfet_05v0
XM_2948 VSS n_I2244 n_I4014 VSS nfet_05v0 L=0.6U W=0.36U AS=0.333P AD=0.0936P
+ PS=2.57U PD=0.88U
* device instance _2949 m0 *1 625.115,810.36 nfet_05v0
XM_2949 n_I4017 n_I4014 VSS VSS nfet_05v0 L=0.6U W=0.36U AS=0.0936P AD=0.0432P
+ PS=0.88U PD=0.6U
* device instance _2950 m0 *1 625.955,810.36 nfet_05v0
XM_2950 n_I4015 n_I4014 n_I4017 VSS nfet_05v0 L=0.6U W=0.36U AS=0.0432P
+ AD=0.369P PS=0.6U PD=2.77U
* device instance _2951 m0 *1 561.545,784.07 pfet_05v0
XM_2951 n_I4027 n_I4022 n_I4023 VDD_DEC pfet_05v0 L=0.5U W=0.36U AS=0.3456P
+ AD=0.0612P PS=2.64U PD=0.7U
* device instance _2952 m0 *1 562.385,784.07 pfet_05v0
XM_2952 n_I4027 n_I4022 VDD_DEC VDD_DEC pfet_05v0 L=0.5U W=0.36U AS=0.379P
+ AD=0.0612P PS=2.37U PD=0.7U
* device instance _2953 m0 *1 564.035,784.39 pfet_05v0
XM_2953 n_159 n_I4023 VDD_DEC VDD_DEC pfet_05v0 L=0.5U W=1.22U AS=0.379P
+ AD=0.5368P PS=2.37U PD=3.32U
* device instance _2954 m0 *1 557.305,783.96 pfet_05v0
XM_2954 VDD_DEC n_I2131 n_I4021 VDD_DEC pfet_05v0 L=0.5U W=0.36U AS=0.3852P
+ AD=0.1116P PS=2.86U PD=0.98U
* device instance _2955 m0 *1 558.425,783.96 pfet_05v0
XM_2955 n_I4026 n_I4021 VDD_DEC VDD_DEC pfet_05v0 L=0.5U W=0.36U AS=0.1116P
+ AD=0.0612P PS=0.98U PD=0.7U
* device instance _2956 m0 *1 559.265,783.96 pfet_05v0
XM_2956 n_I4026 n_I4021 n_I4022 VDD_DEC pfet_05v0 L=0.5U W=0.36U AS=0.3852P
+ AD=0.0612P PS=2.86U PD=0.7U
* device instance _2957 m0 *1 561.595,786.838 nfet_05v0
XM_2957 n_I4025 n_I4022 n_I4023 VSS nfet_05v0 L=0.6U W=0.365U AS=0.3705P
+ AD=0.0438P PS=2.77U PD=0.605U
* device instance _2958 m0 *1 562.435,786.838 nfet_05v0
XM_2958 VSS n_I4022 n_I4025 VSS nfet_05v0 L=0.6U W=0.365U AS=0.0438P
+ AD=0.282625P PS=0.605U PD=1.87U
* device instance _2959 m0 *1 564.085,786.61 nfet_05v0
XM_2959 n_159 n_I4023 VSS VSS nfet_05v0 L=0.6U W=0.82U AS=0.282625P AD=0.3608P
+ PS=1.87U PD=2.52U
* device instance _2960 m0 *1 557.355,786.84 nfet_05v0
XM_2960 VSS n_I2131 n_I4021 VSS nfet_05v0 L=0.6U W=0.36U AS=0.333P AD=0.0936P
+ PS=2.57U PD=0.88U
* device instance _2961 m0 *1 558.475,786.84 nfet_05v0
XM_2961 n_I4024 n_I4021 VSS VSS nfet_05v0 L=0.6U W=0.36U AS=0.0936P AD=0.0432P
+ PS=0.88U PD=0.6U
* device instance _2962 m0 *1 559.315,786.84 nfet_05v0
XM_2962 n_I4022 n_I4021 n_I4024 VSS nfet_05v0 L=0.6U W=0.36U AS=0.0432P
+ AD=0.369P PS=0.6U PD=2.77U
* device instance _2963 m0 *1 543.625,776.23 pfet_05v0
XM_2963 n_I4034 n_I4029 n_I4030 VDD_DEC pfet_05v0 L=0.5U W=0.36U AS=0.3456P
+ AD=0.0612P PS=2.64U PD=0.7U
* device instance _2964 m0 *1 544.465,776.23 pfet_05v0
XM_2964 n_I4034 n_I4029 VDD_DEC VDD_DEC pfet_05v0 L=0.5U W=0.36U AS=0.379P
+ AD=0.0612P PS=2.37U PD=0.7U
* device instance _2965 m0 *1 546.115,776.55 pfet_05v0
XM_2965 n_185 n_I4030 VDD_DEC VDD_DEC pfet_05v0 L=0.5U W=1.22U AS=0.379P
+ AD=0.5368P PS=2.37U PD=3.32U
* device instance _2966 m0 *1 539.385,776.12 pfet_05v0
XM_2966 VDD_DEC n_I2060 n_I4028 VDD_DEC pfet_05v0 L=0.5U W=0.36U AS=0.3852P
+ AD=0.1116P PS=2.86U PD=0.98U
* device instance _2967 m0 *1 540.505,776.12 pfet_05v0
XM_2967 n_I4033 n_I4028 VDD_DEC VDD_DEC pfet_05v0 L=0.5U W=0.36U AS=0.1116P
+ AD=0.0612P PS=0.98U PD=0.7U
* device instance _2968 m0 *1 541.345,776.12 pfet_05v0
XM_2968 n_I4033 n_I4028 n_I4029 VDD_DEC pfet_05v0 L=0.5U W=0.36U AS=0.3852P
+ AD=0.0612P PS=2.86U PD=0.7U
* device instance _2969 m0 *1 543.675,778.998 nfet_05v0
XM_2969 n_I4032 n_I4029 n_I4030 VSS nfet_05v0 L=0.6U W=0.365U AS=0.3705P
+ AD=0.0438P PS=2.77U PD=0.605U
* device instance _2970 m0 *1 544.515,778.998 nfet_05v0
XM_2970 VSS n_I4029 n_I4032 VSS nfet_05v0 L=0.6U W=0.365U AS=0.0438P
+ AD=0.282625P PS=0.605U PD=1.87U
* device instance _2971 m0 *1 546.165,778.77 nfet_05v0
XM_2971 n_185 n_I4030 VSS VSS nfet_05v0 L=0.6U W=0.82U AS=0.282625P AD=0.3608P
+ PS=1.87U PD=2.52U
* device instance _2972 m0 *1 539.435,779 nfet_05v0
XM_2972 VSS n_I2060 n_I4028 VSS nfet_05v0 L=0.6U W=0.36U AS=0.333P AD=0.0936P
+ PS=2.57U PD=0.88U
* device instance _2973 m0 *1 540.555,779 nfet_05v0
XM_2973 n_I4031 n_I4028 VSS VSS nfet_05v0 L=0.6U W=0.36U AS=0.0936P AD=0.0432P
+ PS=0.88U PD=0.6U
* device instance _2974 m0 *1 541.395,779 nfet_05v0
XM_2974 n_I4029 n_I4028 n_I4031 VSS nfet_05v0 L=0.6U W=0.36U AS=0.0432P
+ AD=0.369P PS=0.6U PD=2.77U
* device instance _2975 m0 *1 504.425,776.23 pfet_05v0
XM_2975 n_I4041 n_I4036 n_I4037 VDD_DEC pfet_05v0 L=0.5U W=0.36U AS=0.3456P
+ AD=0.0612P PS=2.64U PD=0.7U
* device instance _2976 m0 *1 505.265,776.23 pfet_05v0
XM_2976 n_I4041 n_I4036 VDD_DEC VDD_DEC pfet_05v0 L=0.5U W=0.36U AS=0.379P
+ AD=0.0612P PS=2.37U PD=0.7U
* device instance _2977 m0 *1 506.915,776.55 pfet_05v0
XM_2977 n_279 n_I4037 VDD_DEC VDD_DEC pfet_05v0 L=0.5U W=1.22U AS=0.379P
+ AD=0.5368P PS=2.37U PD=3.32U
* device instance _2978 m0 *1 500.185,776.12 pfet_05v0
XM_2978 VDD_DEC n_I2053 n_I4035 VDD_DEC pfet_05v0 L=0.5U W=0.36U AS=0.3852P
+ AD=0.1116P PS=2.86U PD=0.98U
* device instance _2979 m0 *1 501.305,776.12 pfet_05v0
XM_2979 n_I4040 n_I4035 VDD_DEC VDD_DEC pfet_05v0 L=0.5U W=0.36U AS=0.1116P
+ AD=0.0612P PS=0.98U PD=0.7U
* device instance _2980 m0 *1 502.145,776.12 pfet_05v0
XM_2980 n_I4040 n_I4035 n_I4036 VDD_DEC pfet_05v0 L=0.5U W=0.36U AS=0.3852P
+ AD=0.0612P PS=2.86U PD=0.7U
* device instance _2981 m0 *1 504.475,778.998 nfet_05v0
XM_2981 n_I4039 n_I4036 n_I4037 VSS nfet_05v0 L=0.6U W=0.365U AS=0.3705P
+ AD=0.0438P PS=2.77U PD=0.605U
* device instance _2982 m0 *1 505.315,778.998 nfet_05v0
XM_2982 VSS n_I4036 n_I4039 VSS nfet_05v0 L=0.6U W=0.365U AS=0.0438P
+ AD=0.282625P PS=0.605U PD=1.87U
* device instance _2983 m0 *1 506.965,778.77 nfet_05v0
XM_2983 n_279 n_I4037 VSS VSS nfet_05v0 L=0.6U W=0.82U AS=0.282625P AD=0.3608P
+ PS=1.87U PD=2.52U
* device instance _2984 m0 *1 500.235,779 nfet_05v0
XM_2984 VSS n_I2053 n_I4035 VSS nfet_05v0 L=0.6U W=0.36U AS=0.333P AD=0.0936P
+ PS=2.57U PD=0.88U
* device instance _2985 m0 *1 501.355,779 nfet_05v0
XM_2985 n_I4038 n_I4035 VSS VSS nfet_05v0 L=0.6U W=0.36U AS=0.0936P AD=0.0432P
+ PS=0.88U PD=0.6U
* device instance _2986 m0 *1 502.195,779 nfet_05v0
XM_2986 n_I4036 n_I4035 n_I4038 VSS nfet_05v0 L=0.6U W=0.36U AS=0.0432P
+ AD=0.369P PS=0.6U PD=2.77U
* device instance _2987 m0 *1 561.545,815.43 pfet_05v0
XM_2987 n_I4048 n_I4043 n_I4044 VDD_DEC pfet_05v0 L=0.5U W=0.36U AS=0.3456P
+ AD=0.0612P PS=2.64U PD=0.7U
* device instance _2988 m0 *1 562.385,815.43 pfet_05v0
XM_2988 n_I4048 n_I4043 VDD_DEC VDD_DEC pfet_05v0 L=0.5U W=0.36U AS=0.379P
+ AD=0.0612P PS=2.37U PD=0.7U
* device instance _2989 m0 *1 564.035,815.75 pfet_05v0
XM_2989 n_I2383 n_I4044 VDD_DEC VDD_DEC pfet_05v0 L=0.5U W=1.22U AS=0.379P
+ AD=0.5368P PS=2.37U PD=3.32U
* device instance _2990 m0 *1 557.305,815.32 pfet_05v0
XM_2990 VDD_DEC n_I2358 n_I4042 VDD_DEC pfet_05v0 L=0.5U W=0.36U AS=0.3852P
+ AD=0.1116P PS=2.86U PD=0.98U
* device instance _2991 m0 *1 558.425,815.32 pfet_05v0
XM_2991 n_I4047 n_I4042 VDD_DEC VDD_DEC pfet_05v0 L=0.5U W=0.36U AS=0.1116P
+ AD=0.0612P PS=0.98U PD=0.7U
* device instance _2992 m0 *1 559.265,815.32 pfet_05v0
XM_2992 n_I4047 n_I4042 n_I4043 VDD_DEC pfet_05v0 L=0.5U W=0.36U AS=0.3852P
+ AD=0.0612P PS=2.86U PD=0.7U
* device instance _2993 m0 *1 561.595,818.198 nfet_05v0
XM_2993 n_I4046 n_I4043 n_I4044 VSS nfet_05v0 L=0.6U W=0.365U AS=0.3705P
+ AD=0.0438P PS=2.77U PD=0.605U
* device instance _2994 m0 *1 562.435,818.198 nfet_05v0
XM_2994 VSS n_I4043 n_I4046 VSS nfet_05v0 L=0.6U W=0.365U AS=0.0438P
+ AD=0.282625P PS=0.605U PD=1.87U
* device instance _2995 m0 *1 564.085,817.97 nfet_05v0
XM_2995 n_I2383 n_I4044 VSS VSS nfet_05v0 L=0.6U W=0.82U AS=0.282625P AD=0.3608P
+ PS=1.87U PD=2.52U
* device instance _2996 m0 *1 557.355,818.2 nfet_05v0
XM_2996 VSS n_I2358 n_I4042 VSS nfet_05v0 L=0.6U W=0.36U AS=0.333P AD=0.0936P
+ PS=2.57U PD=0.88U
* device instance _2997 m0 *1 558.475,818.2 nfet_05v0
XM_2997 n_I4045 n_I4042 VSS VSS nfet_05v0 L=0.6U W=0.36U AS=0.0936P AD=0.0432P
+ PS=0.88U PD=0.6U
* device instance _2998 m0 *1 559.315,818.2 nfet_05v0
XM_2998 n_I4043 n_I4042 n_I4045 VSS nfet_05v0 L=0.6U W=0.36U AS=0.0432P
+ AD=0.369P PS=0.6U PD=2.77U
* device instance _2999 m0 *1 522.345,784.07 pfet_05v0
XM_2999 n_I4055 n_I4050 n_I4051 VDD_DEC pfet_05v0 L=0.5U W=0.36U AS=0.3456P
+ AD=0.0612P PS=2.64U PD=0.7U
* device instance _3000 m0 *1 523.185,784.07 pfet_05v0
XM_3000 n_I4055 n_I4050 VDD_DEC VDD_DEC pfet_05v0 L=0.5U W=0.36U AS=0.379P
+ AD=0.0612P PS=2.37U PD=0.7U
* device instance _3001 m0 *1 524.835,784.39 pfet_05v0
XM_3001 n_175 n_I4051 VDD_DEC VDD_DEC pfet_05v0 L=0.5U W=1.22U AS=0.379P
+ AD=0.5368P PS=2.37U PD=3.32U
* device instance _3002 m0 *1 518.105,783.96 pfet_05v0
XM_3002 VDD_DEC n_I2126 n_I4049 VDD_DEC pfet_05v0 L=0.5U W=0.36U AS=0.3852P
+ AD=0.1116P PS=2.86U PD=0.98U
* device instance _3003 m0 *1 519.225,783.96 pfet_05v0
XM_3003 n_I4054 n_I4049 VDD_DEC VDD_DEC pfet_05v0 L=0.5U W=0.36U AS=0.1116P
+ AD=0.0612P PS=0.98U PD=0.7U
* device instance _3004 m0 *1 520.065,783.96 pfet_05v0
XM_3004 n_I4054 n_I4049 n_I4050 VDD_DEC pfet_05v0 L=0.5U W=0.36U AS=0.3852P
+ AD=0.0612P PS=2.86U PD=0.7U
* device instance _3005 m0 *1 522.395,786.838 nfet_05v0
XM_3005 n_I4053 n_I4050 n_I4051 VSS nfet_05v0 L=0.6U W=0.365U AS=0.3705P
+ AD=0.0438P PS=2.77U PD=0.605U
* device instance _3006 m0 *1 523.235,786.838 nfet_05v0
XM_3006 VSS n_I4050 n_I4053 VSS nfet_05v0 L=0.6U W=0.365U AS=0.0438P
+ AD=0.282625P PS=0.605U PD=1.87U
* device instance _3007 m0 *1 524.885,786.61 nfet_05v0
XM_3007 n_175 n_I4051 VSS VSS nfet_05v0 L=0.6U W=0.82U AS=0.282625P AD=0.3608P
+ PS=1.87U PD=2.52U
* device instance _3008 m0 *1 518.155,786.84 nfet_05v0
XM_3008 VSS n_I2126 n_I4049 VSS nfet_05v0 L=0.6U W=0.36U AS=0.333P AD=0.0936P
+ PS=2.57U PD=0.88U
* device instance _3009 m0 *1 519.275,786.84 nfet_05v0
XM_3009 n_I4052 n_I4049 VSS VSS nfet_05v0 L=0.6U W=0.36U AS=0.0936P AD=0.0432P
+ PS=0.88U PD=0.6U
* device instance _3010 m0 *1 520.115,786.84 nfet_05v0
XM_3010 n_I4050 n_I4049 n_I4052 VSS nfet_05v0 L=0.6U W=0.36U AS=0.0432P
+ AD=0.369P PS=0.6U PD=2.77U
* device instance _3011 m0 *1 513.385,784.07 pfet_05v0
XM_3011 n_I4062 n_I4057 n_I4058 VDD_DEC pfet_05v0 L=0.5U W=0.36U AS=0.3456P
+ AD=0.0612P PS=2.64U PD=0.7U
* device instance _3012 m0 *1 514.225,784.07 pfet_05v0
XM_3012 n_I4062 n_I4057 VDD_DEC VDD_DEC pfet_05v0 L=0.5U W=0.36U AS=0.379P
+ AD=0.0612P PS=2.37U PD=0.7U
* device instance _3013 m0 *1 515.875,784.39 pfet_05v0
XM_3013 n_148 n_I4058 VDD_DEC VDD_DEC pfet_05v0 L=0.5U W=1.22U AS=0.379P
+ AD=0.5368P PS=2.37U PD=3.32U
* device instance _3014 m0 *1 509.145,783.96 pfet_05v0
XM_3014 VDD_DEC n_I2125 n_I4056 VDD_DEC pfet_05v0 L=0.5U W=0.36U AS=0.3852P
+ AD=0.1116P PS=2.86U PD=0.98U
* device instance _3015 m0 *1 510.265,783.96 pfet_05v0
XM_3015 n_I4061 n_I4056 VDD_DEC VDD_DEC pfet_05v0 L=0.5U W=0.36U AS=0.1116P
+ AD=0.0612P PS=0.98U PD=0.7U
* device instance _3016 m0 *1 511.105,783.96 pfet_05v0
XM_3016 n_I4061 n_I4056 n_I4057 VDD_DEC pfet_05v0 L=0.5U W=0.36U AS=0.3852P
+ AD=0.0612P PS=2.86U PD=0.7U
* device instance _3017 m0 *1 513.435,786.838 nfet_05v0
XM_3017 n_I4060 n_I4057 n_I4058 VSS nfet_05v0 L=0.6U W=0.365U AS=0.3705P
+ AD=0.0438P PS=2.77U PD=0.605U
* device instance _3018 m0 *1 514.275,786.838 nfet_05v0
XM_3018 VSS n_I4057 n_I4060 VSS nfet_05v0 L=0.6U W=0.365U AS=0.0438P
+ AD=0.282625P PS=0.605U PD=1.87U
* device instance _3019 m0 *1 515.925,786.61 nfet_05v0
XM_3019 n_148 n_I4058 VSS VSS nfet_05v0 L=0.6U W=0.82U AS=0.282625P AD=0.3608P
+ PS=1.87U PD=2.52U
* device instance _3020 m0 *1 509.195,786.84 nfet_05v0
XM_3020 VSS n_I2125 n_I4056 VSS nfet_05v0 L=0.6U W=0.36U AS=0.333P AD=0.0936P
+ PS=2.57U PD=0.88U
* device instance _3021 m0 *1 510.315,786.84 nfet_05v0
XM_3021 n_I4059 n_I4056 VSS VSS nfet_05v0 L=0.6U W=0.36U AS=0.0936P AD=0.0432P
+ PS=0.88U PD=0.6U
* device instance _3022 m0 *1 511.155,786.84 nfet_05v0
XM_3022 n_I4057 n_I4056 n_I4059 VSS nfet_05v0 L=0.6U W=0.36U AS=0.0432P
+ AD=0.369P PS=0.6U PD=2.77U
* device instance _3023 m0 *1 504.425,784.07 pfet_05v0
XM_3023 n_I4069 n_I4064 n_I4065 VDD_DEC pfet_05v0 L=0.5U W=0.36U AS=0.3456P
+ AD=0.0612P PS=2.64U PD=0.7U
* device instance _3024 m0 *1 505.265,784.07 pfet_05v0
XM_3024 n_I4069 n_I4064 VDD_DEC VDD_DEC pfet_05v0 L=0.5U W=0.36U AS=0.379P
+ AD=0.0612P PS=2.37U PD=0.7U
* device instance _3025 m0 *1 506.915,784.39 pfet_05v0
XM_3025 n_274 n_I4065 VDD_DEC VDD_DEC pfet_05v0 L=0.5U W=1.22U AS=0.379P
+ AD=0.5368P PS=2.37U PD=3.32U
* device instance _3026 m0 *1 500.185,783.96 pfet_05v0
XM_3026 VDD_DEC n_I2123 n_I4063 VDD_DEC pfet_05v0 L=0.5U W=0.36U AS=0.3852P
+ AD=0.1116P PS=2.86U PD=0.98U
* device instance _3027 m0 *1 501.305,783.96 pfet_05v0
XM_3027 n_I4068 n_I4063 VDD_DEC VDD_DEC pfet_05v0 L=0.5U W=0.36U AS=0.1116P
+ AD=0.0612P PS=0.98U PD=0.7U
* device instance _3028 m0 *1 502.145,783.96 pfet_05v0
XM_3028 n_I4068 n_I4063 n_I4064 VDD_DEC pfet_05v0 L=0.5U W=0.36U AS=0.3852P
+ AD=0.0612P PS=2.86U PD=0.7U
* device instance _3029 m0 *1 504.475,786.838 nfet_05v0
XM_3029 n_I4067 n_I4064 n_I4065 VSS nfet_05v0 L=0.6U W=0.365U AS=0.3705P
+ AD=0.0438P PS=2.77U PD=0.605U
* device instance _3030 m0 *1 505.315,786.838 nfet_05v0
XM_3030 VSS n_I4064 n_I4067 VSS nfet_05v0 L=0.6U W=0.365U AS=0.0438P
+ AD=0.282625P PS=0.605U PD=1.87U
* device instance _3031 m0 *1 506.965,786.61 nfet_05v0
XM_3031 n_274 n_I4065 VSS VSS nfet_05v0 L=0.6U W=0.82U AS=0.282625P AD=0.3608P
+ PS=1.87U PD=2.52U
* device instance _3032 m0 *1 500.235,786.84 nfet_05v0
XM_3032 VSS n_I2123 n_I4063 VSS nfet_05v0 L=0.6U W=0.36U AS=0.333P AD=0.0936P
+ PS=2.57U PD=0.88U
* device instance _3033 m0 *1 501.355,786.84 nfet_05v0
XM_3033 n_I4066 n_I4063 VSS VSS nfet_05v0 L=0.6U W=0.36U AS=0.0936P AD=0.0432P
+ PS=0.88U PD=0.6U
* device instance _3034 m0 *1 502.195,786.84 nfet_05v0
XM_3034 n_I4064 n_I4063 n_I4066 VSS nfet_05v0 L=0.6U W=0.36U AS=0.0432P
+ AD=0.369P PS=0.6U PD=2.77U
* device instance _3035 m0 *1 522.345,791.91 pfet_05v0
XM_3035 n_I4076 n_I4071 n_I4072 VDD_DEC pfet_05v0 L=0.5U W=0.36U AS=0.3456P
+ AD=0.0612P PS=2.64U PD=0.7U
* device instance _3036 m0 *1 523.185,791.91 pfet_05v0
XM_3036 n_I4076 n_I4071 VDD_DEC VDD_DEC pfet_05v0 L=0.5U W=0.36U AS=0.379P
+ AD=0.0612P PS=2.37U PD=0.7U
* device instance _3037 m0 *1 524.835,792.23 pfet_05v0
XM_3037 n_157 n_I4072 VDD_DEC VDD_DEC pfet_05v0 L=0.5U W=1.22U AS=0.379P
+ AD=0.5368P PS=2.37U PD=3.32U
* device instance _3038 m0 *1 518.105,791.8 pfet_05v0
XM_3038 VDD_DEC n_I2201 n_I4070 VDD_DEC pfet_05v0 L=0.5U W=0.36U AS=0.3852P
+ AD=0.1116P PS=2.86U PD=0.98U
* device instance _3039 m0 *1 519.225,791.8 pfet_05v0
XM_3039 n_I4075 n_I4070 VDD_DEC VDD_DEC pfet_05v0 L=0.5U W=0.36U AS=0.1116P
+ AD=0.0612P PS=0.98U PD=0.7U
* device instance _3040 m0 *1 520.065,791.8 pfet_05v0
XM_3040 n_I4075 n_I4070 n_I4071 VDD_DEC pfet_05v0 L=0.5U W=0.36U AS=0.3852P
+ AD=0.0612P PS=2.86U PD=0.7U
* device instance _3041 m0 *1 522.395,794.678 nfet_05v0
XM_3041 n_I4074 n_I4071 n_I4072 VSS nfet_05v0 L=0.6U W=0.365U AS=0.3705P
+ AD=0.0438P PS=2.77U PD=0.605U
* device instance _3042 m0 *1 523.235,794.678 nfet_05v0
XM_3042 VSS n_I4071 n_I4074 VSS nfet_05v0 L=0.6U W=0.365U AS=0.0438P
+ AD=0.282625P PS=0.605U PD=1.87U
* device instance _3043 m0 *1 524.885,794.45 nfet_05v0
XM_3043 n_157 n_I4072 VSS VSS nfet_05v0 L=0.6U W=0.82U AS=0.282625P AD=0.3608P
+ PS=1.87U PD=2.52U
* device instance _3044 m0 *1 518.155,794.68 nfet_05v0
XM_3044 VSS n_I2201 n_I4070 VSS nfet_05v0 L=0.6U W=0.36U AS=0.333P AD=0.0936P
+ PS=2.57U PD=0.88U
* device instance _3045 m0 *1 519.275,794.68 nfet_05v0
XM_3045 n_I4073 n_I4070 VSS VSS nfet_05v0 L=0.6U W=0.36U AS=0.0936P AD=0.0432P
+ PS=0.88U PD=0.6U
* device instance _3046 m0 *1 520.115,794.68 nfet_05v0
XM_3046 n_I4071 n_I4070 n_I4073 VSS nfet_05v0 L=0.6U W=0.36U AS=0.0432P
+ AD=0.369P PS=0.6U PD=2.77U
* device instance _3047 m0 *1 495.465,776.23 pfet_05v0
XM_3047 n_I4083 n_I4078 n_I4079 VDD_DEC pfet_05v0 L=0.5U W=0.36U AS=0.3456P
+ AD=0.0612P PS=2.64U PD=0.7U
* device instance _3048 m0 *1 496.305,776.23 pfet_05v0
XM_3048 n_I4083 n_I4078 VDD_DEC VDD_DEC pfet_05v0 L=0.5U W=0.36U AS=0.379P
+ AD=0.0612P PS=2.37U PD=0.7U
* device instance _3049 m0 *1 497.955,776.55 pfet_05v0
XM_3049 n_273 n_I4079 VDD_DEC VDD_DEC pfet_05v0 L=0.5U W=1.22U AS=0.379P
+ AD=0.5368P PS=2.37U PD=3.32U
* device instance _3050 m0 *1 491.225,776.12 pfet_05v0
XM_3050 VDD_DEC n_I2101 n_I4077 VDD_DEC pfet_05v0 L=0.5U W=0.36U AS=0.3852P
+ AD=0.1116P PS=2.86U PD=0.98U
* device instance _3051 m0 *1 492.345,776.12 pfet_05v0
XM_3051 n_I4082 n_I4077 VDD_DEC VDD_DEC pfet_05v0 L=0.5U W=0.36U AS=0.1116P
+ AD=0.0612P PS=0.98U PD=0.7U
* device instance _3052 m0 *1 493.185,776.12 pfet_05v0
XM_3052 n_I4082 n_I4077 n_I4078 VDD_DEC pfet_05v0 L=0.5U W=0.36U AS=0.3852P
+ AD=0.0612P PS=2.86U PD=0.7U
* device instance _3053 m0 *1 495.515,778.998 nfet_05v0
XM_3053 n_I4081 n_I4078 n_I4079 VSS nfet_05v0 L=0.6U W=0.365U AS=0.3705P
+ AD=0.0438P PS=2.77U PD=0.605U
* device instance _3054 m0 *1 496.355,778.998 nfet_05v0
XM_3054 VSS n_I4078 n_I4081 VSS nfet_05v0 L=0.6U W=0.365U AS=0.0438P
+ AD=0.282625P PS=0.605U PD=1.87U
* device instance _3055 m0 *1 498.005,778.77 nfet_05v0
XM_3055 n_273 n_I4079 VSS VSS nfet_05v0 L=0.6U W=0.82U AS=0.282625P AD=0.3608P
+ PS=1.87U PD=2.52U
* device instance _3056 m0 *1 491.275,779 nfet_05v0
XM_3056 VSS n_I2101 n_I4077 VSS nfet_05v0 L=0.6U W=0.36U AS=0.333P AD=0.0936P
+ PS=2.57U PD=0.88U
* device instance _3057 m0 *1 492.395,779 nfet_05v0
XM_3057 n_I4080 n_I4077 VSS VSS nfet_05v0 L=0.6U W=0.36U AS=0.0936P AD=0.0432P
+ PS=0.88U PD=0.6U
* device instance _3058 m0 *1 493.235,779 nfet_05v0
XM_3058 n_I4078 n_I4077 n_I4080 VSS nfet_05v0 L=0.6U W=0.36U AS=0.0432P
+ AD=0.369P PS=0.6U PD=2.77U
* device instance _3059 m0 *1 534.665,776.23 pfet_05v0
XM_3059 n_I4090 n_I4085 n_I4086 VDD_DEC pfet_05v0 L=0.5U W=0.36U AS=0.3456P
+ AD=0.0612P PS=2.64U PD=0.7U
* device instance _3060 m0 *1 535.505,776.23 pfet_05v0
XM_3060 n_I4090 n_I4085 VDD_DEC VDD_DEC pfet_05v0 L=0.5U W=0.36U AS=0.379P
+ AD=0.0612P PS=2.37U PD=0.7U
* device instance _3061 m0 *1 537.155,776.55 pfet_05v0
XM_3061 n_164 n_I4086 VDD_DEC VDD_DEC pfet_05v0 L=0.5U W=1.22U AS=0.379P
+ AD=0.5368P PS=2.37U PD=3.32U
* device instance _3062 m0 *1 530.425,776.12 pfet_05v0
XM_3062 VDD_DEC n_I2058 n_I4084 VDD_DEC pfet_05v0 L=0.5U W=0.36U AS=0.3852P
+ AD=0.1116P PS=2.86U PD=0.98U
* device instance _3063 m0 *1 531.545,776.12 pfet_05v0
XM_3063 n_I4089 n_I4084 VDD_DEC VDD_DEC pfet_05v0 L=0.5U W=0.36U AS=0.1116P
+ AD=0.0612P PS=0.98U PD=0.7U
* device instance _3064 m0 *1 532.385,776.12 pfet_05v0
XM_3064 n_I4089 n_I4084 n_I4085 VDD_DEC pfet_05v0 L=0.5U W=0.36U AS=0.3852P
+ AD=0.0612P PS=2.86U PD=0.7U
* device instance _3065 m0 *1 534.715,778.998 nfet_05v0
XM_3065 n_I4088 n_I4085 n_I4086 VSS nfet_05v0 L=0.6U W=0.365U AS=0.3705P
+ AD=0.0438P PS=2.77U PD=0.605U
* device instance _3066 m0 *1 535.555,778.998 nfet_05v0
XM_3066 VSS n_I4085 n_I4088 VSS nfet_05v0 L=0.6U W=0.365U AS=0.0438P
+ AD=0.282625P PS=0.605U PD=1.87U
* device instance _3067 m0 *1 537.205,778.77 nfet_05v0
XM_3067 n_164 n_I4086 VSS VSS nfet_05v0 L=0.6U W=0.82U AS=0.282625P AD=0.3608P
+ PS=1.87U PD=2.52U
* device instance _3068 m0 *1 530.475,779 nfet_05v0
XM_3068 VSS n_I2058 n_I4084 VSS nfet_05v0 L=0.6U W=0.36U AS=0.333P AD=0.0936P
+ PS=2.57U PD=0.88U
* device instance _3069 m0 *1 531.595,779 nfet_05v0
XM_3069 n_I4087 n_I4084 VSS VSS nfet_05v0 L=0.6U W=0.36U AS=0.0936P AD=0.0432P
+ PS=0.88U PD=0.6U
* device instance _3070 m0 *1 532.435,779 nfet_05v0
XM_3070 n_I4085 n_I4084 n_I4087 VSS nfet_05v0 L=0.6U W=0.36U AS=0.0432P
+ AD=0.369P PS=0.6U PD=2.77U
* device instance _3071 m0 *1 534.665,784.07 pfet_05v0
XM_3071 n_I4097 n_I4092 n_I4093 VDD_DEC pfet_05v0 L=0.5U W=0.36U AS=0.3456P
+ AD=0.0612P PS=2.64U PD=0.7U
* device instance _3072 m0 *1 535.505,784.07 pfet_05v0
XM_3072 n_I4097 n_I4092 VDD_DEC VDD_DEC pfet_05v0 L=0.5U W=0.36U AS=0.379P
+ AD=0.0612P PS=2.37U PD=0.7U
* device instance _3073 m0 *1 537.155,784.39 pfet_05v0
XM_3073 n_155 n_I4093 VDD_DEC VDD_DEC pfet_05v0 L=0.5U W=1.22U AS=0.379P
+ AD=0.5368P PS=2.37U PD=3.32U
* device instance _3074 m0 *1 530.425,783.96 pfet_05v0
XM_3074 VDD_DEC n_I2128 n_I4091 VDD_DEC pfet_05v0 L=0.5U W=0.36U AS=0.3852P
+ AD=0.1116P PS=2.86U PD=0.98U
* device instance _3075 m0 *1 531.545,783.96 pfet_05v0
XM_3075 n_I4096 n_I4091 VDD_DEC VDD_DEC pfet_05v0 L=0.5U W=0.36U AS=0.1116P
+ AD=0.0612P PS=0.98U PD=0.7U
* device instance _3076 m0 *1 532.385,783.96 pfet_05v0
XM_3076 n_I4096 n_I4091 n_I4092 VDD_DEC pfet_05v0 L=0.5U W=0.36U AS=0.3852P
+ AD=0.0612P PS=2.86U PD=0.7U
* device instance _3077 m0 *1 534.715,786.838 nfet_05v0
XM_3077 n_I4095 n_I4092 n_I4093 VSS nfet_05v0 L=0.6U W=0.365U AS=0.3705P
+ AD=0.0438P PS=2.77U PD=0.605U
* device instance _3078 m0 *1 535.555,786.838 nfet_05v0
XM_3078 VSS n_I4092 n_I4095 VSS nfet_05v0 L=0.6U W=0.365U AS=0.0438P
+ AD=0.282625P PS=0.605U PD=1.87U
* device instance _3079 m0 *1 537.205,786.61 nfet_05v0
XM_3079 n_155 n_I4093 VSS VSS nfet_05v0 L=0.6U W=0.82U AS=0.282625P AD=0.3608P
+ PS=1.87U PD=2.52U
* device instance _3080 m0 *1 530.475,786.84 nfet_05v0
XM_3080 VSS n_I2128 n_I4091 VSS nfet_05v0 L=0.6U W=0.36U AS=0.333P AD=0.0936P
+ PS=2.57U PD=0.88U
* device instance _3081 m0 *1 531.595,786.84 nfet_05v0
XM_3081 n_I4094 n_I4091 VSS VSS nfet_05v0 L=0.6U W=0.36U AS=0.0936P AD=0.0432P
+ PS=0.88U PD=0.6U
* device instance _3082 m0 *1 532.435,786.84 nfet_05v0
XM_3082 n_I4092 n_I4091 n_I4094 VSS nfet_05v0 L=0.6U W=0.36U AS=0.0432P
+ AD=0.369P PS=0.6U PD=2.77U
* device instance _3083 m0 *1 621.465,815.43 pfet_05v0
XM_3083 n_I4104 n_I4099 n_I4100 VDD_DEC pfet_05v0 L=0.5U W=0.36U AS=0.3456P
+ AD=0.0612P PS=2.64U PD=0.7U
* device instance _3084 m0 *1 622.305,815.43 pfet_05v0
XM_3084 n_I4104 n_I4099 VDD_DEC VDD_DEC pfet_05v0 L=0.5U W=0.36U AS=0.379P
+ AD=0.0612P PS=2.37U PD=0.7U
* device instance _3085 m0 *1 623.955,815.75 pfet_05v0
XM_3085 n_I2341 n_I4100 VDD_DEC VDD_DEC pfet_05v0 L=0.5U W=1.22U AS=0.379P
+ AD=0.5368P PS=2.37U PD=3.32U
* device instance _3086 m0 *1 617.225,815.32 pfet_05v0
XM_3086 VDD_DEC n_I2401 n_I4098 VDD_DEC pfet_05v0 L=0.5U W=0.36U AS=0.3852P
+ AD=0.1116P PS=2.86U PD=0.98U
* device instance _3087 m0 *1 618.345,815.32 pfet_05v0
XM_3087 n_I4103 n_I4098 VDD_DEC VDD_DEC pfet_05v0 L=0.5U W=0.36U AS=0.1116P
+ AD=0.0612P PS=0.98U PD=0.7U
* device instance _3088 m0 *1 619.185,815.32 pfet_05v0
XM_3088 n_I4103 n_I4098 n_I4099 VDD_DEC pfet_05v0 L=0.5U W=0.36U AS=0.3852P
+ AD=0.0612P PS=2.86U PD=0.7U
* device instance _3089 m0 *1 621.515,818.198 nfet_05v0
XM_3089 n_I4102 n_I4099 n_I4100 VSS nfet_05v0 L=0.6U W=0.365U AS=0.3705P
+ AD=0.0438P PS=2.77U PD=0.605U
* device instance _3090 m0 *1 622.355,818.198 nfet_05v0
XM_3090 VSS n_I4099 n_I4102 VSS nfet_05v0 L=0.6U W=0.365U AS=0.0438P
+ AD=0.282625P PS=0.605U PD=1.87U
* device instance _3091 m0 *1 624.005,817.97 nfet_05v0
XM_3091 n_I2341 n_I4100 VSS VSS nfet_05v0 L=0.6U W=0.82U AS=0.282625P AD=0.3608P
+ PS=1.87U PD=2.52U
* device instance _3092 m0 *1 617.275,818.2 nfet_05v0
XM_3092 VSS n_I2401 n_I4098 VSS nfet_05v0 L=0.6U W=0.36U AS=0.333P AD=0.0936P
+ PS=2.57U PD=0.88U
* device instance _3093 m0 *1 618.395,818.2 nfet_05v0
XM_3093 n_I4101 n_I4098 VSS VSS nfet_05v0 L=0.6U W=0.36U AS=0.0936P AD=0.0432P
+ PS=0.88U PD=0.6U
* device instance _3094 m0 *1 619.235,818.2 nfet_05v0
XM_3094 n_I4099 n_I4098 n_I4101 VSS nfet_05v0 L=0.6U W=0.36U AS=0.0432P
+ AD=0.369P PS=0.6U PD=2.77U
* device instance _3095 m0 *1 502.745,791.91 pfet_05v0
XM_3095 n_I4111 n_I4106 n_I4107 VDD_DEC pfet_05v0 L=0.5U W=0.36U AS=0.3456P
+ AD=0.0612P PS=2.64U PD=0.7U
* device instance _3096 m0 *1 503.585,791.91 pfet_05v0
XM_3096 n_I4111 n_I4106 VDD_DEC VDD_DEC pfet_05v0 L=0.5U W=0.36U AS=0.379P
+ AD=0.0612P PS=2.37U PD=0.7U
* device instance _3097 m0 *1 505.235,792.23 pfet_05v0
XM_3097 n_267 n_I4107 VDD_DEC VDD_DEC pfet_05v0 L=0.5U W=1.22U AS=0.379P
+ AD=0.5368P PS=2.37U PD=3.32U
* device instance _3098 m0 *1 498.505,791.8 pfet_05v0
XM_3098 VDD_DEC n_I2197 n_I4105 VDD_DEC pfet_05v0 L=0.5U W=0.36U AS=0.3852P
+ AD=0.1116P PS=2.86U PD=0.98U
* device instance _3099 m0 *1 499.625,791.8 pfet_05v0
XM_3099 n_I4110 n_I4105 VDD_DEC VDD_DEC pfet_05v0 L=0.5U W=0.36U AS=0.1116P
+ AD=0.0612P PS=0.98U PD=0.7U
* device instance _3100 m0 *1 500.465,791.8 pfet_05v0
XM_3100 n_I4110 n_I4105 n_I4106 VDD_DEC pfet_05v0 L=0.5U W=0.36U AS=0.3852P
+ AD=0.0612P PS=2.86U PD=0.7U
* device instance _3101 m0 *1 502.795,794.678 nfet_05v0
XM_3101 n_I4109 n_I4106 n_I4107 VSS nfet_05v0 L=0.6U W=0.365U AS=0.3705P
+ AD=0.0438P PS=2.77U PD=0.605U
* device instance _3102 m0 *1 503.635,794.678 nfet_05v0
XM_3102 VSS n_I4106 n_I4109 VSS nfet_05v0 L=0.6U W=0.365U AS=0.0438P
+ AD=0.282625P PS=0.605U PD=1.87U
* device instance _3103 m0 *1 505.285,794.45 nfet_05v0
XM_3103 n_267 n_I4107 VSS VSS nfet_05v0 L=0.6U W=0.82U AS=0.282625P AD=0.3608P
+ PS=1.87U PD=2.52U
* device instance _3104 m0 *1 498.555,794.68 nfet_05v0
XM_3104 VSS n_I2197 n_I4105 VSS nfet_05v0 L=0.6U W=0.36U AS=0.333P AD=0.0936P
+ PS=2.57U PD=0.88U
* device instance _3105 m0 *1 499.675,794.68 nfet_05v0
XM_3105 n_I4108 n_I4105 VSS VSS nfet_05v0 L=0.6U W=0.36U AS=0.0936P AD=0.0432P
+ PS=0.88U PD=0.6U
* device instance _3106 m0 *1 500.515,794.68 nfet_05v0
XM_3106 n_I4106 n_I4105 n_I4108 VSS nfet_05v0 L=0.6U W=0.36U AS=0.0432P
+ AD=0.369P PS=0.6U PD=2.77U
* device instance _3107 m0 *1 552.585,776.23 pfet_05v0
XM_3107 n_I4118 n_I4113 n_I4114 VDD_DEC pfet_05v0 L=0.5U W=0.36U AS=0.3456P
+ AD=0.0612P PS=2.64U PD=0.7U
* device instance _3108 m0 *1 553.425,776.23 pfet_05v0
XM_3108 n_I4118 n_I4113 VDD_DEC VDD_DEC pfet_05v0 L=0.5U W=0.36U AS=0.379P
+ AD=0.0612P PS=2.37U PD=0.7U
* device instance _3109 m0 *1 555.075,776.55 pfet_05v0
XM_3109 n_156 n_I4114 VDD_DEC VDD_DEC pfet_05v0 L=0.5U W=1.22U AS=0.379P
+ AD=0.5368P PS=2.37U PD=3.32U
* device instance _3110 m0 *1 548.345,776.12 pfet_05v0
XM_3110 VDD_DEC n_I2127 n_I4112 VDD_DEC pfet_05v0 L=0.5U W=0.36U AS=0.3852P
+ AD=0.1116P PS=2.86U PD=0.98U
* device instance _3111 m0 *1 549.465,776.12 pfet_05v0
XM_3111 n_I4117 n_I4112 VDD_DEC VDD_DEC pfet_05v0 L=0.5U W=0.36U AS=0.1116P
+ AD=0.0612P PS=0.98U PD=0.7U
* device instance _3112 m0 *1 550.305,776.12 pfet_05v0
XM_3112 n_I4117 n_I4112 n_I4113 VDD_DEC pfet_05v0 L=0.5U W=0.36U AS=0.3852P
+ AD=0.0612P PS=2.86U PD=0.7U
* device instance _3113 m0 *1 552.635,778.998 nfet_05v0
XM_3113 n_I4116 n_I4113 n_I4114 VSS nfet_05v0 L=0.6U W=0.365U AS=0.3705P
+ AD=0.0438P PS=2.77U PD=0.605U
* device instance _3114 m0 *1 553.475,778.998 nfet_05v0
XM_3114 VSS n_I4113 n_I4116 VSS nfet_05v0 L=0.6U W=0.365U AS=0.0438P
+ AD=0.282625P PS=0.605U PD=1.87U
* device instance _3115 m0 *1 555.125,778.77 nfet_05v0
XM_3115 n_156 n_I4114 VSS VSS nfet_05v0 L=0.6U W=0.82U AS=0.282625P AD=0.3608P
+ PS=1.87U PD=2.52U
* device instance _3116 m0 *1 548.395,779 nfet_05v0
XM_3116 VSS n_I2127 n_I4112 VSS nfet_05v0 L=0.6U W=0.36U AS=0.333P AD=0.0936P
+ PS=2.57U PD=0.88U
* device instance _3117 m0 *1 549.515,779 nfet_05v0
XM_3117 n_I4115 n_I4112 VSS VSS nfet_05v0 L=0.6U W=0.36U AS=0.0936P AD=0.0432P
+ PS=0.88U PD=0.6U
* device instance _3118 m0 *1 550.355,779 nfet_05v0
XM_3118 n_I4113 n_I4112 n_I4115 VSS nfet_05v0 L=0.6U W=0.36U AS=0.0432P
+ AD=0.369P PS=0.6U PD=2.77U
* device instance _3119 m0 *1 543.625,784.07 pfet_05v0
XM_3119 n_I4125 n_I4120 n_I4121 VDD_DEC pfet_05v0 L=0.5U W=0.36U AS=0.3456P
+ AD=0.0612P PS=2.64U PD=0.7U
* device instance _3120 m0 *1 544.465,784.07 pfet_05v0
XM_3120 n_I4125 n_I4120 VDD_DEC VDD_DEC pfet_05v0 L=0.5U W=0.36U AS=0.379P
+ AD=0.0612P PS=2.37U PD=0.7U
* device instance _3121 m0 *1 546.115,784.39 pfet_05v0
XM_3121 n_170 n_I4121 VDD_DEC VDD_DEC pfet_05v0 L=0.5U W=1.22U AS=0.379P
+ AD=0.5368P PS=2.37U PD=3.32U
* device instance _3122 m0 *1 539.385,783.96 pfet_05v0
XM_3122 VDD_DEC n_I2129 n_I4119 VDD_DEC pfet_05v0 L=0.5U W=0.36U AS=0.3852P
+ AD=0.1116P PS=2.86U PD=0.98U
* device instance _3123 m0 *1 540.505,783.96 pfet_05v0
XM_3123 n_I4124 n_I4119 VDD_DEC VDD_DEC pfet_05v0 L=0.5U W=0.36U AS=0.1116P
+ AD=0.0612P PS=0.98U PD=0.7U
* device instance _3124 m0 *1 541.345,783.96 pfet_05v0
XM_3124 n_I4124 n_I4119 n_I4120 VDD_DEC pfet_05v0 L=0.5U W=0.36U AS=0.3852P
+ AD=0.0612P PS=2.86U PD=0.7U
* device instance _3125 m0 *1 543.675,786.838 nfet_05v0
XM_3125 n_I4123 n_I4120 n_I4121 VSS nfet_05v0 L=0.6U W=0.365U AS=0.3705P
+ AD=0.0438P PS=2.77U PD=0.605U
* device instance _3126 m0 *1 544.515,786.838 nfet_05v0
XM_3126 VSS n_I4120 n_I4123 VSS nfet_05v0 L=0.6U W=0.365U AS=0.0438P
+ AD=0.282625P PS=0.605U PD=1.87U
* device instance _3127 m0 *1 546.165,786.61 nfet_05v0
XM_3127 n_170 n_I4121 VSS VSS nfet_05v0 L=0.6U W=0.82U AS=0.282625P AD=0.3608P
+ PS=1.87U PD=2.52U
* device instance _3128 m0 *1 539.435,786.84 nfet_05v0
XM_3128 VSS n_I2129 n_I4119 VSS nfet_05v0 L=0.6U W=0.36U AS=0.333P AD=0.0936P
+ PS=2.57U PD=0.88U
* device instance _3129 m0 *1 540.555,786.84 nfet_05v0
XM_3129 n_I4122 n_I4119 VSS VSS nfet_05v0 L=0.6U W=0.36U AS=0.0936P AD=0.0432P
+ PS=0.88U PD=0.6U
* device instance _3130 m0 *1 541.395,786.84 nfet_05v0
XM_3130 n_I4120 n_I4119 n_I4122 VSS nfet_05v0 L=0.6U W=0.36U AS=0.0432P
+ AD=0.369P PS=0.6U PD=2.77U
* device instance _3131 m0 *1 513.385,776.23 pfet_05v0
XM_3131 n_I4132 n_I4127 n_I4128 VDD_DEC pfet_05v0 L=0.5U W=0.36U AS=0.3456P
+ AD=0.0612P PS=2.64U PD=0.7U
* device instance _3132 m0 *1 514.225,776.23 pfet_05v0
XM_3132 n_I4132 n_I4127 VDD_DEC VDD_DEC pfet_05v0 L=0.5U W=0.36U AS=0.379P
+ AD=0.0612P PS=2.37U PD=0.7U
* device instance _3133 m0 *1 515.875,776.55 pfet_05v0
XM_3133 n_166 n_I4128 VDD_DEC VDD_DEC pfet_05v0 L=0.5U W=1.22U AS=0.379P
+ AD=0.5368P PS=2.37U PD=3.32U
* device instance _3134 m0 *1 509.145,776.12 pfet_05v0
XM_3134 VDD_DEC n_I2054 n_I4126 VDD_DEC pfet_05v0 L=0.5U W=0.36U AS=0.3852P
+ AD=0.1116P PS=2.86U PD=0.98U
* device instance _3135 m0 *1 510.265,776.12 pfet_05v0
XM_3135 n_I4131 n_I4126 VDD_DEC VDD_DEC pfet_05v0 L=0.5U W=0.36U AS=0.1116P
+ AD=0.0612P PS=0.98U PD=0.7U
* device instance _3136 m0 *1 511.105,776.12 pfet_05v0
XM_3136 n_I4131 n_I4126 n_I4127 VDD_DEC pfet_05v0 L=0.5U W=0.36U AS=0.3852P
+ AD=0.0612P PS=2.86U PD=0.7U
* device instance _3137 m0 *1 513.435,778.998 nfet_05v0
XM_3137 n_I4130 n_I4127 n_I4128 VSS nfet_05v0 L=0.6U W=0.365U AS=0.3705P
+ AD=0.0438P PS=2.77U PD=0.605U
* device instance _3138 m0 *1 514.275,778.998 nfet_05v0
XM_3138 VSS n_I4127 n_I4130 VSS nfet_05v0 L=0.6U W=0.365U AS=0.0438P
+ AD=0.282625P PS=0.605U PD=1.87U
* device instance _3139 m0 *1 515.925,778.77 nfet_05v0
XM_3139 n_166 n_I4128 VSS VSS nfet_05v0 L=0.6U W=0.82U AS=0.282625P AD=0.3608P
+ PS=1.87U PD=2.52U
* device instance _3140 m0 *1 509.195,779 nfet_05v0
XM_3140 VSS n_I2054 n_I4126 VSS nfet_05v0 L=0.6U W=0.36U AS=0.333P AD=0.0936P
+ PS=2.57U PD=0.88U
* device instance _3141 m0 *1 510.315,779 nfet_05v0
XM_3141 n_I4129 n_I4126 VSS VSS nfet_05v0 L=0.6U W=0.36U AS=0.0936P AD=0.0432P
+ PS=0.88U PD=0.6U
* device instance _3142 m0 *1 511.155,779 nfet_05v0
XM_3142 n_I4127 n_I4126 n_I4129 VSS nfet_05v0 L=0.6U W=0.36U AS=0.0432P
+ AD=0.369P PS=0.6U PD=2.77U
* device instance _3143 m0 *1 522.345,776.23 pfet_05v0
XM_3143 n_I4139 n_I4134 n_I4135 VDD_DEC pfet_05v0 L=0.5U W=0.36U AS=0.3456P
+ AD=0.0612P PS=2.64U PD=0.7U
* device instance _3144 m0 *1 523.185,776.23 pfet_05v0
XM_3144 n_I4139 n_I4134 VDD_DEC VDD_DEC pfet_05v0 L=0.5U W=0.36U AS=0.379P
+ AD=0.0612P PS=2.37U PD=0.7U
* device instance _3145 m0 *1 524.835,776.55 pfet_05v0
XM_3145 n_190 n_I4135 VDD_DEC VDD_DEC pfet_05v0 L=0.5U W=1.22U AS=0.379P
+ AD=0.5368P PS=2.37U PD=3.32U
* device instance _3146 m0 *1 518.105,776.12 pfet_05v0
XM_3146 VDD_DEC n_I2056 n_I4133 VDD_DEC pfet_05v0 L=0.5U W=0.36U AS=0.3852P
+ AD=0.1116P PS=2.86U PD=0.98U
* device instance _3147 m0 *1 519.225,776.12 pfet_05v0
XM_3147 n_I4138 n_I4133 VDD_DEC VDD_DEC pfet_05v0 L=0.5U W=0.36U AS=0.1116P
+ AD=0.0612P PS=0.98U PD=0.7U
* device instance _3148 m0 *1 520.065,776.12 pfet_05v0
XM_3148 n_I4138 n_I4133 n_I4134 VDD_DEC pfet_05v0 L=0.5U W=0.36U AS=0.3852P
+ AD=0.0612P PS=2.86U PD=0.7U
* device instance _3149 m0 *1 522.395,778.998 nfet_05v0
XM_3149 n_I4137 n_I4134 n_I4135 VSS nfet_05v0 L=0.6U W=0.365U AS=0.3705P
+ AD=0.0438P PS=2.77U PD=0.605U
* device instance _3150 m0 *1 523.235,778.998 nfet_05v0
XM_3150 VSS n_I4134 n_I4137 VSS nfet_05v0 L=0.6U W=0.365U AS=0.0438P
+ AD=0.282625P PS=0.605U PD=1.87U
* device instance _3151 m0 *1 524.885,778.77 nfet_05v0
XM_3151 n_190 n_I4135 VSS VSS nfet_05v0 L=0.6U W=0.82U AS=0.282625P AD=0.3608P
+ PS=1.87U PD=2.52U
* device instance _3152 m0 *1 518.155,779 nfet_05v0
XM_3152 VSS n_I2056 n_I4133 VSS nfet_05v0 L=0.6U W=0.36U AS=0.333P AD=0.0936P
+ PS=2.57U PD=0.88U
* device instance _3153 m0 *1 519.275,779 nfet_05v0
XM_3153 n_I4136 n_I4133 VSS VSS nfet_05v0 L=0.6U W=0.36U AS=0.0936P AD=0.0432P
+ PS=0.88U PD=0.6U
* device instance _3154 m0 *1 520.115,779 nfet_05v0
XM_3154 n_I4134 n_I4133 n_I4136 VSS nfet_05v0 L=0.6U W=0.36U AS=0.0432P
+ AD=0.369P PS=0.6U PD=2.77U
* device instance _3155 r180 *1 579.895,815.43 pfet_05v0
XM_3155 n_I4146 n_I4141 n_I4142 VDD_DEC pfet_05v0 L=0.5U W=0.36U AS=0.3456P
+ AD=0.0612P PS=2.64U PD=0.7U
* device instance _3156 r180 *1 579.055,815.43 pfet_05v0
XM_3156 n_I4146 n_I4141 VDD_DEC VDD_DEC pfet_05v0 L=0.5U W=0.36U AS=0.379P
+ AD=0.0612P PS=2.37U PD=0.7U
* device instance _3157 r180 *1 577.405,815.75 pfet_05v0
XM_3157 n_I2384 n_I4142 VDD_DEC VDD_DEC pfet_05v0 L=0.5U W=1.22U AS=0.379P
+ AD=0.5368P PS=2.37U PD=3.32U
* device instance _3158 r180 *1 584.135,815.32 pfet_05v0
XM_3158 VDD_DEC n_I2334 n_I4140 VDD_DEC pfet_05v0 L=0.5U W=0.36U AS=0.3852P
+ AD=0.1116P PS=2.86U PD=0.98U
* device instance _3159 r180 *1 583.015,815.32 pfet_05v0
XM_3159 n_I4145 n_I4140 VDD_DEC VDD_DEC pfet_05v0 L=0.5U W=0.36U AS=0.1116P
+ AD=0.0612P PS=0.98U PD=0.7U
* device instance _3160 r180 *1 582.175,815.32 pfet_05v0
XM_3160 n_I4145 n_I4140 n_I4141 VDD_DEC pfet_05v0 L=0.5U W=0.36U AS=0.3852P
+ AD=0.0612P PS=2.86U PD=0.7U
* device instance _3161 r180 *1 579.845,818.198 nfet_05v0
XM_3161 n_I4144 n_I4141 n_I4142 VSS nfet_05v0 L=0.6U W=0.365U AS=0.3705P
+ AD=0.0438P PS=2.77U PD=0.605U
* device instance _3162 r180 *1 579.005,818.198 nfet_05v0
XM_3162 VSS n_I4141 n_I4144 VSS nfet_05v0 L=0.6U W=0.365U AS=0.0438P
+ AD=0.282625P PS=0.605U PD=1.87U
* device instance _3163 r180 *1 577.355,817.97 nfet_05v0
XM_3163 n_I2384 n_I4142 VSS VSS nfet_05v0 L=0.6U W=0.82U AS=0.282625P AD=0.3608P
+ PS=1.87U PD=2.52U
* device instance _3164 r180 *1 584.085,818.2 nfet_05v0
XM_3164 VSS n_I2334 n_I4140 VSS nfet_05v0 L=0.6U W=0.36U AS=0.333P AD=0.0936P
+ PS=2.57U PD=0.88U
* device instance _3165 r180 *1 582.965,818.2 nfet_05v0
XM_3165 n_I4143 n_I4140 VSS VSS nfet_05v0 L=0.6U W=0.36U AS=0.0936P AD=0.0432P
+ PS=0.88U PD=0.6U
* device instance _3166 r180 *1 582.125,818.2 nfet_05v0
XM_3166 n_I4141 n_I4140 n_I4143 VSS nfet_05v0 L=0.6U W=0.36U AS=0.0432P
+ AD=0.369P PS=0.6U PD=2.77U
* device instance _3167 r180 *1 609.015,807.59 pfet_05v0
XM_3167 n_I4153 n_I4148 n_I4149 VDD_DEC pfet_05v0 L=0.5U W=0.36U AS=0.3456P
+ AD=0.0612P PS=2.64U PD=0.7U
* device instance _3168 r180 *1 608.175,807.59 pfet_05v0
XM_3168 n_I4153 n_I4148 VDD_DEC VDD_DEC pfet_05v0 L=0.5U W=0.36U AS=0.379P
+ AD=0.0612P PS=2.37U PD=0.7U
* device instance _3169 r180 *1 606.525,807.91 pfet_05v0
XM_3169 n_I2284 n_I4149 VDD_DEC VDD_DEC pfet_05v0 L=0.5U W=1.22U AS=0.379P
+ AD=0.5368P PS=2.37U PD=3.32U
* device instance _3170 r180 *1 613.255,807.48 pfet_05v0
XM_3170 VDD_DEC n_I2341 n_I4147 VDD_DEC pfet_05v0 L=0.5U W=0.36U AS=0.3852P
+ AD=0.1116P PS=2.86U PD=0.98U
* device instance _3171 r180 *1 612.135,807.48 pfet_05v0
XM_3171 n_I4152 n_I4147 VDD_DEC VDD_DEC pfet_05v0 L=0.5U W=0.36U AS=0.1116P
+ AD=0.0612P PS=0.98U PD=0.7U
* device instance _3172 r180 *1 611.295,807.48 pfet_05v0
XM_3172 n_I4152 n_I4147 n_I4148 VDD_DEC pfet_05v0 L=0.5U W=0.36U AS=0.3852P
+ AD=0.0612P PS=2.86U PD=0.7U
* device instance _3173 r180 *1 608.965,810.358 nfet_05v0
XM_3173 n_I4151 n_I4148 n_I4149 VSS nfet_05v0 L=0.6U W=0.365U AS=0.3705P
+ AD=0.0438P PS=2.77U PD=0.605U
* device instance _3174 r180 *1 608.125,810.358 nfet_05v0
XM_3174 VSS n_I4148 n_I4151 VSS nfet_05v0 L=0.6U W=0.365U AS=0.0438P
+ AD=0.282625P PS=0.605U PD=1.87U
* device instance _3175 r180 *1 606.475,810.13 nfet_05v0
XM_3175 n_I2284 n_I4149 VSS VSS nfet_05v0 L=0.6U W=0.82U AS=0.282625P AD=0.3608P
+ PS=1.87U PD=2.52U
* device instance _3176 r180 *1 613.205,810.36 nfet_05v0
XM_3176 VSS n_I2341 n_I4147 VSS nfet_05v0 L=0.6U W=0.36U AS=0.333P AD=0.0936P
+ PS=2.57U PD=0.88U
* device instance _3177 r180 *1 612.085,810.36 nfet_05v0
XM_3177 n_I4150 n_I4147 VSS VSS nfet_05v0 L=0.6U W=0.36U AS=0.0936P AD=0.0432P
+ PS=0.88U PD=0.6U
* device instance _3178 r180 *1 611.245,810.36 nfet_05v0
XM_3178 n_I4148 n_I4147 n_I4150 VSS nfet_05v0 L=0.6U W=0.36U AS=0.0432P
+ AD=0.369P PS=0.6U PD=2.77U
* device instance _3179 r180 *1 598.935,791.91 pfet_05v0
XM_3179 n_I4160 n_I4155 n_I4156 VDD_DEC pfet_05v0 L=0.5U W=0.36U AS=0.3456P
+ AD=0.0612P PS=2.64U PD=0.7U
* device instance _3180 r180 *1 598.095,791.91 pfet_05v0
XM_3180 n_I4160 n_I4155 VDD_DEC VDD_DEC pfet_05v0 L=0.5U W=0.36U AS=0.379P
+ AD=0.0612P PS=2.37U PD=0.7U
* device instance _3181 r180 *1 596.445,792.23 pfet_05v0
XM_3181 n_I2171 n_I4156 VDD_DEC VDD_DEC pfet_05v0 L=0.5U W=1.22U AS=0.379P
+ AD=0.5368P PS=2.37U PD=3.32U
* device instance _3182 r180 *1 603.175,791.8 pfet_05v0
XM_3182 VDD_DEC n_I2338 n_I4154 VDD_DEC pfet_05v0 L=0.5U W=0.36U AS=0.3852P
+ AD=0.1116P PS=2.86U PD=0.98U
* device instance _3183 r180 *1 602.055,791.8 pfet_05v0
XM_3183 n_I4159 n_I4154 VDD_DEC VDD_DEC pfet_05v0 L=0.5U W=0.36U AS=0.1116P
+ AD=0.0612P PS=0.98U PD=0.7U
* device instance _3184 r180 *1 601.215,791.8 pfet_05v0
XM_3184 n_I4159 n_I4154 n_I4155 VDD_DEC pfet_05v0 L=0.5U W=0.36U AS=0.3852P
+ AD=0.0612P PS=2.86U PD=0.7U
* device instance _3185 r180 *1 598.885,794.678 nfet_05v0
XM_3185 n_I4158 n_I4155 n_I4156 VSS nfet_05v0 L=0.6U W=0.365U AS=0.3705P
+ AD=0.0438P PS=2.77U PD=0.605U
* device instance _3186 r180 *1 598.045,794.678 nfet_05v0
XM_3186 VSS n_I4155 n_I4158 VSS nfet_05v0 L=0.6U W=0.365U AS=0.0438P
+ AD=0.282625P PS=0.605U PD=1.87U
* device instance _3187 r180 *1 596.395,794.45 nfet_05v0
XM_3187 n_I2171 n_I4156 VSS VSS nfet_05v0 L=0.6U W=0.82U AS=0.282625P AD=0.3608P
+ PS=1.87U PD=2.52U
* device instance _3188 r180 *1 603.125,794.68 nfet_05v0
XM_3188 VSS n_I2338 n_I4154 VSS nfet_05v0 L=0.6U W=0.36U AS=0.333P AD=0.0936P
+ PS=2.57U PD=0.88U
* device instance _3189 r180 *1 602.005,794.68 nfet_05v0
XM_3189 n_I4157 n_I4154 VSS VSS nfet_05v0 L=0.6U W=0.36U AS=0.0936P AD=0.0432P
+ PS=0.88U PD=0.6U
* device instance _3190 r180 *1 601.165,794.68 nfet_05v0
XM_3190 n_I4155 n_I4154 n_I4157 VSS nfet_05v0 L=0.6U W=0.36U AS=0.0432P
+ AD=0.369P PS=0.6U PD=2.77U
* device instance _3191 r180 *1 580.455,776.23 pfet_05v0
XM_3191 n_I4167 n_I4162 n_I4163 VDD_DEC pfet_05v0 L=0.5U W=0.36U AS=0.3456P
+ AD=0.0612P PS=2.64U PD=0.7U
* device instance _3192 r180 *1 579.615,776.23 pfet_05v0
XM_3192 n_I4167 n_I4162 VDD_DEC VDD_DEC pfet_05v0 L=0.5U W=0.36U AS=0.379P
+ AD=0.0612P PS=2.37U PD=0.7U
* device instance _3193 r180 *1 577.965,776.55 pfet_05v0
XM_3193 n_88 n_I4163 VDD_DEC VDD_DEC pfet_05v0 L=0.5U W=1.22U AS=0.379P
+ AD=0.5368P PS=2.37U PD=3.32U
* device instance _3194 r180 *1 584.695,776.12 pfet_05v0
XM_3194 VDD_DEC n_I2067 n_I4161 VDD_DEC pfet_05v0 L=0.5U W=0.36U AS=0.3852P
+ AD=0.1116P PS=2.86U PD=0.98U
* device instance _3195 r180 *1 583.575,776.12 pfet_05v0
XM_3195 n_I4166 n_I4161 VDD_DEC VDD_DEC pfet_05v0 L=0.5U W=0.36U AS=0.1116P
+ AD=0.0612P PS=0.98U PD=0.7U
* device instance _3196 r180 *1 582.735,776.12 pfet_05v0
XM_3196 n_I4166 n_I4161 n_I4162 VDD_DEC pfet_05v0 L=0.5U W=0.36U AS=0.3852P
+ AD=0.0612P PS=2.86U PD=0.7U
* device instance _3197 r180 *1 580.405,778.998 nfet_05v0
XM_3197 n_I4165 n_I4162 n_I4163 VSS nfet_05v0 L=0.6U W=0.365U AS=0.3705P
+ AD=0.0438P PS=2.77U PD=0.605U
* device instance _3198 r180 *1 579.565,778.998 nfet_05v0
XM_3198 VSS n_I4162 n_I4165 VSS nfet_05v0 L=0.6U W=0.365U AS=0.0438P
+ AD=0.282625P PS=0.605U PD=1.87U
* device instance _3199 r180 *1 577.915,778.77 nfet_05v0
XM_3199 n_88 n_I4163 VSS VSS nfet_05v0 L=0.6U W=0.82U AS=0.282625P AD=0.3608P
+ PS=1.87U PD=2.52U
* device instance _3200 r180 *1 584.645,779 nfet_05v0
XM_3200 VSS n_I2067 n_I4161 VSS nfet_05v0 L=0.6U W=0.36U AS=0.333P AD=0.0936P
+ PS=2.57U PD=0.88U
* device instance _3201 r180 *1 583.525,779 nfet_05v0
XM_3201 n_I4164 n_I4161 VSS VSS nfet_05v0 L=0.6U W=0.36U AS=0.0936P AD=0.0432P
+ PS=0.88U PD=0.6U
* device instance _3202 r180 *1 582.685,779 nfet_05v0
XM_3202 n_I4162 n_I4161 n_I4164 VSS nfet_05v0 L=0.6U W=0.36U AS=0.0432P
+ AD=0.369P PS=0.6U PD=2.77U
* device instance _3203 r180 *1 588.855,815.43 pfet_05v0
XM_3203 n_I4174 n_I4169 n_I4170 VDD_DEC pfet_05v0 L=0.5U W=0.36U AS=0.3456P
+ AD=0.0612P PS=2.64U PD=0.7U
* device instance _3204 r180 *1 588.015,815.43 pfet_05v0
XM_3204 n_I4174 n_I4169 VDD_DEC VDD_DEC pfet_05v0 L=0.5U W=0.36U AS=0.379P
+ AD=0.0612P PS=2.37U PD=0.7U
* device instance _3205 r180 *1 586.365,815.75 pfet_05v0
XM_3205 n_I2211 n_I4170 VDD_DEC VDD_DEC pfet_05v0 L=0.5U W=1.22U AS=0.379P
+ AD=0.5368P PS=2.37U PD=3.32U
* device instance _3206 r180 *1 593.095,815.32 pfet_05v0
XM_3206 VDD_DEC n_I2288 n_I4168 VDD_DEC pfet_05v0 L=0.5U W=0.36U AS=0.3852P
+ AD=0.1116P PS=2.86U PD=0.98U
* device instance _3207 r180 *1 591.975,815.32 pfet_05v0
XM_3207 n_I4173 n_I4168 VDD_DEC VDD_DEC pfet_05v0 L=0.5U W=0.36U AS=0.1116P
+ AD=0.0612P PS=0.98U PD=0.7U
* device instance _3208 r180 *1 591.135,815.32 pfet_05v0
XM_3208 n_I4173 n_I4168 n_I4169 VDD_DEC pfet_05v0 L=0.5U W=0.36U AS=0.3852P
+ AD=0.0612P PS=2.86U PD=0.7U
* device instance _3209 r180 *1 588.805,818.198 nfet_05v0
XM_3209 n_I4172 n_I4169 n_I4170 VSS nfet_05v0 L=0.6U W=0.365U AS=0.3705P
+ AD=0.0438P PS=2.77U PD=0.605U
* device instance _3210 r180 *1 587.965,818.198 nfet_05v0
XM_3210 VSS n_I4169 n_I4172 VSS nfet_05v0 L=0.6U W=0.365U AS=0.0438P
+ AD=0.282625P PS=0.605U PD=1.87U
* device instance _3211 r180 *1 586.315,817.97 nfet_05v0
XM_3211 n_I2211 n_I4170 VSS VSS nfet_05v0 L=0.6U W=0.82U AS=0.282625P AD=0.3608P
+ PS=1.87U PD=2.52U
* device instance _3212 r180 *1 593.045,818.2 nfet_05v0
XM_3212 VSS n_I2288 n_I4168 VSS nfet_05v0 L=0.6U W=0.36U AS=0.333P AD=0.0936P
+ PS=2.57U PD=0.88U
* device instance _3213 r180 *1 591.925,818.2 nfet_05v0
XM_3213 n_I4171 n_I4168 VSS VSS nfet_05v0 L=0.6U W=0.36U AS=0.0936P AD=0.0432P
+ PS=0.88U PD=0.6U
* device instance _3214 r180 *1 591.085,818.2 nfet_05v0
XM_3214 n_I4169 n_I4168 n_I4171 VSS nfet_05v0 L=0.6U W=0.36U AS=0.0432P
+ AD=0.369P PS=0.6U PD=2.77U
* device instance _3215 r180 *1 610.695,815.43 pfet_05v0
XM_3215 n_I4181 n_I4176 n_I4177 VDD_DEC pfet_05v0 L=0.5U W=0.36U AS=0.3456P
+ AD=0.0612P PS=2.64U PD=0.7U
* device instance _3216 r180 *1 609.855,815.43 pfet_05v0
XM_3216 n_I4181 n_I4176 VDD_DEC VDD_DEC pfet_05v0 L=0.5U W=0.36U AS=0.379P
+ AD=0.0612P PS=2.37U PD=0.7U
* device instance _3217 r180 *1 608.205,815.75 pfet_05v0
XM_3217 n_I2210 n_I4177 VDD_DEC VDD_DEC pfet_05v0 L=0.5U W=1.22U AS=0.379P
+ AD=0.5368P PS=2.37U PD=3.32U
* device instance _3218 r180 *1 614.935,815.32 pfet_05v0
XM_3218 VDD_DEC n_I2341 n_I4175 VDD_DEC pfet_05v0 L=0.5U W=0.36U AS=0.3852P
+ AD=0.1116P PS=2.86U PD=0.98U
* device instance _3219 r180 *1 613.815,815.32 pfet_05v0
XM_3219 n_I4180 n_I4175 VDD_DEC VDD_DEC pfet_05v0 L=0.5U W=0.36U AS=0.1116P
+ AD=0.0612P PS=0.98U PD=0.7U
* device instance _3220 r180 *1 612.975,815.32 pfet_05v0
XM_3220 n_I4180 n_I4175 n_I4176 VDD_DEC pfet_05v0 L=0.5U W=0.36U AS=0.3852P
+ AD=0.0612P PS=2.86U PD=0.7U
* device instance _3221 r180 *1 610.645,818.198 nfet_05v0
XM_3221 n_I4179 n_I4176 n_I4177 VSS nfet_05v0 L=0.6U W=0.365U AS=0.3705P
+ AD=0.0438P PS=2.77U PD=0.605U
* device instance _3222 r180 *1 609.805,818.198 nfet_05v0
XM_3222 VSS n_I4176 n_I4179 VSS nfet_05v0 L=0.6U W=0.365U AS=0.0438P
+ AD=0.282625P PS=0.605U PD=1.87U
* device instance _3223 r180 *1 608.155,817.97 nfet_05v0
XM_3223 n_I2210 n_I4177 VSS VSS nfet_05v0 L=0.6U W=0.82U AS=0.282625P AD=0.3608P
+ PS=1.87U PD=2.52U
* device instance _3224 r180 *1 614.885,818.2 nfet_05v0
XM_3224 VSS n_I2341 n_I4175 VSS nfet_05v0 L=0.6U W=0.36U AS=0.333P AD=0.0936P
+ PS=2.57U PD=0.88U
* device instance _3225 r180 *1 613.765,818.2 nfet_05v0
XM_3225 n_I4178 n_I4175 VSS VSS nfet_05v0 L=0.6U W=0.36U AS=0.0936P AD=0.0432P
+ PS=0.88U PD=0.6U
* device instance _3226 r180 *1 612.925,818.2 nfet_05v0
XM_3226 n_I4176 n_I4175 n_I4178 VSS nfet_05v0 L=0.6U W=0.36U AS=0.0432P
+ AD=0.369P PS=0.6U PD=2.77U
* device instance _3227 r180 *1 595.575,799.75 pfet_05v0
XM_3227 n_I4188 n_I4183 n_I4184 VDD_DEC pfet_05v0 L=0.5U W=0.36U AS=0.3456P
+ AD=0.0612P PS=2.64U PD=0.7U
* device instance _3228 r180 *1 594.735,799.75 pfet_05v0
XM_3228 n_I4188 n_I4183 VDD_DEC VDD_DEC pfet_05v0 L=0.5U W=0.36U AS=0.379P
+ AD=0.0612P PS=2.37U PD=0.7U
* device instance _3229 r180 *1 593.085,800.07 pfet_05v0
XM_3229 n_I2172 n_I4184 VDD_DEC VDD_DEC pfet_05v0 L=0.5U W=1.22U AS=0.379P
+ AD=0.5368P PS=2.37U PD=3.32U
* device instance _3230 r180 *1 599.815,799.64 pfet_05v0
XM_3230 VDD_DEC n_I2211 n_I4182 VDD_DEC pfet_05v0 L=0.5U W=0.36U AS=0.3852P
+ AD=0.1116P PS=2.86U PD=0.98U
* device instance _3231 r180 *1 598.695,799.64 pfet_05v0
XM_3231 n_I4187 n_I4182 VDD_DEC VDD_DEC pfet_05v0 L=0.5U W=0.36U AS=0.1116P
+ AD=0.0612P PS=0.98U PD=0.7U
* device instance _3232 r180 *1 597.855,799.64 pfet_05v0
XM_3232 n_I4187 n_I4182 n_I4183 VDD_DEC pfet_05v0 L=0.5U W=0.36U AS=0.3852P
+ AD=0.0612P PS=2.86U PD=0.7U
* device instance _3233 r180 *1 595.525,802.518 nfet_05v0
XM_3233 n_I4186 n_I4183 n_I4184 VSS nfet_05v0 L=0.6U W=0.365U AS=0.3705P
+ AD=0.0438P PS=2.77U PD=0.605U
* device instance _3234 r180 *1 594.685,802.518 nfet_05v0
XM_3234 VSS n_I4183 n_I4186 VSS nfet_05v0 L=0.6U W=0.365U AS=0.0438P
+ AD=0.282625P PS=0.605U PD=1.87U
* device instance _3235 r180 *1 593.035,802.29 nfet_05v0
XM_3235 n_I2172 n_I4184 VSS VSS nfet_05v0 L=0.6U W=0.82U AS=0.282625P AD=0.3608P
+ PS=1.87U PD=2.52U
* device instance _3236 r180 *1 599.765,802.52 nfet_05v0
XM_3236 VSS n_I2211 n_I4182 VSS nfet_05v0 L=0.6U W=0.36U AS=0.333P AD=0.0936P
+ PS=2.57U PD=0.88U
* device instance _3237 r180 *1 598.645,802.52 nfet_05v0
XM_3237 n_I4185 n_I4182 VSS VSS nfet_05v0 L=0.6U W=0.36U AS=0.0936P AD=0.0432P
+ PS=0.88U PD=0.6U
* device instance _3238 r180 *1 597.805,802.52 nfet_05v0
XM_3238 n_I4183 n_I4182 n_I4185 VSS nfet_05v0 L=0.6U W=0.36U AS=0.0432P
+ AD=0.369P PS=0.6U PD=2.77U
* device instance _3239 r180 *1 505.975,807.59 pfet_05v0
XM_3239 n_I4195 n_I4190 n_I4191 VDD_DEC pfet_05v0 L=0.5U W=0.36U AS=0.3456P
+ AD=0.0612P PS=2.64U PD=0.7U
* device instance _3240 r180 *1 505.135,807.59 pfet_05v0
XM_3240 n_I4195 n_I4190 VDD_DEC VDD_DEC pfet_05v0 L=0.5U W=0.36U AS=0.379P
+ AD=0.0612P PS=2.37U PD=0.7U
* device instance _3241 r180 *1 503.485,807.91 pfet_05v0
XM_3241 n_I2353 n_I4191 VDD_DEC VDD_DEC pfet_05v0 L=0.5U W=1.22U AS=0.379P
+ AD=0.5368P PS=2.37U PD=3.32U
* device instance _3242 r180 *1 510.215,807.48 pfet_05v0
XM_3242 VDD_DEC n_I2355 n_I4189 VDD_DEC pfet_05v0 L=0.5U W=0.36U AS=0.3852P
+ AD=0.1116P PS=2.86U PD=0.98U
* device instance _3243 r180 *1 509.095,807.48 pfet_05v0
XM_3243 n_I4194 n_I4189 VDD_DEC VDD_DEC pfet_05v0 L=0.5U W=0.36U AS=0.1116P
+ AD=0.0612P PS=0.98U PD=0.7U
* device instance _3244 r180 *1 508.255,807.48 pfet_05v0
XM_3244 n_I4194 n_I4189 n_I4190 VDD_DEC pfet_05v0 L=0.5U W=0.36U AS=0.3852P
+ AD=0.0612P PS=2.86U PD=0.7U
* device instance _3245 r180 *1 505.925,810.358 nfet_05v0
XM_3245 n_I4193 n_I4190 n_I4191 VSS nfet_05v0 L=0.6U W=0.365U AS=0.3705P
+ AD=0.0438P PS=2.77U PD=0.605U
* device instance _3246 r180 *1 505.085,810.358 nfet_05v0
XM_3246 VSS n_I4190 n_I4193 VSS nfet_05v0 L=0.6U W=0.365U AS=0.0438P
+ AD=0.282625P PS=0.605U PD=1.87U
* device instance _3247 r180 *1 503.435,810.13 nfet_05v0
XM_3247 n_I2353 n_I4191 VSS VSS nfet_05v0 L=0.6U W=0.82U AS=0.282625P AD=0.3608P
+ PS=1.87U PD=2.52U
* device instance _3248 r180 *1 510.165,810.36 nfet_05v0
XM_3248 VSS n_I2355 n_I4189 VSS nfet_05v0 L=0.6U W=0.36U AS=0.333P AD=0.0936P
+ PS=2.57U PD=0.88U
* device instance _3249 r180 *1 509.045,810.36 nfet_05v0
XM_3249 n_I4192 n_I4189 VSS VSS nfet_05v0 L=0.6U W=0.36U AS=0.0936P AD=0.0432P
+ PS=0.88U PD=0.6U
* device instance _3250 r180 *1 508.205,810.36 nfet_05v0
XM_3250 n_I4190 n_I4189 n_I4192 VSS nfet_05v0 L=0.6U W=0.36U AS=0.0432P
+ AD=0.369P PS=0.6U PD=2.77U
* device instance _3251 r180 *1 653.255,807.59 pfet_05v0
XM_3251 n_I4202 n_I4197 n_I4198 VDD_DEC pfet_05v0 L=0.5U W=0.36U AS=0.3456P
+ AD=0.0612P PS=2.64U PD=0.7U
* device instance _3252 r180 *1 652.415,807.59 pfet_05v0
XM_3252 n_I4202 n_I4197 VDD_DEC VDD_DEC pfet_05v0 L=0.5U W=0.36U AS=0.379P
+ AD=0.0612P PS=2.37U PD=0.7U
* device instance _3253 r180 *1 650.765,807.91 pfet_05v0
XM_3253 n_I2342 n_I4198 VDD_DEC VDD_DEC pfet_05v0 L=0.5U W=1.22U AS=0.379P
+ AD=0.5368P PS=2.37U PD=3.32U
* device instance _3254 r180 *1 657.495,807.48 pfet_05v0
XM_3254 VDD_DEC n_I2344 n_I4196 VDD_DEC pfet_05v0 L=0.5U W=0.36U AS=0.3852P
+ AD=0.1116P PS=2.86U PD=0.98U
* device instance _3255 r180 *1 656.375,807.48 pfet_05v0
XM_3255 n_I4201 n_I4196 VDD_DEC VDD_DEC pfet_05v0 L=0.5U W=0.36U AS=0.1116P
+ AD=0.0612P PS=0.98U PD=0.7U
* device instance _3256 r180 *1 655.535,807.48 pfet_05v0
XM_3256 n_I4201 n_I4196 n_I4197 VDD_DEC pfet_05v0 L=0.5U W=0.36U AS=0.3852P
+ AD=0.0612P PS=2.86U PD=0.7U
* device instance _3257 r180 *1 653.205,810.358 nfet_05v0
XM_3257 n_I4200 n_I4197 n_I4198 VSS nfet_05v0 L=0.6U W=0.365U AS=0.3705P
+ AD=0.0438P PS=2.77U PD=0.605U
* device instance _3258 r180 *1 652.365,810.358 nfet_05v0
XM_3258 VSS n_I4197 n_I4200 VSS nfet_05v0 L=0.6U W=0.365U AS=0.0438P
+ AD=0.282625P PS=0.605U PD=1.87U
* device instance _3259 r180 *1 650.715,810.13 nfet_05v0
XM_3259 n_I2342 n_I4198 VSS VSS nfet_05v0 L=0.6U W=0.82U AS=0.282625P AD=0.3608P
+ PS=1.87U PD=2.52U
* device instance _3260 r180 *1 657.445,810.36 nfet_05v0
XM_3260 VSS n_I2344 n_I4196 VSS nfet_05v0 L=0.6U W=0.36U AS=0.333P AD=0.0936P
+ PS=2.57U PD=0.88U
* device instance _3261 r180 *1 656.325,810.36 nfet_05v0
XM_3261 n_I4199 n_I4196 VSS VSS nfet_05v0 L=0.6U W=0.36U AS=0.0936P AD=0.0432P
+ PS=0.88U PD=0.6U
* device instance _3262 r180 *1 655.485,810.36 nfet_05v0
XM_3262 n_I4197 n_I4196 n_I4199 VSS nfet_05v0 L=0.6U W=0.36U AS=0.0432P
+ AD=0.369P PS=0.6U PD=2.77U
* device instance _3263 r180 *1 540.695,807.59 pfet_05v0
XM_3263 n_I4209 n_I4204 n_I4205 VDD_DEC pfet_05v0 L=0.5U W=0.36U AS=0.3456P
+ AD=0.0612P PS=2.64U PD=0.7U
* device instance _3264 r180 *1 539.855,807.59 pfet_05v0
XM_3264 n_I4209 n_I4204 VDD_DEC VDD_DEC pfet_05v0 L=0.5U W=0.36U AS=0.379P
+ AD=0.0612P PS=2.37U PD=0.7U
* device instance _3265 r180 *1 538.205,807.91 pfet_05v0
XM_3265 n_I2379 n_I4205 VDD_DEC VDD_DEC pfet_05v0 L=0.5U W=1.22U AS=0.379P
+ AD=0.5368P PS=2.37U PD=3.32U
* device instance _3266 r180 *1 544.935,807.48 pfet_05v0
XM_3266 VDD_DEC n_I2334 n_I4203 VDD_DEC pfet_05v0 L=0.5U W=0.36U AS=0.3852P
+ AD=0.1116P PS=2.86U PD=0.98U
* device instance _3267 r180 *1 543.815,807.48 pfet_05v0
XM_3267 n_I4208 n_I4203 VDD_DEC VDD_DEC pfet_05v0 L=0.5U W=0.36U AS=0.1116P
+ AD=0.0612P PS=0.98U PD=0.7U
* device instance _3268 r180 *1 542.975,807.48 pfet_05v0
XM_3268 n_I4208 n_I4203 n_I4204 VDD_DEC pfet_05v0 L=0.5U W=0.36U AS=0.3852P
+ AD=0.0612P PS=2.86U PD=0.7U
* device instance _3269 r180 *1 540.645,810.358 nfet_05v0
XM_3269 n_I4207 n_I4204 n_I4205 VSS nfet_05v0 L=0.6U W=0.365U AS=0.3705P
+ AD=0.0438P PS=2.77U PD=0.605U
* device instance _3270 r180 *1 539.805,810.358 nfet_05v0
XM_3270 VSS n_I4204 n_I4207 VSS nfet_05v0 L=0.6U W=0.365U AS=0.0438P
+ AD=0.282625P PS=0.605U PD=1.87U
* device instance _3271 r180 *1 538.155,810.13 nfet_05v0
XM_3271 n_I2379 n_I4205 VSS VSS nfet_05v0 L=0.6U W=0.82U AS=0.282625P AD=0.3608P
+ PS=1.87U PD=2.52U
* device instance _3272 r180 *1 544.885,810.36 nfet_05v0
XM_3272 VSS n_I2334 n_I4203 VSS nfet_05v0 L=0.6U W=0.36U AS=0.333P AD=0.0936P
+ PS=2.57U PD=0.88U
* device instance _3273 r180 *1 543.765,810.36 nfet_05v0
XM_3273 n_I4206 n_I4203 VSS VSS nfet_05v0 L=0.6U W=0.36U AS=0.0936P AD=0.0432P
+ PS=0.88U PD=0.6U
* device instance _3274 r180 *1 542.925,810.36 nfet_05v0
XM_3274 n_I4204 n_I4203 n_I4206 VSS nfet_05v0 L=0.6U W=0.36U AS=0.0432P
+ AD=0.369P PS=0.6U PD=2.77U
* device instance _3275 r180 *1 569.815,815.43 pfet_05v0
XM_3275 n_I4216 n_I4211 n_I4212 VDD_DEC pfet_05v0 L=0.5U W=0.36U AS=0.3456P
+ AD=0.0612P PS=2.64U PD=0.7U
* device instance _3276 r180 *1 568.975,815.43 pfet_05v0
XM_3276 n_I4216 n_I4211 VDD_DEC VDD_DEC pfet_05v0 L=0.5U W=0.36U AS=0.379P
+ AD=0.0612P PS=2.37U PD=0.7U
* device instance _3277 r180 *1 567.325,815.75 pfet_05v0
XM_3277 n_I2280 n_I4212 VDD_DEC VDD_DEC pfet_05v0 L=0.5U W=1.22U AS=0.379P
+ AD=0.5368P PS=2.37U PD=3.32U
* device instance _3278 r180 *1 574.055,815.32 pfet_05v0
XM_3278 VDD_DEC n_I2342 n_I4210 VDD_DEC pfet_05v0 L=0.5U W=0.36U AS=0.3852P
+ AD=0.1116P PS=2.86U PD=0.98U
* device instance _3279 r180 *1 572.935,815.32 pfet_05v0
XM_3279 n_I4215 n_I4210 VDD_DEC VDD_DEC pfet_05v0 L=0.5U W=0.36U AS=0.1116P
+ AD=0.0612P PS=0.98U PD=0.7U
* device instance _3280 r180 *1 572.095,815.32 pfet_05v0
XM_3280 n_I4215 n_I4210 n_I4211 VDD_DEC pfet_05v0 L=0.5U W=0.36U AS=0.3852P
+ AD=0.0612P PS=2.86U PD=0.7U
* device instance _3281 r180 *1 569.765,818.198 nfet_05v0
XM_3281 n_I4214 n_I4211 n_I4212 VSS nfet_05v0 L=0.6U W=0.365U AS=0.3705P
+ AD=0.0438P PS=2.77U PD=0.605U
* device instance _3282 r180 *1 568.925,818.198 nfet_05v0
XM_3282 VSS n_I4211 n_I4214 VSS nfet_05v0 L=0.6U W=0.365U AS=0.0438P
+ AD=0.282625P PS=0.605U PD=1.87U
* device instance _3283 r180 *1 567.275,817.97 nfet_05v0
XM_3283 n_I2280 n_I4212 VSS VSS nfet_05v0 L=0.6U W=0.82U AS=0.282625P AD=0.3608P
+ PS=1.87U PD=2.52U
* device instance _3284 r180 *1 574.005,818.2 nfet_05v0
XM_3284 VSS n_I2342 n_I4210 VSS nfet_05v0 L=0.6U W=0.36U AS=0.333P AD=0.0936P
+ PS=2.57U PD=0.88U
* device instance _3285 r180 *1 572.885,818.2 nfet_05v0
XM_3285 n_I4213 n_I4210 VSS VSS nfet_05v0 L=0.6U W=0.36U AS=0.0936P AD=0.0432P
+ PS=0.88U PD=0.6U
* device instance _3286 r180 *1 572.045,818.2 nfet_05v0
XM_3286 n_I4211 n_I4210 n_I4213 VSS nfet_05v0 L=0.6U W=0.36U AS=0.0432P
+ AD=0.369P PS=0.6U PD=2.77U
* device instance _3287 r180 *1 666.135,815.43 pfet_05v0
XM_3287 n_I4223 n_I4218 n_I4219 VDD_DEC pfet_05v0 L=0.5U W=0.36U AS=0.3456P
+ AD=0.0612P PS=2.64U PD=0.7U
* device instance _3288 r180 *1 665.295,815.43 pfet_05v0
XM_3288 n_I4223 n_I4218 VDD_DEC VDD_DEC pfet_05v0 L=0.5U W=0.36U AS=0.379P
+ AD=0.0612P PS=2.37U PD=0.7U
* device instance _3289 r180 *1 663.645,815.75 pfet_05v0
XM_3289 n_18 n_I4219 VDD_DEC VDD_DEC pfet_05v0 L=0.5U W=1.22U AS=0.379P
+ AD=0.5368P PS=2.37U PD=3.32U
* device instance _3290 r180 *1 670.375,815.32 pfet_05v0
XM_3290 VDD_DEC n_I2370 n_I4217 VDD_DEC pfet_05v0 L=0.5U W=0.36U AS=0.3852P
+ AD=0.1116P PS=2.86U PD=0.98U
* device instance _3291 r180 *1 669.255,815.32 pfet_05v0
XM_3291 n_I4222 n_I4217 VDD_DEC VDD_DEC pfet_05v0 L=0.5U W=0.36U AS=0.1116P
+ AD=0.0612P PS=0.98U PD=0.7U
* device instance _3292 r180 *1 668.415,815.32 pfet_05v0
XM_3292 n_I4222 n_I4217 n_I4218 VDD_DEC pfet_05v0 L=0.5U W=0.36U AS=0.3852P
+ AD=0.0612P PS=2.86U PD=0.7U
* device instance _3293 r180 *1 666.085,818.198 nfet_05v0
XM_3293 n_I4221 n_I4218 n_I4219 VSS nfet_05v0 L=0.6U W=0.365U AS=0.3705P
+ AD=0.0438P PS=2.77U PD=0.605U
* device instance _3294 r180 *1 665.245,818.198 nfet_05v0
XM_3294 VSS n_I4218 n_I4221 VSS nfet_05v0 L=0.6U W=0.365U AS=0.0438P
+ AD=0.282625P PS=0.605U PD=1.87U
* device instance _3295 r180 *1 663.595,817.97 nfet_05v0
XM_3295 n_18 n_I4219 VSS VSS nfet_05v0 L=0.6U W=0.82U AS=0.282625P AD=0.3608P
+ PS=1.87U PD=2.52U
* device instance _3296 r180 *1 670.325,818.2 nfet_05v0
XM_3296 VSS n_I2370 n_I4217 VSS nfet_05v0 L=0.6U W=0.36U AS=0.333P AD=0.0936P
+ PS=2.57U PD=0.88U
* device instance _3297 r180 *1 669.205,818.2 nfet_05v0
XM_3297 n_I4220 n_I4217 VSS VSS nfet_05v0 L=0.6U W=0.36U AS=0.0936P AD=0.0432P
+ PS=0.88U PD=0.6U
* device instance _3298 r180 *1 668.365,818.2 nfet_05v0
XM_3298 n_I4218 n_I4217 n_I4220 VSS nfet_05v0 L=0.6U W=0.36U AS=0.0432P
+ AD=0.369P PS=0.6U PD=2.77U
* device instance _3299 r180 *1 550.775,815.43 pfet_05v0
XM_3299 n_I4230 n_I4225 n_I4226 VDD_DEC pfet_05v0 L=0.5U W=0.36U AS=0.3456P
+ AD=0.0612P PS=2.64U PD=0.7U
* device instance _3300 r180 *1 549.935,815.43 pfet_05v0
XM_3300 n_I4230 n_I4225 VDD_DEC VDD_DEC pfet_05v0 L=0.5U W=0.36U AS=0.379P
+ AD=0.0612P PS=2.37U PD=0.7U
* device instance _3301 r180 *1 548.285,815.75 pfet_05v0
XM_3301 n_I2332 n_I4226 VDD_DEC VDD_DEC pfet_05v0 L=0.5U W=1.22U AS=0.379P
+ AD=0.5368P PS=2.37U PD=3.32U
* device instance _3302 r180 *1 555.015,815.32 pfet_05v0
XM_3302 VDD_DEC n_I2337 n_I4224 VDD_DEC pfet_05v0 L=0.5U W=0.36U AS=0.3852P
+ AD=0.1116P PS=2.86U PD=0.98U
* device instance _3303 r180 *1 553.895,815.32 pfet_05v0
XM_3303 n_I4229 n_I4224 VDD_DEC VDD_DEC pfet_05v0 L=0.5U W=0.36U AS=0.1116P
+ AD=0.0612P PS=0.98U PD=0.7U
* device instance _3304 r180 *1 553.055,815.32 pfet_05v0
XM_3304 n_I4229 n_I4224 n_I4225 VDD_DEC pfet_05v0 L=0.5U W=0.36U AS=0.3852P
+ AD=0.0612P PS=2.86U PD=0.7U
* device instance _3305 r180 *1 550.725,818.198 nfet_05v0
XM_3305 n_I4228 n_I4225 n_I4226 VSS nfet_05v0 L=0.6U W=0.365U AS=0.3705P
+ AD=0.0438P PS=2.77U PD=0.605U
* device instance _3306 r180 *1 549.885,818.198 nfet_05v0
XM_3306 VSS n_I4225 n_I4228 VSS nfet_05v0 L=0.6U W=0.365U AS=0.0438P
+ AD=0.282625P PS=0.605U PD=1.87U
* device instance _3307 r180 *1 548.235,817.97 nfet_05v0
XM_3307 n_I2332 n_I4226 VSS VSS nfet_05v0 L=0.6U W=0.82U AS=0.282625P AD=0.3608P
+ PS=1.87U PD=2.52U
* device instance _3308 r180 *1 554.965,818.2 nfet_05v0
XM_3308 VSS n_I2337 n_I4224 VSS nfet_05v0 L=0.6U W=0.36U AS=0.333P AD=0.0936P
+ PS=2.57U PD=0.88U
* device instance _3309 r180 *1 553.845,818.2 nfet_05v0
XM_3309 n_I4227 n_I4224 VSS VSS nfet_05v0 L=0.6U W=0.36U AS=0.0936P AD=0.0432P
+ PS=0.88U PD=0.6U
* device instance _3310 r180 *1 553.005,818.2 nfet_05v0
XM_3310 n_I4225 n_I4224 n_I4227 VSS nfet_05v0 L=0.6U W=0.36U AS=0.0432P
+ AD=0.369P PS=0.6U PD=2.77U
* device instance _3311 r180 *1 635.335,807.59 pfet_05v0
XM_3311 n_I4237 n_I4232 n_I4233 VDD_DEC pfet_05v0 L=0.5U W=0.36U AS=0.3456P
+ AD=0.0612P PS=2.64U PD=0.7U
* device instance _3312 r180 *1 634.495,807.59 pfet_05v0
XM_3312 n_I4237 n_I4232 VDD_DEC VDD_DEC pfet_05v0 L=0.5U W=0.36U AS=0.379P
+ AD=0.0612P PS=2.37U PD=0.7U
* device instance _3313 r180 *1 632.845,807.91 pfet_05v0
XM_3313 n_I2286 n_I4233 VDD_DEC VDD_DEC pfet_05v0 L=0.5U W=1.22U AS=0.379P
+ AD=0.5368P PS=2.37U PD=3.32U
* device instance _3314 r180 *1 639.575,807.48 pfet_05v0
XM_3314 VDD_DEC n_I2311 n_I4231 VDD_DEC pfet_05v0 L=0.5U W=0.36U AS=0.3852P
+ AD=0.1116P PS=2.86U PD=0.98U
* device instance _3315 r180 *1 638.455,807.48 pfet_05v0
XM_3315 n_I4236 n_I4231 VDD_DEC VDD_DEC pfet_05v0 L=0.5U W=0.36U AS=0.1116P
+ AD=0.0612P PS=0.98U PD=0.7U
* device instance _3316 r180 *1 637.615,807.48 pfet_05v0
XM_3316 n_I4236 n_I4231 n_I4232 VDD_DEC pfet_05v0 L=0.5U W=0.36U AS=0.3852P
+ AD=0.0612P PS=2.86U PD=0.7U
* device instance _3317 r180 *1 635.285,810.358 nfet_05v0
XM_3317 n_I4235 n_I4232 n_I4233 VSS nfet_05v0 L=0.6U W=0.365U AS=0.3705P
+ AD=0.0438P PS=2.77U PD=0.605U
* device instance _3318 r180 *1 634.445,810.358 nfet_05v0
XM_3318 VSS n_I4232 n_I4235 VSS nfet_05v0 L=0.6U W=0.365U AS=0.0438P
+ AD=0.282625P PS=0.605U PD=1.87U
* device instance _3319 r180 *1 632.795,810.13 nfet_05v0
XM_3319 n_I2286 n_I4233 VSS VSS nfet_05v0 L=0.6U W=0.82U AS=0.282625P AD=0.3608P
+ PS=1.87U PD=2.52U
* device instance _3320 r180 *1 639.525,810.36 nfet_05v0
XM_3320 VSS n_I2311 n_I4231 VSS nfet_05v0 L=0.6U W=0.36U AS=0.333P AD=0.0936P
+ PS=2.57U PD=0.88U
* device instance _3321 r180 *1 638.405,810.36 nfet_05v0
XM_3321 n_I4234 n_I4231 VSS VSS nfet_05v0 L=0.6U W=0.36U AS=0.0936P AD=0.0432P
+ PS=0.88U PD=0.6U
* device instance _3322 r180 *1 637.565,810.36 nfet_05v0
XM_3322 n_I4232 n_I4231 n_I4234 VSS nfet_05v0 L=0.6U W=0.36U AS=0.0432P
+ AD=0.369P PS=0.6U PD=2.77U
* device instance _3323 r180 *1 531.735,807.59 pfet_05v0
XM_3323 n_I4244 n_I4239 n_I4240 VDD_DEC pfet_05v0 L=0.5U W=0.36U AS=0.3456P
+ AD=0.0612P PS=2.64U PD=0.7U
* device instance _3324 r180 *1 530.895,807.59 pfet_05v0
XM_3324 n_I4244 n_I4239 VDD_DEC VDD_DEC pfet_05v0 L=0.5U W=0.36U AS=0.379P
+ AD=0.0612P PS=2.37U PD=0.7U
* device instance _3325 r180 *1 529.245,807.91 pfet_05v0
XM_3325 n_I2250 n_I4240 VDD_DEC VDD_DEC pfet_05v0 L=0.5U W=1.22U AS=0.379P
+ AD=0.5368P PS=2.37U PD=3.32U
* device instance _3326 r180 *1 535.975,807.48 pfet_05v0
XM_3326 VDD_DEC n_I2169 n_I4238 VDD_DEC pfet_05v0 L=0.5U W=0.36U AS=0.3852P
+ AD=0.1116P PS=2.86U PD=0.98U
* device instance _3327 r180 *1 534.855,807.48 pfet_05v0
XM_3327 n_I4243 n_I4238 VDD_DEC VDD_DEC pfet_05v0 L=0.5U W=0.36U AS=0.1116P
+ AD=0.0612P PS=0.98U PD=0.7U
* device instance _3328 r180 *1 534.015,807.48 pfet_05v0
XM_3328 n_I4243 n_I4238 n_I4239 VDD_DEC pfet_05v0 L=0.5U W=0.36U AS=0.3852P
+ AD=0.0612P PS=2.86U PD=0.7U
* device instance _3329 r180 *1 531.685,810.358 nfet_05v0
XM_3329 n_I4242 n_I4239 n_I4240 VSS nfet_05v0 L=0.6U W=0.365U AS=0.3705P
+ AD=0.0438P PS=2.77U PD=0.605U
* device instance _3330 r180 *1 530.845,810.358 nfet_05v0
XM_3330 VSS n_I4239 n_I4242 VSS nfet_05v0 L=0.6U W=0.365U AS=0.0438P
+ AD=0.282625P PS=0.605U PD=1.87U
* device instance _3331 r180 *1 529.195,810.13 nfet_05v0
XM_3331 n_I2250 n_I4240 VSS VSS nfet_05v0 L=0.6U W=0.82U AS=0.282625P AD=0.3608P
+ PS=1.87U PD=2.52U
* device instance _3332 r180 *1 535.925,810.36 nfet_05v0
XM_3332 VSS n_I2169 n_I4238 VSS nfet_05v0 L=0.6U W=0.36U AS=0.333P AD=0.0936P
+ PS=2.57U PD=0.88U
* device instance _3333 r180 *1 534.805,810.36 nfet_05v0
XM_3333 n_I4241 n_I4238 VSS VSS nfet_05v0 L=0.6U W=0.36U AS=0.0936P AD=0.0432P
+ PS=0.88U PD=0.6U
* device instance _3334 r180 *1 533.965,810.36 nfet_05v0
XM_3334 n_I4239 n_I4238 n_I4241 VSS nfet_05v0 L=0.6U W=0.36U AS=0.0432P
+ AD=0.369P PS=0.6U PD=2.77U
* device instance _3335 r180 *1 533.975,815.43 pfet_05v0
XM_3335 n_I4251 n_I4246 n_I4247 VDD_DEC pfet_05v0 L=0.5U W=0.36U AS=0.3456P
+ AD=0.0612P PS=2.64U PD=0.7U
* device instance _3336 r180 *1 533.135,815.43 pfet_05v0
XM_3336 n_I4251 n_I4246 VDD_DEC VDD_DEC pfet_05v0 L=0.5U W=0.36U AS=0.379P
+ AD=0.0612P PS=2.37U PD=0.7U
* device instance _3337 r180 *1 531.485,815.75 pfet_05v0
XM_3337 n_I2331 n_I4247 VDD_DEC VDD_DEC pfet_05v0 L=0.5U W=1.22U AS=0.379P
+ AD=0.5368P PS=2.37U PD=3.32U
* device instance _3338 r180 *1 538.215,815.32 pfet_05v0
XM_3338 VDD_DEC n_I2342 n_I4245 VDD_DEC pfet_05v0 L=0.5U W=0.36U AS=0.3852P
+ AD=0.1116P PS=2.86U PD=0.98U
* device instance _3339 r180 *1 537.095,815.32 pfet_05v0
XM_3339 n_I4250 n_I4245 VDD_DEC VDD_DEC pfet_05v0 L=0.5U W=0.36U AS=0.1116P
+ AD=0.0612P PS=0.98U PD=0.7U
* device instance _3340 r180 *1 536.255,815.32 pfet_05v0
XM_3340 n_I4250 n_I4245 n_I4246 VDD_DEC pfet_05v0 L=0.5U W=0.36U AS=0.3852P
+ AD=0.0612P PS=2.86U PD=0.7U
* device instance _3341 r180 *1 533.925,818.198 nfet_05v0
XM_3341 n_I4249 n_I4246 n_I4247 VSS nfet_05v0 L=0.6U W=0.365U AS=0.3705P
+ AD=0.0438P PS=2.77U PD=0.605U
* device instance _3342 r180 *1 533.085,818.198 nfet_05v0
XM_3342 VSS n_I4246 n_I4249 VSS nfet_05v0 L=0.6U W=0.365U AS=0.0438P
+ AD=0.282625P PS=0.605U PD=1.87U
* device instance _3343 r180 *1 531.435,817.97 nfet_05v0
XM_3343 n_I2331 n_I4247 VSS VSS nfet_05v0 L=0.6U W=0.82U AS=0.282625P AD=0.3608P
+ PS=1.87U PD=2.52U
* device instance _3344 r180 *1 538.165,818.2 nfet_05v0
XM_3344 VSS n_I2342 n_I4245 VSS nfet_05v0 L=0.6U W=0.36U AS=0.333P AD=0.0936P
+ PS=2.57U PD=0.88U
* device instance _3345 r180 *1 537.045,818.2 nfet_05v0
XM_3345 n_I4248 n_I4245 VSS VSS nfet_05v0 L=0.6U W=0.36U AS=0.0936P AD=0.0432P
+ PS=0.88U PD=0.6U
* device instance _3346 r180 *1 536.205,818.2 nfet_05v0
XM_3346 n_I4246 n_I4245 n_I4248 VSS nfet_05v0 L=0.6U W=0.36U AS=0.0432P
+ AD=0.369P PS=0.6U PD=2.77U
* device instance _3347 r180 *1 649.335,784.07 pfet_05v0
XM_3347 n_I4258 n_I4253 n_I4254 VDD_DEC pfet_05v0 L=0.5U W=0.36U AS=0.3456P
+ AD=0.0612P PS=2.64U PD=0.7U
* device instance _3348 r180 *1 648.495,784.07 pfet_05v0
XM_3348 n_I4258 n_I4253 VDD_DEC VDD_DEC pfet_05v0 L=0.5U W=0.36U AS=0.379P
+ AD=0.0612P PS=2.37U PD=0.7U
* device instance _3349 r180 *1 646.845,784.39 pfet_05v0
XM_3349 n_I2138 n_I4254 VDD_DEC VDD_DEC pfet_05v0 L=0.5U W=1.22U AS=0.379P
+ AD=0.5368P PS=2.37U PD=3.32U
* device instance _3350 r180 *1 653.575,783.96 pfet_05v0
XM_3350 VDD_DEC n_I2139 n_I4252 VDD_DEC pfet_05v0 L=0.5U W=0.36U AS=0.3852P
+ AD=0.1116P PS=2.86U PD=0.98U
* device instance _3351 r180 *1 652.455,783.96 pfet_05v0
XM_3351 n_I4257 n_I4252 VDD_DEC VDD_DEC pfet_05v0 L=0.5U W=0.36U AS=0.1116P
+ AD=0.0612P PS=0.98U PD=0.7U
* device instance _3352 r180 *1 651.615,783.96 pfet_05v0
XM_3352 n_I4257 n_I4252 n_I4253 VDD_DEC pfet_05v0 L=0.5U W=0.36U AS=0.3852P
+ AD=0.0612P PS=2.86U PD=0.7U
* device instance _3353 r180 *1 649.285,786.838 nfet_05v0
XM_3353 n_I4256 n_I4253 n_I4254 VSS nfet_05v0 L=0.6U W=0.365U AS=0.3705P
+ AD=0.0438P PS=2.77U PD=0.605U
* device instance _3354 r180 *1 648.445,786.838 nfet_05v0
XM_3354 VSS n_I4253 n_I4256 VSS nfet_05v0 L=0.6U W=0.365U AS=0.0438P
+ AD=0.282625P PS=0.605U PD=1.87U
* device instance _3355 r180 *1 646.795,786.61 nfet_05v0
XM_3355 n_I2138 n_I4254 VSS VSS nfet_05v0 L=0.6U W=0.82U AS=0.282625P AD=0.3608P
+ PS=1.87U PD=2.52U
* device instance _3356 r180 *1 653.525,786.84 nfet_05v0
XM_3356 VSS n_I2139 n_I4252 VSS nfet_05v0 L=0.6U W=0.36U AS=0.333P AD=0.0936P
+ PS=2.57U PD=0.88U
* device instance _3357 r180 *1 652.405,786.84 nfet_05v0
XM_3357 n_I4255 n_I4252 VSS VSS nfet_05v0 L=0.6U W=0.36U AS=0.0936P AD=0.0432P
+ PS=0.88U PD=0.6U
* device instance _3358 r180 *1 651.565,786.84 nfet_05v0
XM_3358 n_I4253 n_I4252 n_I4255 VSS nfet_05v0 L=0.6U W=0.36U AS=0.0432P
+ AD=0.369P PS=0.6U PD=2.77U
* device instance _3359 r180 *1 657.175,823.27 pfet_05v0
XM_3359 n_I4265 n_I4260 n_I4261 VDD_DEC pfet_05v0 L=0.5U W=0.36U AS=0.3456P
+ AD=0.0612P PS=2.64U PD=0.7U
* device instance _3360 r180 *1 656.335,823.27 pfet_05v0
XM_3360 n_I4265 n_I4260 VDD_DEC VDD_DEC pfet_05v0 L=0.5U W=0.36U AS=0.379P
+ AD=0.0612P PS=2.37U PD=0.7U
* device instance _3361 r180 *1 654.685,823.59 pfet_05v0
XM_3361 n_17 n_I4261 VDD_DEC VDD_DEC pfet_05v0 L=0.5U W=1.22U AS=0.379P
+ AD=0.5368P PS=2.37U PD=3.32U
* device instance _3362 r180 *1 661.415,823.16 pfet_05v0
XM_3362 VDD_DEC n_I2409 n_I4259 VDD_DEC pfet_05v0 L=0.5U W=0.36U AS=0.3852P
+ AD=0.1116P PS=2.86U PD=0.98U
* device instance _3363 r180 *1 660.295,823.16 pfet_05v0
XM_3363 n_I4264 n_I4259 VDD_DEC VDD_DEC pfet_05v0 L=0.5U W=0.36U AS=0.1116P
+ AD=0.0612P PS=0.98U PD=0.7U
* device instance _3364 r180 *1 659.455,823.16 pfet_05v0
XM_3364 n_I4264 n_I4259 n_I4260 VDD_DEC pfet_05v0 L=0.5U W=0.36U AS=0.3852P
+ AD=0.0612P PS=2.86U PD=0.7U
* device instance _3365 r180 *1 657.125,826.038 nfet_05v0
XM_3365 n_I4263 n_I4260 n_I4261 VSS nfet_05v0 L=0.6U W=0.365U AS=0.3705P
+ AD=0.0438P PS=2.77U PD=0.605U
* device instance _3366 r180 *1 656.285,826.038 nfet_05v0
XM_3366 VSS n_I4260 n_I4263 VSS nfet_05v0 L=0.6U W=0.365U AS=0.0438P
+ AD=0.282625P PS=0.605U PD=1.87U
* device instance _3367 r180 *1 654.635,825.81 nfet_05v0
XM_3367 n_17 n_I4261 VSS VSS nfet_05v0 L=0.6U W=0.82U AS=0.282625P AD=0.3608P
+ PS=1.87U PD=2.52U
* device instance _3368 r180 *1 661.365,826.04 nfet_05v0
XM_3368 VSS n_I2409 n_I4259 VSS nfet_05v0 L=0.6U W=0.36U AS=0.333P AD=0.0936P
+ PS=2.57U PD=0.88U
* device instance _3369 r180 *1 660.245,826.04 nfet_05v0
XM_3369 n_I4262 n_I4259 VSS VSS nfet_05v0 L=0.6U W=0.36U AS=0.0936P AD=0.0432P
+ PS=0.88U PD=0.6U
* device instance _3370 r180 *1 659.405,826.04 nfet_05v0
XM_3370 n_I4260 n_I4259 n_I4262 VSS nfet_05v0 L=0.6U W=0.36U AS=0.0432P
+ AD=0.369P PS=0.6U PD=2.77U
* device instance _3371 r180 *1 509.895,791.91 pfet_05v0
XM_3371 n_I4272 n_I4267 n_I4268 VDD_DEC pfet_05v0 L=0.5U W=0.36U AS=0.3456P
+ AD=0.0612P PS=2.64U PD=0.7U
* device instance _3372 r180 *1 509.055,791.91 pfet_05v0
XM_3372 n_I4272 n_I4267 VDD_DEC VDD_DEC pfet_05v0 L=0.5U W=0.36U AS=0.379P
+ AD=0.0612P PS=2.37U PD=0.7U
* device instance _3373 r180 *1 507.405,792.23 pfet_05v0
XM_3373 n_I2196 n_I4268 VDD_DEC VDD_DEC pfet_05v0 L=0.5U W=1.22U AS=0.379P
+ AD=0.5368P PS=2.37U PD=3.32U
* device instance _3374 r180 *1 514.135,791.8 pfet_05v0
XM_3374 VDD_DEC n_I2199 n_I4266 VDD_DEC pfet_05v0 L=0.5U W=0.36U AS=0.3852P
+ AD=0.1116P PS=2.86U PD=0.98U
* device instance _3375 r180 *1 513.015,791.8 pfet_05v0
XM_3375 n_I4271 n_I4266 VDD_DEC VDD_DEC pfet_05v0 L=0.5U W=0.36U AS=0.1116P
+ AD=0.0612P PS=0.98U PD=0.7U
* device instance _3376 r180 *1 512.175,791.8 pfet_05v0
XM_3376 n_I4271 n_I4266 n_I4267 VDD_DEC pfet_05v0 L=0.5U W=0.36U AS=0.3852P
+ AD=0.0612P PS=2.86U PD=0.7U
* device instance _3377 r180 *1 509.845,794.678 nfet_05v0
XM_3377 n_I4270 n_I4267 n_I4268 VSS nfet_05v0 L=0.6U W=0.365U AS=0.3705P
+ AD=0.0438P PS=2.77U PD=0.605U
* device instance _3378 r180 *1 509.005,794.678 nfet_05v0
XM_3378 VSS n_I4267 n_I4270 VSS nfet_05v0 L=0.6U W=0.365U AS=0.0438P
+ AD=0.282625P PS=0.605U PD=1.87U
* device instance _3379 r180 *1 507.355,794.45 nfet_05v0
XM_3379 n_I2196 n_I4268 VSS VSS nfet_05v0 L=0.6U W=0.82U AS=0.282625P AD=0.3608P
+ PS=1.87U PD=2.52U
* device instance _3380 r180 *1 514.085,794.68 nfet_05v0
XM_3380 VSS n_I2199 n_I4266 VSS nfet_05v0 L=0.6U W=0.36U AS=0.333P AD=0.0936P
+ PS=2.57U PD=0.88U
* device instance _3381 r180 *1 512.965,794.68 nfet_05v0
XM_3381 n_I4269 n_I4266 VSS VSS nfet_05v0 L=0.6U W=0.36U AS=0.0936P AD=0.0432P
+ PS=0.88U PD=0.6U
* device instance _3382 r180 *1 512.125,794.68 nfet_05v0
XM_3382 n_I4267 n_I4266 n_I4269 VSS nfet_05v0 L=0.6U W=0.36U AS=0.0432P
+ AD=0.369P PS=0.6U PD=2.77U
* device instance _3383 r180 *1 627.495,799.75 pfet_05v0
XM_3383 n_I4279 n_I4274 n_I4275 VDD_DEC pfet_05v0 L=0.5U W=0.36U AS=0.3456P
+ AD=0.0612P PS=2.64U PD=0.7U
* device instance _3384 r180 *1 626.655,799.75 pfet_05v0
XM_3384 n_I4279 n_I4274 VDD_DEC VDD_DEC pfet_05v0 L=0.5U W=0.36U AS=0.379P
+ AD=0.0612P PS=2.37U PD=0.7U
* device instance _3385 r180 *1 625.005,800.07 pfet_05v0
XM_3385 n_I2213 n_I4275 VDD_DEC VDD_DEC pfet_05v0 L=0.5U W=1.22U AS=0.379P
+ AD=0.5368P PS=2.37U PD=3.32U
* device instance _3386 r180 *1 631.735,799.64 pfet_05v0
XM_3386 VDD_DEC n_I2175 n_I4273 VDD_DEC pfet_05v0 L=0.5U W=0.36U AS=0.3852P
+ AD=0.1116P PS=2.86U PD=0.98U
* device instance _3387 r180 *1 630.615,799.64 pfet_05v0
XM_3387 n_I4278 n_I4273 VDD_DEC VDD_DEC pfet_05v0 L=0.5U W=0.36U AS=0.1116P
+ AD=0.0612P PS=0.98U PD=0.7U
* device instance _3388 r180 *1 629.775,799.64 pfet_05v0
XM_3388 n_I4278 n_I4273 n_I4274 VDD_DEC pfet_05v0 L=0.5U W=0.36U AS=0.3852P
+ AD=0.0612P PS=2.86U PD=0.7U
* device instance _3389 r180 *1 627.445,802.518 nfet_05v0
XM_3389 n_I4277 n_I4274 n_I4275 VSS nfet_05v0 L=0.6U W=0.365U AS=0.3705P
+ AD=0.0438P PS=2.77U PD=0.605U
* device instance _3390 r180 *1 626.605,802.518 nfet_05v0
XM_3390 VSS n_I4274 n_I4277 VSS nfet_05v0 L=0.6U W=0.365U AS=0.0438P
+ AD=0.282625P PS=0.605U PD=1.87U
* device instance _3391 r180 *1 624.955,802.29 nfet_05v0
XM_3391 n_I2213 n_I4275 VSS VSS nfet_05v0 L=0.6U W=0.82U AS=0.282625P AD=0.3608P
+ PS=1.87U PD=2.52U
* device instance _3392 r180 *1 631.685,802.52 nfet_05v0
XM_3392 VSS n_I2175 n_I4273 VSS nfet_05v0 L=0.6U W=0.36U AS=0.333P AD=0.0936P
+ PS=2.57U PD=0.88U
* device instance _3393 r180 *1 630.565,802.52 nfet_05v0
XM_3393 n_I4276 n_I4273 VSS VSS nfet_05v0 L=0.6U W=0.36U AS=0.0936P AD=0.0432P
+ PS=0.88U PD=0.6U
* device instance _3394 r180 *1 629.725,802.52 nfet_05v0
XM_3394 n_I4274 n_I4273 n_I4276 VSS nfet_05v0 L=0.6U W=0.36U AS=0.0432P
+ AD=0.369P PS=0.6U PD=2.77U
* device instance _3395 r180 *1 559.735,791.91 pfet_05v0
XM_3395 n_I4286 n_I4281 n_I4282 VDD_DEC pfet_05v0 L=0.5U W=0.36U AS=0.3456P
+ AD=0.0612P PS=2.64U PD=0.7U
* device instance _3396 r180 *1 558.895,791.91 pfet_05v0
XM_3396 n_I4286 n_I4281 VDD_DEC VDD_DEC pfet_05v0 L=0.5U W=0.36U AS=0.379P
+ AD=0.0612P PS=2.37U PD=0.7U
* device instance _3397 r180 *1 557.245,792.23 pfet_05v0
XM_3397 n_I2416 n_I4282 VDD_DEC VDD_DEC pfet_05v0 L=0.5U W=1.22U AS=0.379P
+ AD=0.5368P PS=2.37U PD=3.32U
* device instance _3398 r180 *1 563.975,791.8 pfet_05v0
XM_3398 VDD_DEC n_I2202 n_I4280 VDD_DEC pfet_05v0 L=0.5U W=0.36U AS=0.3852P
+ AD=0.1116P PS=2.86U PD=0.98U
* device instance _3399 r180 *1 562.855,791.8 pfet_05v0
XM_3399 n_I4285 n_I4280 VDD_DEC VDD_DEC pfet_05v0 L=0.5U W=0.36U AS=0.1116P
+ AD=0.0612P PS=0.98U PD=0.7U
* device instance _3400 r180 *1 562.015,791.8 pfet_05v0
XM_3400 n_I4285 n_I4280 n_I4281 VDD_DEC pfet_05v0 L=0.5U W=0.36U AS=0.3852P
+ AD=0.0612P PS=2.86U PD=0.7U
* device instance _3401 r180 *1 559.685,794.678 nfet_05v0
XM_3401 n_I4284 n_I4281 n_I4282 VSS nfet_05v0 L=0.6U W=0.365U AS=0.3705P
+ AD=0.0438P PS=2.77U PD=0.605U
* device instance _3402 r180 *1 558.845,794.678 nfet_05v0
XM_3402 VSS n_I4281 n_I4284 VSS nfet_05v0 L=0.6U W=0.365U AS=0.0438P
+ AD=0.282625P PS=0.605U PD=1.87U
* device instance _3403 r180 *1 557.195,794.45 nfet_05v0
XM_3403 n_I2416 n_I4282 VSS VSS nfet_05v0 L=0.6U W=0.82U AS=0.282625P AD=0.3608P
+ PS=1.87U PD=2.52U
* device instance _3404 r180 *1 563.925,794.68 nfet_05v0
XM_3404 VSS n_I2202 n_I4280 VSS nfet_05v0 L=0.6U W=0.36U AS=0.333P AD=0.0936P
+ PS=2.57U PD=0.88U
* device instance _3405 r180 *1 562.805,794.68 nfet_05v0
XM_3405 n_I4283 n_I4280 VSS VSS nfet_05v0 L=0.6U W=0.36U AS=0.0936P AD=0.0432P
+ PS=0.88U PD=0.6U
* device instance _3406 r180 *1 561.965,794.68 nfet_05v0
XM_3406 n_I4281 n_I4280 n_I4283 VSS nfet_05v0 L=0.6U W=0.36U AS=0.0432P
+ AD=0.369P PS=0.6U PD=2.77U
* device instance _3407 r180 *1 620.215,791.91 pfet_05v0
XM_3407 n_I4293 n_I4288 n_I4289 VDD_DEC pfet_05v0 L=0.5U W=0.36U AS=0.3456P
+ AD=0.0612P PS=2.64U PD=0.7U
* device instance _3408 r180 *1 619.375,791.91 pfet_05v0
XM_3408 n_I4293 n_I4288 VDD_DEC VDD_DEC pfet_05v0 L=0.5U W=0.36U AS=0.379P
+ AD=0.0612P PS=2.37U PD=0.7U
* device instance _3409 r180 *1 617.725,792.23 pfet_05v0
XM_3409 n_I2239 n_I4289 VDD_DEC VDD_DEC pfet_05v0 L=0.5U W=1.22U AS=0.379P
+ AD=0.5368P PS=2.37U PD=3.32U
* device instance _3410 r180 *1 624.455,791.8 pfet_05v0
XM_3410 VDD_DEC n_I2213 n_I4287 VDD_DEC pfet_05v0 L=0.5U W=0.36U AS=0.3852P
+ AD=0.1116P PS=2.86U PD=0.98U
* device instance _3411 r180 *1 623.335,791.8 pfet_05v0
XM_3411 n_I4292 n_I4287 VDD_DEC VDD_DEC pfet_05v0 L=0.5U W=0.36U AS=0.1116P
+ AD=0.0612P PS=0.98U PD=0.7U
* device instance _3412 r180 *1 622.495,791.8 pfet_05v0
XM_3412 n_I4292 n_I4287 n_I4288 VDD_DEC pfet_05v0 L=0.5U W=0.36U AS=0.3852P
+ AD=0.0612P PS=2.86U PD=0.7U
* device instance _3413 r180 *1 620.165,794.678 nfet_05v0
XM_3413 n_I4291 n_I4288 n_I4289 VSS nfet_05v0 L=0.6U W=0.365U AS=0.3705P
+ AD=0.0438P PS=2.77U PD=0.605U
* device instance _3414 r180 *1 619.325,794.678 nfet_05v0
XM_3414 VSS n_I4288 n_I4291 VSS nfet_05v0 L=0.6U W=0.365U AS=0.0438P
+ AD=0.282625P PS=0.605U PD=1.87U
* device instance _3415 r180 *1 617.675,794.45 nfet_05v0
XM_3415 n_I2239 n_I4289 VSS VSS nfet_05v0 L=0.6U W=0.82U AS=0.282625P AD=0.3608P
+ PS=1.87U PD=2.52U
* device instance _3416 r180 *1 624.405,794.68 nfet_05v0
XM_3416 VSS n_I2213 n_I4287 VSS nfet_05v0 L=0.6U W=0.36U AS=0.333P AD=0.0936P
+ PS=2.57U PD=0.88U
* device instance _3417 r180 *1 623.285,794.68 nfet_05v0
XM_3417 n_I4290 n_I4287 VSS VSS nfet_05v0 L=0.6U W=0.36U AS=0.0936P AD=0.0432P
+ PS=0.88U PD=0.6U
* device instance _3418 r180 *1 622.445,794.68 nfet_05v0
XM_3418 n_I4288 n_I4287 n_I4290 VSS nfet_05v0 L=0.6U W=0.36U AS=0.0432P
+ AD=0.369P PS=0.6U PD=2.77U
* device instance _3419 r180 *1 535.095,791.91 pfet_05v0
XM_3419 n_I4300 n_I4295 n_I4296 VDD_DEC pfet_05v0 L=0.5U W=0.36U AS=0.3456P
+ AD=0.0612P PS=2.64U PD=0.7U
* device instance _3420 r180 *1 534.255,791.91 pfet_05v0
XM_3420 n_I4300 n_I4295 VDD_DEC VDD_DEC pfet_05v0 L=0.5U W=0.36U AS=0.379P
+ AD=0.0612P PS=2.37U PD=0.7U
* device instance _3421 r180 *1 532.605,792.23 pfet_05v0
XM_3421 n_I2200 n_I4296 VDD_DEC VDD_DEC pfet_05v0 L=0.5U W=1.22U AS=0.379P
+ AD=0.5368P PS=2.37U PD=3.32U
* device instance _3422 r180 *1 539.335,791.8 pfet_05v0
XM_3422 VDD_DEC n_I2331 n_I4294 VDD_DEC pfet_05v0 L=0.5U W=0.36U AS=0.3852P
+ AD=0.1116P PS=2.86U PD=0.98U
* device instance _3423 r180 *1 538.215,791.8 pfet_05v0
XM_3423 n_I4299 n_I4294 VDD_DEC VDD_DEC pfet_05v0 L=0.5U W=0.36U AS=0.1116P
+ AD=0.0612P PS=0.98U PD=0.7U
* device instance _3424 r180 *1 537.375,791.8 pfet_05v0
XM_3424 n_I4299 n_I4294 n_I4295 VDD_DEC pfet_05v0 L=0.5U W=0.36U AS=0.3852P
+ AD=0.0612P PS=2.86U PD=0.7U
* device instance _3425 r180 *1 535.045,794.678 nfet_05v0
XM_3425 n_I4298 n_I4295 n_I4296 VSS nfet_05v0 L=0.6U W=0.365U AS=0.3705P
+ AD=0.0438P PS=2.77U PD=0.605U
* device instance _3426 r180 *1 534.205,794.678 nfet_05v0
XM_3426 VSS n_I4295 n_I4298 VSS nfet_05v0 L=0.6U W=0.365U AS=0.0438P
+ AD=0.282625P PS=0.605U PD=1.87U
* device instance _3427 r180 *1 532.555,794.45 nfet_05v0
XM_3427 n_I2200 n_I4296 VSS VSS nfet_05v0 L=0.6U W=0.82U AS=0.282625P AD=0.3608P
+ PS=1.87U PD=2.52U
* device instance _3428 r180 *1 539.285,794.68 nfet_05v0
XM_3428 VSS n_I2331 n_I4294 VSS nfet_05v0 L=0.6U W=0.36U AS=0.333P AD=0.0936P
+ PS=2.57U PD=0.88U
* device instance _3429 r180 *1 538.165,794.68 nfet_05v0
XM_3429 n_I4297 n_I4294 VSS VSS nfet_05v0 L=0.6U W=0.36U AS=0.0936P AD=0.0432P
+ PS=0.88U PD=0.6U
* device instance _3430 r180 *1 537.325,794.68 nfet_05v0
XM_3430 n_I4295 n_I4294 n_I4297 VSS nfet_05v0 L=0.6U W=0.36U AS=0.0432P
+ AD=0.369P PS=0.6U PD=2.77U
* device instance _3431 r180 *1 573.735,799.75 pfet_05v0
XM_3431 n_I4307 n_I4302 n_I4303 VDD_DEC pfet_05v0 L=0.5U W=0.36U AS=0.3456P
+ AD=0.0612P PS=2.64U PD=0.7U
* device instance _3432 r180 *1 572.895,799.75 pfet_05v0
XM_3432 n_I4307 n_I4302 VDD_DEC VDD_DEC pfet_05v0 L=0.5U W=0.36U AS=0.379P
+ AD=0.0612P PS=2.37U PD=0.7U
* device instance _3433 r180 *1 571.245,800.07 pfet_05v0
XM_3433 n_I2203 n_I4303 VDD_DEC VDD_DEC pfet_05v0 L=0.5U W=1.22U AS=0.379P
+ AD=0.5368P PS=2.37U PD=3.32U
* device instance _3434 r180 *1 577.975,799.64 pfet_05v0
XM_3434 VDD_DEC n_I2280 n_I4301 VDD_DEC pfet_05v0 L=0.5U W=0.36U AS=0.3852P
+ AD=0.1116P PS=2.86U PD=0.98U
* device instance _3435 r180 *1 576.855,799.64 pfet_05v0
XM_3435 n_I4306 n_I4301 VDD_DEC VDD_DEC pfet_05v0 L=0.5U W=0.36U AS=0.1116P
+ AD=0.0612P PS=0.98U PD=0.7U
* device instance _3436 r180 *1 576.015,799.64 pfet_05v0
XM_3436 n_I4306 n_I4301 n_I4302 VDD_DEC pfet_05v0 L=0.5U W=0.36U AS=0.3852P
+ AD=0.0612P PS=2.86U PD=0.7U
* device instance _3437 r180 *1 573.685,802.518 nfet_05v0
XM_3437 n_I4305 n_I4302 n_I4303 VSS nfet_05v0 L=0.6U W=0.365U AS=0.3705P
+ AD=0.0438P PS=2.77U PD=0.605U
* device instance _3438 r180 *1 572.845,802.518 nfet_05v0
XM_3438 VSS n_I4302 n_I4305 VSS nfet_05v0 L=0.6U W=0.365U AS=0.0438P
+ AD=0.282625P PS=0.605U PD=1.87U
* device instance _3439 r180 *1 571.195,802.29 nfet_05v0
XM_3439 n_I2203 n_I4303 VSS VSS nfet_05v0 L=0.6U W=0.82U AS=0.282625P AD=0.3608P
+ PS=1.87U PD=2.52U
* device instance _3440 r180 *1 577.925,802.52 nfet_05v0
XM_3440 VSS n_I2280 n_I4301 VSS nfet_05v0 L=0.6U W=0.36U AS=0.333P AD=0.0936P
+ PS=2.57U PD=0.88U
* device instance _3441 r180 *1 576.805,802.52 nfet_05v0
XM_3441 n_I4304 n_I4301 VSS VSS nfet_05v0 L=0.6U W=0.36U AS=0.0936P AD=0.0432P
+ PS=0.88U PD=0.6U
* device instance _3442 r180 *1 575.965,802.52 nfet_05v0
XM_3442 n_I4302 n_I4301 n_I4304 VSS nfet_05v0 L=0.6U W=0.36U AS=0.0432P
+ AD=0.369P PS=0.6U PD=2.77U
* device instance _3443 r180 *1 638.135,799.75 pfet_05v0
XM_3443 n_I4314 n_I4309 n_I4310 VDD_DEC pfet_05v0 L=0.5U W=0.36U AS=0.3456P
+ AD=0.0612P PS=2.64U PD=0.7U
* device instance _3444 r180 *1 637.295,799.75 pfet_05v0
XM_3444 n_I4314 n_I4309 VDD_DEC VDD_DEC pfet_05v0 L=0.5U W=0.36U AS=0.379P
+ AD=0.0612P PS=2.37U PD=0.7U
* device instance _3445 r180 *1 635.645,800.07 pfet_05v0
XM_3445 n_I2285 n_I4310 VDD_DEC VDD_DEC pfet_05v0 L=0.5U W=1.22U AS=0.379P
+ AD=0.5368P PS=2.37U PD=3.32U
* device instance _3446 r180 *1 642.375,799.64 pfet_05v0
XM_3446 VDD_DEC n_I2288 n_I4308 VDD_DEC pfet_05v0 L=0.5U W=0.36U AS=0.3852P
+ AD=0.1116P PS=2.86U PD=0.98U
* device instance _3447 r180 *1 641.255,799.64 pfet_05v0
XM_3447 n_I4313 n_I4308 VDD_DEC VDD_DEC pfet_05v0 L=0.5U W=0.36U AS=0.1116P
+ AD=0.0612P PS=0.98U PD=0.7U
* device instance _3448 r180 *1 640.415,799.64 pfet_05v0
XM_3448 n_I4313 n_I4308 n_I4309 VDD_DEC pfet_05v0 L=0.5U W=0.36U AS=0.3852P
+ AD=0.0612P PS=2.86U PD=0.7U
* device instance _3449 r180 *1 638.085,802.518 nfet_05v0
XM_3449 n_I4312 n_I4309 n_I4310 VSS nfet_05v0 L=0.6U W=0.365U AS=0.3705P
+ AD=0.0438P PS=2.77U PD=0.605U
* device instance _3450 r180 *1 637.245,802.518 nfet_05v0
XM_3450 VSS n_I4309 n_I4312 VSS nfet_05v0 L=0.6U W=0.365U AS=0.0438P
+ AD=0.282625P PS=0.605U PD=1.87U
* device instance _3451 r180 *1 635.595,802.29 nfet_05v0
XM_3451 n_I2285 n_I4310 VSS VSS nfet_05v0 L=0.6U W=0.82U AS=0.282625P AD=0.3608P
+ PS=1.87U PD=2.52U
* device instance _3452 r180 *1 642.325,802.52 nfet_05v0
XM_3452 VSS n_I2288 n_I4308 VSS nfet_05v0 L=0.6U W=0.36U AS=0.333P AD=0.0936P
+ PS=2.57U PD=0.88U
* device instance _3453 r180 *1 641.205,802.52 nfet_05v0
XM_3453 n_I4311 n_I4308 VSS VSS nfet_05v0 L=0.6U W=0.36U AS=0.0936P AD=0.0432P
+ PS=0.88U PD=0.6U
* device instance _3454 r180 *1 640.365,802.52 nfet_05v0
XM_3454 n_I4309 n_I4308 n_I4311 VSS nfet_05v0 L=0.6U W=0.36U AS=0.0432P
+ AD=0.369P PS=0.6U PD=2.77U
* device instance _3455 r180 *1 648.775,799.75 pfet_05v0
XM_3455 n_I4321 n_I4316 n_I4317 VDD_DEC pfet_05v0 L=0.5U W=0.36U AS=0.3456P
+ AD=0.0612P PS=2.64U PD=0.7U
* device instance _3456 r180 *1 647.935,799.75 pfet_05v0
XM_3456 n_I4321 n_I4316 VDD_DEC VDD_DEC pfet_05v0 L=0.5U W=0.36U AS=0.379P
+ AD=0.0612P PS=2.37U PD=0.7U
* device instance _3457 r180 *1 646.285,800.07 pfet_05v0
XM_3457 n_I2207 n_I4317 VDD_DEC VDD_DEC pfet_05v0 L=0.5U W=1.22U AS=0.379P
+ AD=0.5368P PS=2.37U PD=3.32U
* device instance _3458 r180 *1 653.015,799.64 pfet_05v0
XM_3458 VDD_DEC n_I2385 n_I4315 VDD_DEC pfet_05v0 L=0.5U W=0.36U AS=0.3852P
+ AD=0.1116P PS=2.86U PD=0.98U
* device instance _3459 r180 *1 651.895,799.64 pfet_05v0
XM_3459 n_I4320 n_I4315 VDD_DEC VDD_DEC pfet_05v0 L=0.5U W=0.36U AS=0.1116P
+ AD=0.0612P PS=0.98U PD=0.7U
* device instance _3460 r180 *1 651.055,799.64 pfet_05v0
XM_3460 n_I4320 n_I4315 n_I4316 VDD_DEC pfet_05v0 L=0.5U W=0.36U AS=0.3852P
+ AD=0.0612P PS=2.86U PD=0.7U
* device instance _3461 r180 *1 648.725,802.518 nfet_05v0
XM_3461 n_I4319 n_I4316 n_I4317 VSS nfet_05v0 L=0.6U W=0.365U AS=0.3705P
+ AD=0.0438P PS=2.77U PD=0.605U
* device instance _3462 r180 *1 647.885,802.518 nfet_05v0
XM_3462 VSS n_I4316 n_I4319 VSS nfet_05v0 L=0.6U W=0.365U AS=0.0438P
+ AD=0.282625P PS=0.605U PD=1.87U
* device instance _3463 r180 *1 646.235,802.29 nfet_05v0
XM_3463 n_I2207 n_I4317 VSS VSS nfet_05v0 L=0.6U W=0.82U AS=0.282625P AD=0.3608P
+ PS=1.87U PD=2.52U
* device instance _3464 r180 *1 652.965,802.52 nfet_05v0
XM_3464 VSS n_I2385 n_I4315 VSS nfet_05v0 L=0.6U W=0.36U AS=0.333P AD=0.0936P
+ PS=2.57U PD=0.88U
* device instance _3465 r180 *1 651.845,802.52 nfet_05v0
XM_3465 n_I4318 n_I4315 VSS VSS nfet_05v0 L=0.6U W=0.36U AS=0.0936P AD=0.0432P
+ PS=0.88U PD=0.6U
* device instance _3466 r180 *1 651.005,802.52 nfet_05v0
XM_3466 n_I4316 n_I4315 n_I4318 VSS nfet_05v0 L=0.6U W=0.36U AS=0.0432P
+ AD=0.369P PS=0.6U PD=2.77U
* device instance _3467 r0 *1 634.905,814.17 pfet_05v0
XM_3467 n_I4328 n_I4323 n_I4324 VDD_DEC pfet_05v0 L=0.5U W=0.36U AS=0.3456P
+ AD=0.0612P PS=2.64U PD=0.7U
* device instance _3468 r0 *1 635.745,814.17 pfet_05v0
XM_3468 n_I4328 n_I4323 VDD_DEC VDD_DEC pfet_05v0 L=0.5U W=0.36U AS=0.379P
+ AD=0.0612P PS=2.37U PD=0.7U
* device instance _3469 r0 *1 637.395,813.85 pfet_05v0
XM_3469 n_I2214 n_I4324 VDD_DEC VDD_DEC pfet_05v0 L=0.5U W=1.22U AS=0.379P
+ AD=0.5368P PS=2.37U PD=3.32U
* device instance _3470 r0 *1 630.665,814.28 pfet_05v0
XM_3470 VDD_DEC n_I2286 n_I4322 VDD_DEC pfet_05v0 L=0.5U W=0.36U AS=0.3852P
+ AD=0.1116P PS=2.86U PD=0.98U
* device instance _3471 r0 *1 631.785,814.28 pfet_05v0
XM_3471 n_I4327 n_I4322 VDD_DEC VDD_DEC pfet_05v0 L=0.5U W=0.36U AS=0.1116P
+ AD=0.0612P PS=0.98U PD=0.7U
* device instance _3472 r0 *1 632.625,814.28 pfet_05v0
XM_3472 n_I4327 n_I4322 n_I4323 VDD_DEC pfet_05v0 L=0.5U W=0.36U AS=0.3852P
+ AD=0.0612P PS=2.86U PD=0.7U
* device instance _3473 r0 *1 634.955,811.402 nfet_05v0
XM_3473 n_I4326 n_I4323 n_I4324 VSS nfet_05v0 L=0.6U W=0.365U AS=0.3705P
+ AD=0.0438P PS=2.77U PD=0.605U
* device instance _3474 r0 *1 635.795,811.402 nfet_05v0
XM_3474 VSS n_I4323 n_I4326 VSS nfet_05v0 L=0.6U W=0.365U AS=0.0438P
+ AD=0.282625P PS=0.605U PD=1.87U
* device instance _3475 r0 *1 637.445,811.63 nfet_05v0
XM_3475 n_I2214 n_I4324 VSS VSS nfet_05v0 L=0.6U W=0.82U AS=0.282625P AD=0.3608P
+ PS=1.87U PD=2.52U
* device instance _3476 r0 *1 630.715,811.4 nfet_05v0
XM_3476 VSS n_I2286 n_I4322 VSS nfet_05v0 L=0.6U W=0.36U AS=0.333P AD=0.0936P
+ PS=2.57U PD=0.88U
* device instance _3477 r0 *1 631.835,811.4 nfet_05v0
XM_3477 n_I4325 n_I4322 VSS VSS nfet_05v0 L=0.6U W=0.36U AS=0.0936P AD=0.0432P
+ PS=0.88U PD=0.6U
* device instance _3478 r0 *1 632.675,811.4 nfet_05v0
XM_3478 n_I4323 n_I4322 n_I4325 VSS nfet_05v0 L=0.6U W=0.36U AS=0.0432P
+ AD=0.369P PS=0.6U PD=2.77U
* device instance _3479 r0 *1 521.225,774.97 pfet_05v0
XM_3479 n_I4335 n_I4330 n_I4331 VDD_DEC pfet_05v0 L=0.5U W=0.36U AS=0.3456P
+ AD=0.0612P PS=2.64U PD=0.7U
* device instance _3480 r0 *1 522.065,774.97 pfet_05v0
XM_3480 n_I4335 n_I4330 VDD_DEC VDD_DEC pfet_05v0 L=0.5U W=0.36U AS=0.379P
+ AD=0.0612P PS=2.37U PD=0.7U
* device instance _3481 r0 *1 523.715,774.65 pfet_05v0
XM_3481 n_152 n_I4331 VDD_DEC VDD_DEC pfet_05v0 L=0.5U W=1.22U AS=0.379P
+ AD=0.5368P PS=2.37U PD=3.32U
* device instance _3482 r0 *1 516.985,775.08 pfet_05v0
XM_3482 VDD_DEC n_I2022 n_I4329 VDD_DEC pfet_05v0 L=0.5U W=0.36U AS=0.3852P
+ AD=0.1116P PS=2.86U PD=0.98U
* device instance _3483 r0 *1 518.105,775.08 pfet_05v0
XM_3483 n_I4334 n_I4329 VDD_DEC VDD_DEC pfet_05v0 L=0.5U W=0.36U AS=0.1116P
+ AD=0.0612P PS=0.98U PD=0.7U
* device instance _3484 r0 *1 518.945,775.08 pfet_05v0
XM_3484 n_I4334 n_I4329 n_I4330 VDD_DEC pfet_05v0 L=0.5U W=0.36U AS=0.3852P
+ AD=0.0612P PS=2.86U PD=0.7U
* device instance _3485 r0 *1 521.275,772.202 nfet_05v0
XM_3485 n_I4333 n_I4330 n_I4331 VSS nfet_05v0 L=0.6U W=0.365U AS=0.3705P
+ AD=0.0438P PS=2.77U PD=0.605U
* device instance _3486 r0 *1 522.115,772.202 nfet_05v0
XM_3486 VSS n_I4330 n_I4333 VSS nfet_05v0 L=0.6U W=0.365U AS=0.0438P
+ AD=0.282625P PS=0.605U PD=1.87U
* device instance _3487 r0 *1 523.765,772.43 nfet_05v0
XM_3487 n_152 n_I4331 VSS VSS nfet_05v0 L=0.6U W=0.82U AS=0.282625P AD=0.3608P
+ PS=1.87U PD=2.52U
* device instance _3488 r0 *1 517.035,772.2 nfet_05v0
XM_3488 VSS n_I2022 n_I4329 VSS nfet_05v0 L=0.6U W=0.36U AS=0.333P AD=0.0936P
+ PS=2.57U PD=0.88U
* device instance _3489 r0 *1 518.155,772.2 nfet_05v0
XM_3489 n_I4332 n_I4329 VSS VSS nfet_05v0 L=0.6U W=0.36U AS=0.0936P AD=0.0432P
+ PS=0.88U PD=0.6U
* device instance _3490 r0 *1 518.995,772.2 nfet_05v0
XM_3490 n_I4330 n_I4329 n_I4332 VSS nfet_05v0 L=0.6U W=0.36U AS=0.0432P
+ AD=0.369P PS=0.6U PD=2.77U
* device instance _3491 r0 *1 524.025,782.81 pfet_05v0
XM_3491 n_I4342 n_I4337 n_I4338 VDD_DEC pfet_05v0 L=0.5U W=0.36U AS=0.3456P
+ AD=0.0612P PS=2.64U PD=0.7U
* device instance _3492 r0 *1 524.865,782.81 pfet_05v0
XM_3492 n_I4342 n_I4337 VDD_DEC VDD_DEC pfet_05v0 L=0.5U W=0.36U AS=0.379P
+ AD=0.0612P PS=2.37U PD=0.7U
* device instance _3493 r0 *1 526.515,782.49 pfet_05v0
XM_3493 n_184 n_I4338 VDD_DEC VDD_DEC pfet_05v0 L=0.5U W=1.22U AS=0.379P
+ AD=0.5368P PS=2.37U PD=3.32U
* device instance _3494 r0 *1 519.785,782.92 pfet_05v0
XM_3494 VDD_DEC n_I2057 n_I4336 VDD_DEC pfet_05v0 L=0.5U W=0.36U AS=0.3852P
+ AD=0.1116P PS=2.86U PD=0.98U
* device instance _3495 r0 *1 520.905,782.92 pfet_05v0
XM_3495 n_I4341 n_I4336 VDD_DEC VDD_DEC pfet_05v0 L=0.5U W=0.36U AS=0.1116P
+ AD=0.0612P PS=0.98U PD=0.7U
* device instance _3496 r0 *1 521.745,782.92 pfet_05v0
XM_3496 n_I4341 n_I4336 n_I4337 VDD_DEC pfet_05v0 L=0.5U W=0.36U AS=0.3852P
+ AD=0.0612P PS=2.86U PD=0.7U
* device instance _3497 r0 *1 524.075,780.042 nfet_05v0
XM_3497 n_I4340 n_I4337 n_I4338 VSS nfet_05v0 L=0.6U W=0.365U AS=0.3705P
+ AD=0.0438P PS=2.77U PD=0.605U
* device instance _3498 r0 *1 524.915,780.042 nfet_05v0
XM_3498 VSS n_I4337 n_I4340 VSS nfet_05v0 L=0.6U W=0.365U AS=0.0438P
+ AD=0.282625P PS=0.605U PD=1.87U
* device instance _3499 r0 *1 526.565,780.27 nfet_05v0
XM_3499 n_184 n_I4338 VSS VSS nfet_05v0 L=0.6U W=0.82U AS=0.282625P AD=0.3608P
+ PS=1.87U PD=2.52U
* device instance _3500 r0 *1 519.835,780.04 nfet_05v0
XM_3500 VSS n_I2057 n_I4336 VSS nfet_05v0 L=0.6U W=0.36U AS=0.333P AD=0.0936P
+ PS=2.57U PD=0.88U
* device instance _3501 r0 *1 520.955,780.04 nfet_05v0
XM_3501 n_I4339 n_I4336 VSS VSS nfet_05v0 L=0.6U W=0.36U AS=0.0936P AD=0.0432P
+ PS=0.88U PD=0.6U
* device instance _3502 r0 *1 521.795,780.04 nfet_05v0
XM_3502 n_I4337 n_I4336 n_I4339 VSS nfet_05v0 L=0.6U W=0.36U AS=0.0432P
+ AD=0.369P PS=0.6U PD=2.77U
* device instance _3503 r0 *1 501.625,837.69 pfet_05v0
XM_3503 n_I4349 n_I4344 n_I4345 VDD_DEC pfet_05v0 L=0.5U W=0.36U AS=0.3456P
+ AD=0.0612P PS=2.64U PD=0.7U
* device instance _3504 r0 *1 502.465,837.69 pfet_05v0
XM_3504 n_I4349 n_I4344 VDD_DEC VDD_DEC pfet_05v0 L=0.5U W=0.36U AS=0.379P
+ AD=0.0612P PS=2.37U PD=0.7U
* device instance _3505 r0 *1 504.115,837.37 pfet_05v0
XM_3505 n_I2355 n_I4345 VDD_DEC VDD_DEC pfet_05v0 L=0.5U W=1.22U AS=0.379P
+ AD=0.5368P PS=2.37U PD=3.32U
* device instance _3506 r0 *1 497.385,837.8 pfet_05v0
XM_3506 VDD_DEC D[0] n_I4343 VDD_DEC pfet_05v0 L=0.5U W=0.36U AS=0.3852P
+ AD=0.1116P PS=2.86U PD=0.98U
* device instance _3507 r0 *1 498.505,837.8 pfet_05v0
XM_3507 n_I4348 n_I4343 VDD_DEC VDD_DEC pfet_05v0 L=0.5U W=0.36U AS=0.1116P
+ AD=0.0612P PS=0.98U PD=0.7U
* device instance _3508 r0 *1 499.345,837.8 pfet_05v0
XM_3508 n_I4348 n_I4343 n_I4344 VDD_DEC pfet_05v0 L=0.5U W=0.36U AS=0.3852P
+ AD=0.0612P PS=2.86U PD=0.7U
* device instance _3509 r0 *1 501.675,834.922 nfet_05v0
XM_3509 n_I4347 n_I4344 n_I4345 VSS nfet_05v0 L=0.6U W=0.365U AS=0.3705P
+ AD=0.0438P PS=2.77U PD=0.605U
* device instance _3510 r0 *1 502.515,834.922 nfet_05v0
XM_3510 VSS n_I4344 n_I4347 VSS nfet_05v0 L=0.6U W=0.365U AS=0.0438P
+ AD=0.282625P PS=0.605U PD=1.87U
* device instance _3511 r0 *1 504.165,835.15 nfet_05v0
XM_3511 n_I2355 n_I4345 VSS VSS nfet_05v0 L=0.6U W=0.82U AS=0.282625P AD=0.3608P
+ PS=1.87U PD=2.52U
* device instance _3512 r0 *1 497.435,834.92 nfet_05v0
XM_3512 VSS D[0] n_I4343 VSS nfet_05v0 L=0.6U W=0.36U AS=0.333P AD=0.0936P
+ PS=2.57U PD=0.88U
* device instance _3513 r0 *1 498.555,834.92 nfet_05v0
XM_3513 n_I4346 n_I4343 VSS VSS nfet_05v0 L=0.6U W=0.36U AS=0.0936P AD=0.0432P
+ PS=0.88U PD=0.6U
* device instance _3514 r0 *1 499.395,834.92 nfet_05v0
XM_3514 n_I4344 n_I4343 n_I4346 VSS nfet_05v0 L=0.6U W=0.36U AS=0.0432P
+ AD=0.369P PS=0.6U PD=2.77U
* device instance _3515 r0 *1 559.305,774.97 pfet_05v0
XM_3515 n_I4356 n_I4351 n_I4352 VDD_DEC pfet_05v0 L=0.5U W=0.36U AS=0.3456P
+ AD=0.0612P PS=2.64U PD=0.7U
* device instance _3516 r0 *1 560.145,774.97 pfet_05v0
XM_3516 n_I4356 n_I4351 VDD_DEC VDD_DEC pfet_05v0 L=0.5U W=0.36U AS=0.379P
+ AD=0.0612P PS=2.37U PD=0.7U
* device instance _3517 r0 *1 561.795,774.65 pfet_05v0
XM_3517 n_174 n_I4352 VDD_DEC VDD_DEC pfet_05v0 L=0.5U W=1.22U AS=0.379P
+ AD=0.5368P PS=2.37U PD=3.32U
* device instance _3518 r0 *1 555.065,775.08 pfet_05v0
XM_3518 VDD_DEC n_I2026 n_I4350 VDD_DEC pfet_05v0 L=0.5U W=0.36U AS=0.3852P
+ AD=0.1116P PS=2.86U PD=0.98U
* device instance _3519 r0 *1 556.185,775.08 pfet_05v0
XM_3519 n_I4355 n_I4350 VDD_DEC VDD_DEC pfet_05v0 L=0.5U W=0.36U AS=0.1116P
+ AD=0.0612P PS=0.98U PD=0.7U
* device instance _3520 r0 *1 557.025,775.08 pfet_05v0
XM_3520 n_I4355 n_I4350 n_I4351 VDD_DEC pfet_05v0 L=0.5U W=0.36U AS=0.3852P
+ AD=0.0612P PS=2.86U PD=0.7U
* device instance _3521 r0 *1 559.355,772.202 nfet_05v0
XM_3521 n_I4354 n_I4351 n_I4352 VSS nfet_05v0 L=0.6U W=0.365U AS=0.3705P
+ AD=0.0438P PS=2.77U PD=0.605U
* device instance _3522 r0 *1 560.195,772.202 nfet_05v0
XM_3522 VSS n_I4351 n_I4354 VSS nfet_05v0 L=0.6U W=0.365U AS=0.0438P
+ AD=0.282625P PS=0.605U PD=1.87U
* device instance _3523 r0 *1 561.845,772.43 nfet_05v0
XM_3523 n_174 n_I4352 VSS VSS nfet_05v0 L=0.6U W=0.82U AS=0.282625P AD=0.3608P
+ PS=1.87U PD=2.52U
* device instance _3524 r0 *1 555.115,772.2 nfet_05v0
XM_3524 VSS n_I2026 n_I4350 VSS nfet_05v0 L=0.6U W=0.36U AS=0.333P AD=0.0936P
+ PS=2.57U PD=0.88U
* device instance _3525 r0 *1 556.235,772.2 nfet_05v0
XM_3525 n_I4353 n_I4350 VSS VSS nfet_05v0 L=0.6U W=0.36U AS=0.0936P AD=0.0432P
+ PS=0.88U PD=0.6U
* device instance _3526 r0 *1 557.075,772.2 nfet_05v0
XM_3526 n_I4351 n_I4350 n_I4353 VSS nfet_05v0 L=0.6U W=0.36U AS=0.0432P
+ AD=0.369P PS=0.6U PD=2.77U
* device instance _3527 r0 *1 645.545,837.69 pfet_05v0
XM_3527 n_I4363 n_I4358 n_I4359 VDD_DEC pfet_05v0 L=0.5U W=0.36U AS=0.3456P
+ AD=0.0612P PS=2.64U PD=0.7U
* device instance _3528 r0 *1 646.385,837.69 pfet_05v0
XM_3528 n_I4363 n_I4358 VDD_DEC VDD_DEC pfet_05v0 L=0.5U W=0.36U AS=0.379P
+ AD=0.0612P PS=2.37U PD=0.7U
* device instance _3529 r0 *1 648.035,837.37 pfet_05v0
XM_3529 n_I2404 n_I4359 VDD_DEC VDD_DEC pfet_05v0 L=0.5U W=1.22U AS=0.379P
+ AD=0.5368P PS=2.37U PD=3.32U
* device instance _3530 r0 *1 641.305,837.8 pfet_05v0
XM_3530 VDD_DEC D[5] n_I4357 VDD_DEC pfet_05v0 L=0.5U W=0.36U AS=0.3852P
+ AD=0.1116P PS=2.86U PD=0.98U
* device instance _3531 r0 *1 642.425,837.8 pfet_05v0
XM_3531 n_I4362 n_I4357 VDD_DEC VDD_DEC pfet_05v0 L=0.5U W=0.36U AS=0.1116P
+ AD=0.0612P PS=0.98U PD=0.7U
* device instance _3532 r0 *1 643.265,837.8 pfet_05v0
XM_3532 n_I4362 n_I4357 n_I4358 VDD_DEC pfet_05v0 L=0.5U W=0.36U AS=0.3852P
+ AD=0.0612P PS=2.86U PD=0.7U
* device instance _3533 r0 *1 645.595,834.922 nfet_05v0
XM_3533 n_I4361 n_I4358 n_I4359 VSS nfet_05v0 L=0.6U W=0.365U AS=0.3705P
+ AD=0.0438P PS=2.77U PD=0.605U
* device instance _3534 r0 *1 646.435,834.922 nfet_05v0
XM_3534 VSS n_I4358 n_I4361 VSS nfet_05v0 L=0.6U W=0.365U AS=0.0438P
+ AD=0.282625P PS=0.605U PD=1.87U
* device instance _3535 r0 *1 648.085,835.15 nfet_05v0
XM_3535 n_I2404 n_I4359 VSS VSS nfet_05v0 L=0.6U W=0.82U AS=0.282625P AD=0.3608P
+ PS=1.87U PD=2.52U
* device instance _3536 r0 *1 641.355,834.92 nfet_05v0
XM_3536 VSS D[5] n_I4357 VSS nfet_05v0 L=0.6U W=0.36U AS=0.333P AD=0.0936P
+ PS=2.57U PD=0.88U
* device instance _3537 r0 *1 642.475,834.92 nfet_05v0
XM_3537 n_I4360 n_I4357 VSS VSS nfet_05v0 L=0.6U W=0.36U AS=0.0936P AD=0.0432P
+ PS=0.88U PD=0.6U
* device instance _3538 r0 *1 643.315,834.92 nfet_05v0
XM_3538 n_I4358 n_I4357 n_I4360 VSS nfet_05v0 L=0.6U W=0.36U AS=0.0432P
+ AD=0.369P PS=0.6U PD=2.77U
* device instance _3539 r0 *1 552.025,829.85 pfet_05v0
XM_3539 n_I4370 n_I4365 n_I4366 VDD_DEC pfet_05v0 L=0.5U W=0.36U AS=0.3456P
+ AD=0.0612P PS=2.64U PD=0.7U
* device instance _3540 r0 *1 552.865,829.85 pfet_05v0
XM_3540 n_I4370 n_I4365 VDD_DEC VDD_DEC pfet_05v0 L=0.5U W=0.36U AS=0.379P
+ AD=0.0612P PS=2.37U PD=0.7U
* device instance _3541 r0 *1 554.515,829.53 pfet_05v0
XM_3541 n_I2354 n_I4366 VDD_DEC VDD_DEC pfet_05v0 L=0.5U W=1.22U AS=0.379P
+ AD=0.5368P PS=2.37U PD=3.32U
* device instance _3542 r0 *1 547.785,829.96 pfet_05v0
XM_3542 VDD_DEC n_I2418 n_I4364 VDD_DEC pfet_05v0 L=0.5U W=0.36U AS=0.3852P
+ AD=0.1116P PS=2.86U PD=0.98U
* device instance _3543 r0 *1 548.905,829.96 pfet_05v0
XM_3543 n_I4369 n_I4364 VDD_DEC VDD_DEC pfet_05v0 L=0.5U W=0.36U AS=0.1116P
+ AD=0.0612P PS=0.98U PD=0.7U
* device instance _3544 r0 *1 549.745,829.96 pfet_05v0
XM_3544 n_I4369 n_I4364 n_I4365 VDD_DEC pfet_05v0 L=0.5U W=0.36U AS=0.3852P
+ AD=0.0612P PS=2.86U PD=0.7U
* device instance _3545 r0 *1 552.075,827.082 nfet_05v0
XM_3545 n_I4368 n_I4365 n_I4366 VSS nfet_05v0 L=0.6U W=0.365U AS=0.3705P
+ AD=0.0438P PS=2.77U PD=0.605U
* device instance _3546 r0 *1 552.915,827.082 nfet_05v0
XM_3546 VSS n_I4365 n_I4368 VSS nfet_05v0 L=0.6U W=0.365U AS=0.0438P
+ AD=0.282625P PS=0.605U PD=1.87U
* device instance _3547 r0 *1 554.565,827.31 nfet_05v0
XM_3547 n_I2354 n_I4366 VSS VSS nfet_05v0 L=0.6U W=0.82U AS=0.282625P AD=0.3608P
+ PS=1.87U PD=2.52U
* device instance _3548 r0 *1 547.835,827.08 nfet_05v0
XM_3548 VSS n_I2418 n_I4364 VSS nfet_05v0 L=0.6U W=0.36U AS=0.333P AD=0.0936P
+ PS=2.57U PD=0.88U
* device instance _3549 r0 *1 548.955,827.08 nfet_05v0
XM_3549 n_I4367 n_I4364 VSS VSS nfet_05v0 L=0.6U W=0.36U AS=0.0936P AD=0.0432P
+ PS=0.88U PD=0.6U
* device instance _3550 r0 *1 549.795,827.08 nfet_05v0
XM_3550 n_I4365 n_I4364 n_I4367 VSS nfet_05v0 L=0.6U W=0.36U AS=0.0432P
+ AD=0.369P PS=0.6U PD=2.77U
* device instance _3551 r0 *1 531.305,774.97 pfet_05v0
XM_3551 n_I4377 n_I4372 n_I4373 VDD_DEC pfet_05v0 L=0.5U W=0.36U AS=0.3456P
+ AD=0.0612P PS=2.64U PD=0.7U
* device instance _3552 r0 *1 532.145,774.97 pfet_05v0
XM_3552 n_I4377 n_I4372 VDD_DEC VDD_DEC pfet_05v0 L=0.5U W=0.36U AS=0.379P
+ AD=0.0612P PS=2.37U PD=0.7U
* device instance _3553 r0 *1 533.795,774.65 pfet_05v0
XM_3553 n_167 n_I4373 VDD_DEC VDD_DEC pfet_05v0 L=0.5U W=1.22U AS=0.379P
+ AD=0.5368P PS=2.37U PD=3.32U
* device instance _3554 r0 *1 527.065,775.08 pfet_05v0
XM_3554 VDD_DEC n_I2023 n_I4371 VDD_DEC pfet_05v0 L=0.5U W=0.36U AS=0.3852P
+ AD=0.1116P PS=2.86U PD=0.98U
* device instance _3555 r0 *1 528.185,775.08 pfet_05v0
XM_3555 n_I4376 n_I4371 VDD_DEC VDD_DEC pfet_05v0 L=0.5U W=0.36U AS=0.1116P
+ AD=0.0612P PS=0.98U PD=0.7U
* device instance _3556 r0 *1 529.025,775.08 pfet_05v0
XM_3556 n_I4376 n_I4371 n_I4372 VDD_DEC pfet_05v0 L=0.5U W=0.36U AS=0.3852P
+ AD=0.0612P PS=2.86U PD=0.7U
* device instance _3557 r0 *1 531.355,772.202 nfet_05v0
XM_3557 n_I4375 n_I4372 n_I4373 VSS nfet_05v0 L=0.6U W=0.365U AS=0.3705P
+ AD=0.0438P PS=2.77U PD=0.605U
* device instance _3558 r0 *1 532.195,772.202 nfet_05v0
XM_3558 VSS n_I4372 n_I4375 VSS nfet_05v0 L=0.6U W=0.365U AS=0.0438P
+ AD=0.282625P PS=0.605U PD=1.87U
* device instance _3559 r0 *1 533.845,772.43 nfet_05v0
XM_3559 n_167 n_I4373 VSS VSS nfet_05v0 L=0.6U W=0.82U AS=0.282625P AD=0.3608P
+ PS=1.87U PD=2.52U
* device instance _3560 r0 *1 527.115,772.2 nfet_05v0
XM_3560 VSS n_I2023 n_I4371 VSS nfet_05v0 L=0.6U W=0.36U AS=0.333P AD=0.0936P
+ PS=2.57U PD=0.88U
* device instance _3561 r0 *1 528.235,772.2 nfet_05v0
XM_3561 n_I4374 n_I4371 VSS VSS nfet_05v0 L=0.6U W=0.36U AS=0.0936P AD=0.0432P
+ PS=0.88U PD=0.6U
* device instance _3562 r0 *1 529.075,772.2 nfet_05v0
XM_3562 n_I4372 n_I4371 n_I4374 VSS nfet_05v0 L=0.6U W=0.36U AS=0.0432P
+ AD=0.369P PS=0.6U PD=2.77U
* device instance _3563 r0 *1 572.185,782.81 pfet_05v0
XM_3563 n_I4384 n_I4379 n_I4380 VDD_DEC pfet_05v0 L=0.5U W=0.36U AS=0.3456P
+ AD=0.0612P PS=2.64U PD=0.7U
* device instance _3564 r0 *1 573.025,782.81 pfet_05v0
XM_3564 n_I4384 n_I4379 VDD_DEC VDD_DEC pfet_05v0 L=0.5U W=0.36U AS=0.379P
+ AD=0.0612P PS=2.37U PD=0.7U
* device instance _3565 r0 *1 574.675,782.49 pfet_05v0
XM_3565 n_183 n_I4380 VDD_DEC VDD_DEC pfet_05v0 L=0.5U W=1.22U AS=0.379P
+ AD=0.5368P PS=2.37U PD=3.32U
* device instance _3566 r0 *1 567.945,782.92 pfet_05v0
XM_3566 VDD_DEC n_I2061 n_I4378 VDD_DEC pfet_05v0 L=0.5U W=0.36U AS=0.3852P
+ AD=0.1116P PS=2.86U PD=0.98U
* device instance _3567 r0 *1 569.065,782.92 pfet_05v0
XM_3567 n_I4383 n_I4378 VDD_DEC VDD_DEC pfet_05v0 L=0.5U W=0.36U AS=0.1116P
+ AD=0.0612P PS=0.98U PD=0.7U
* device instance _3568 r0 *1 569.905,782.92 pfet_05v0
XM_3568 n_I4383 n_I4378 n_I4379 VDD_DEC pfet_05v0 L=0.5U W=0.36U AS=0.3852P
+ AD=0.0612P PS=2.86U PD=0.7U
* device instance _3569 r0 *1 572.235,780.042 nfet_05v0
XM_3569 n_I4382 n_I4379 n_I4380 VSS nfet_05v0 L=0.6U W=0.365U AS=0.3705P
+ AD=0.0438P PS=2.77U PD=0.605U
* device instance _3570 r0 *1 573.075,780.042 nfet_05v0
XM_3570 VSS n_I4379 n_I4382 VSS nfet_05v0 L=0.6U W=0.365U AS=0.0438P
+ AD=0.282625P PS=0.605U PD=1.87U
* device instance _3571 r0 *1 574.725,780.27 nfet_05v0
XM_3571 n_183 n_I4380 VSS VSS nfet_05v0 L=0.6U W=0.82U AS=0.282625P AD=0.3608P
+ PS=1.87U PD=2.52U
* device instance _3572 r0 *1 567.995,780.04 nfet_05v0
XM_3572 VSS n_I2061 n_I4378 VSS nfet_05v0 L=0.6U W=0.36U AS=0.333P AD=0.0936P
+ PS=2.57U PD=0.88U
* device instance _3573 r0 *1 569.115,780.04 nfet_05v0
XM_3573 n_I4381 n_I4378 VSS VSS nfet_05v0 L=0.6U W=0.36U AS=0.0936P AD=0.0432P
+ PS=0.88U PD=0.6U
* device instance _3574 r0 *1 569.955,780.04 nfet_05v0
XM_3574 n_I4379 n_I4378 n_I4381 VSS nfet_05v0 L=0.6U W=0.36U AS=0.0432P
+ AD=0.369P PS=0.6U PD=2.77U
* device instance _3575 r0 *1 554.265,782.81 pfet_05v0
XM_3575 n_I4391 n_I4386 n_I4387 VDD_DEC pfet_05v0 L=0.5U W=0.36U AS=0.3456P
+ AD=0.0612P PS=2.64U PD=0.7U
* device instance _3576 r0 *1 555.105,782.81 pfet_05v0
XM_3576 n_I4391 n_I4386 VDD_DEC VDD_DEC pfet_05v0 L=0.5U W=0.36U AS=0.379P
+ AD=0.0612P PS=2.37U PD=0.7U
* device instance _3577 r0 *1 556.755,782.49 pfet_05v0
XM_3577 n_150 n_I4387 VDD_DEC VDD_DEC pfet_05v0 L=0.5U W=1.22U AS=0.379P
+ AD=0.5368P PS=2.37U PD=3.32U
* device instance _3578 r0 *1 550.025,782.92 pfet_05v0
XM_3578 VDD_DEC n_I2062 n_I4385 VDD_DEC pfet_05v0 L=0.5U W=0.36U AS=0.3852P
+ AD=0.1116P PS=2.86U PD=0.98U
* device instance _3579 r0 *1 551.145,782.92 pfet_05v0
XM_3579 n_I4390 n_I4385 VDD_DEC VDD_DEC pfet_05v0 L=0.5U W=0.36U AS=0.1116P
+ AD=0.0612P PS=0.98U PD=0.7U
* device instance _3580 r0 *1 551.985,782.92 pfet_05v0
XM_3580 n_I4390 n_I4385 n_I4386 VDD_DEC pfet_05v0 L=0.5U W=0.36U AS=0.3852P
+ AD=0.0612P PS=2.86U PD=0.7U
* device instance _3581 r0 *1 554.315,780.042 nfet_05v0
XM_3581 n_I4389 n_I4386 n_I4387 VSS nfet_05v0 L=0.6U W=0.365U AS=0.3705P
+ AD=0.0438P PS=2.77U PD=0.605U
* device instance _3582 r0 *1 555.155,780.042 nfet_05v0
XM_3582 VSS n_I4386 n_I4389 VSS nfet_05v0 L=0.6U W=0.365U AS=0.0438P
+ AD=0.282625P PS=0.605U PD=1.87U
* device instance _3583 r0 *1 556.805,780.27 nfet_05v0
XM_3583 n_150 n_I4387 VSS VSS nfet_05v0 L=0.6U W=0.82U AS=0.282625P AD=0.3608P
+ PS=1.87U PD=2.52U
* device instance _3584 r0 *1 550.075,780.04 nfet_05v0
XM_3584 VSS n_I2062 n_I4385 VSS nfet_05v0 L=0.6U W=0.36U AS=0.333P AD=0.0936P
+ PS=2.57U PD=0.88U
* device instance _3585 r0 *1 551.195,780.04 nfet_05v0
XM_3585 n_I4388 n_I4385 VSS VSS nfet_05v0 L=0.6U W=0.36U AS=0.0936P AD=0.0432P
+ PS=0.88U PD=0.6U
* device instance _3586 r0 *1 552.035,780.04 nfet_05v0
XM_3586 n_I4386 n_I4385 n_I4388 VSS nfet_05v0 L=0.6U W=0.36U AS=0.0432P
+ AD=0.369P PS=0.6U PD=2.77U
* device instance _3587 r0 *1 531.305,837.69 pfet_05v0
XM_3587 n_I4398 n_I4393 n_I4394 VDD_DEC pfet_05v0 L=0.5U W=0.36U AS=0.3456P
+ AD=0.0612P PS=2.64U PD=0.7U
* device instance _3588 r0 *1 532.145,837.69 pfet_05v0
XM_3588 n_I4398 n_I4393 VDD_DEC VDD_DEC pfet_05v0 L=0.5U W=0.36U AS=0.379P
+ AD=0.0612P PS=2.37U PD=0.7U
* device instance _3589 r0 *1 533.795,837.37 pfet_05v0
XM_3589 n_I2365 n_I4394 VDD_DEC VDD_DEC pfet_05v0 L=0.5U W=1.22U AS=0.379P
+ AD=0.5368P PS=2.37U PD=3.32U
* device instance _3590 r0 *1 527.065,837.8 pfet_05v0
XM_3590 VDD_DEC D[1] n_I4392 VDD_DEC pfet_05v0 L=0.5U W=0.36U AS=0.3852P
+ AD=0.1116P PS=2.86U PD=0.98U
* device instance _3591 r0 *1 528.185,837.8 pfet_05v0
XM_3591 n_I4397 n_I4392 VDD_DEC VDD_DEC pfet_05v0 L=0.5U W=0.36U AS=0.1116P
+ AD=0.0612P PS=0.98U PD=0.7U
* device instance _3592 r0 *1 529.025,837.8 pfet_05v0
XM_3592 n_I4397 n_I4392 n_I4393 VDD_DEC pfet_05v0 L=0.5U W=0.36U AS=0.3852P
+ AD=0.0612P PS=2.86U PD=0.7U
* device instance _3593 r0 *1 531.355,834.922 nfet_05v0
XM_3593 n_I4396 n_I4393 n_I4394 VSS nfet_05v0 L=0.6U W=0.365U AS=0.3705P
+ AD=0.0438P PS=2.77U PD=0.605U
* device instance _3594 r0 *1 532.195,834.922 nfet_05v0
XM_3594 VSS n_I4393 n_I4396 VSS nfet_05v0 L=0.6U W=0.365U AS=0.0438P
+ AD=0.282625P PS=0.605U PD=1.87U
* device instance _3595 r0 *1 533.845,835.15 nfet_05v0
XM_3595 n_I2365 n_I4394 VSS VSS nfet_05v0 L=0.6U W=0.82U AS=0.282625P AD=0.3608P
+ PS=1.87U PD=2.52U
* device instance _3596 r0 *1 527.115,834.92 nfet_05v0
XM_3596 VSS D[1] n_I4392 VSS nfet_05v0 L=0.6U W=0.36U AS=0.333P AD=0.0936P
+ PS=2.57U PD=0.88U
* device instance _3597 r0 *1 528.235,834.92 nfet_05v0
XM_3597 n_I4395 n_I4392 VSS VSS nfet_05v0 L=0.6U W=0.36U AS=0.0936P AD=0.0432P
+ PS=0.88U PD=0.6U
* device instance _3598 r0 *1 529.075,834.92 nfet_05v0
XM_3598 n_I4393 n_I4392 n_I4395 VSS nfet_05v0 L=0.6U W=0.36U AS=0.0432P
+ AD=0.369P PS=0.6U PD=2.77U
* device instance _3599 r0 *1 541.945,782.81 pfet_05v0
XM_3599 n_I4405 n_I4400 n_I4401 VDD_DEC pfet_05v0 L=0.5U W=0.36U AS=0.3456P
+ AD=0.0612P PS=2.64U PD=0.7U
* device instance _3600 r0 *1 542.785,782.81 pfet_05v0
XM_3600 n_I4405 n_I4400 VDD_DEC VDD_DEC pfet_05v0 L=0.5U W=0.36U AS=0.379P
+ AD=0.0612P PS=2.37U PD=0.7U
* device instance _3601 r0 *1 544.435,782.49 pfet_05v0
XM_3601 n_176 n_I4401 VDD_DEC VDD_DEC pfet_05v0 L=0.5U W=1.22U AS=0.379P
+ AD=0.5368P PS=2.37U PD=3.32U
* device instance _3602 r0 *1 537.705,782.92 pfet_05v0
XM_3602 VDD_DEC n_I2059 n_I4399 VDD_DEC pfet_05v0 L=0.5U W=0.36U AS=0.3852P
+ AD=0.1116P PS=2.86U PD=0.98U
* device instance _3603 r0 *1 538.825,782.92 pfet_05v0
XM_3603 n_I4404 n_I4399 VDD_DEC VDD_DEC pfet_05v0 L=0.5U W=0.36U AS=0.1116P
+ AD=0.0612P PS=0.98U PD=0.7U
* device instance _3604 r0 *1 539.665,782.92 pfet_05v0
XM_3604 n_I4404 n_I4399 n_I4400 VDD_DEC pfet_05v0 L=0.5U W=0.36U AS=0.3852P
+ AD=0.0612P PS=2.86U PD=0.7U
* device instance _3605 r0 *1 541.995,780.042 nfet_05v0
XM_3605 n_I4403 n_I4400 n_I4401 VSS nfet_05v0 L=0.6U W=0.365U AS=0.3705P
+ AD=0.0438P PS=2.77U PD=0.605U
* device instance _3606 r0 *1 542.835,780.042 nfet_05v0
XM_3606 VSS n_I4400 n_I4403 VSS nfet_05v0 L=0.6U W=0.365U AS=0.0438P
+ AD=0.282625P PS=0.605U PD=1.87U
* device instance _3607 r0 *1 544.485,780.27 nfet_05v0
XM_3607 n_176 n_I4401 VSS VSS nfet_05v0 L=0.6U W=0.82U AS=0.282625P AD=0.3608P
+ PS=1.87U PD=2.52U
* device instance _3608 r0 *1 537.755,780.04 nfet_05v0
XM_3608 VSS n_I2059 n_I4399 VSS nfet_05v0 L=0.6U W=0.36U AS=0.333P AD=0.0936P
+ PS=2.57U PD=0.88U
* device instance _3609 r0 *1 538.875,780.04 nfet_05v0
XM_3609 n_I4402 n_I4399 VSS VSS nfet_05v0 L=0.6U W=0.36U AS=0.0936P AD=0.0432P
+ PS=0.88U PD=0.6U
* device instance _3610 r0 *1 539.715,780.04 nfet_05v0
XM_3610 n_I4400 n_I4399 n_I4402 VSS nfet_05v0 L=0.6U W=0.36U AS=0.0432P
+ AD=0.369P PS=0.6U PD=2.77U
* device instance _3611 r0 *1 569.385,774.97 pfet_05v0
XM_3611 n_I4412 n_I4407 n_I4408 VDD_DEC pfet_05v0 L=0.5U W=0.36U AS=0.3456P
+ AD=0.0612P PS=2.64U PD=0.7U
* device instance _3612 r0 *1 570.225,774.97 pfet_05v0
XM_3612 n_I4412 n_I4407 VDD_DEC VDD_DEC pfet_05v0 L=0.5U W=0.36U AS=0.379P
+ AD=0.0612P PS=2.37U PD=0.7U
* device instance _3613 r0 *1 571.875,774.65 pfet_05v0
XM_3613 n_189 n_I4408 VDD_DEC VDD_DEC pfet_05v0 L=0.5U W=1.22U AS=0.379P
+ AD=0.5368P PS=2.37U PD=3.32U
* device instance _3614 r0 *1 565.145,775.08 pfet_05v0
XM_3614 VDD_DEC n_I2027 n_I4406 VDD_DEC pfet_05v0 L=0.5U W=0.36U AS=0.3852P
+ AD=0.1116P PS=2.86U PD=0.98U
* device instance _3615 r0 *1 566.265,775.08 pfet_05v0
XM_3615 n_I4411 n_I4406 VDD_DEC VDD_DEC pfet_05v0 L=0.5U W=0.36U AS=0.1116P
+ AD=0.0612P PS=0.98U PD=0.7U
* device instance _3616 r0 *1 567.105,775.08 pfet_05v0
XM_3616 n_I4411 n_I4406 n_I4407 VDD_DEC pfet_05v0 L=0.5U W=0.36U AS=0.3852P
+ AD=0.0612P PS=2.86U PD=0.7U
* device instance _3617 r0 *1 569.435,772.202 nfet_05v0
XM_3617 n_I4410 n_I4407 n_I4408 VSS nfet_05v0 L=0.6U W=0.365U AS=0.3705P
+ AD=0.0438P PS=2.77U PD=0.605U
* device instance _3618 r0 *1 570.275,772.202 nfet_05v0
XM_3618 VSS n_I4407 n_I4410 VSS nfet_05v0 L=0.6U W=0.365U AS=0.0438P
+ AD=0.282625P PS=0.605U PD=1.87U
* device instance _3619 r0 *1 571.925,772.43 nfet_05v0
XM_3619 n_189 n_I4408 VSS VSS nfet_05v0 L=0.6U W=0.82U AS=0.282625P AD=0.3608P
+ PS=1.87U PD=2.52U
* device instance _3620 r0 *1 565.195,772.2 nfet_05v0
XM_3620 VSS n_I2027 n_I4406 VSS nfet_05v0 L=0.6U W=0.36U AS=0.333P AD=0.0936P
+ PS=2.57U PD=0.88U
* device instance _3621 r0 *1 566.315,772.2 nfet_05v0
XM_3621 n_I4409 n_I4406 VSS VSS nfet_05v0 L=0.6U W=0.36U AS=0.0936P AD=0.0432P
+ PS=0.88U PD=0.6U
* device instance _3622 r0 *1 567.155,772.2 nfet_05v0
XM_3622 n_I4407 n_I4406 n_I4409 VSS nfet_05v0 L=0.6U W=0.36U AS=0.0432P
+ AD=0.369P PS=0.6U PD=2.77U
* device instance _3623 r0 *1 540.265,774.97 pfet_05v0
XM_3623 n_I4419 n_I4414 n_I4415 VDD_DEC pfet_05v0 L=0.5U W=0.36U AS=0.3456P
+ AD=0.0612P PS=2.64U PD=0.7U
* device instance _3624 r0 *1 541.105,774.97 pfet_05v0
XM_3624 n_I4419 n_I4414 VDD_DEC VDD_DEC pfet_05v0 L=0.5U W=0.36U AS=0.379P
+ AD=0.0612P PS=2.37U PD=0.7U
* device instance _3625 r0 *1 542.755,774.65 pfet_05v0
XM_3625 n_188 n_I4415 VDD_DEC VDD_DEC pfet_05v0 L=0.5U W=1.22U AS=0.379P
+ AD=0.5368P PS=2.37U PD=3.32U
* device instance _3626 r0 *1 536.025,775.08 pfet_05v0
XM_3626 VDD_DEC n_I2024 n_I4413 VDD_DEC pfet_05v0 L=0.5U W=0.36U AS=0.3852P
+ AD=0.1116P PS=2.86U PD=0.98U
* device instance _3627 r0 *1 537.145,775.08 pfet_05v0
XM_3627 n_I4418 n_I4413 VDD_DEC VDD_DEC pfet_05v0 L=0.5U W=0.36U AS=0.1116P
+ AD=0.0612P PS=0.98U PD=0.7U
* device instance _3628 r0 *1 537.985,775.08 pfet_05v0
XM_3628 n_I4418 n_I4413 n_I4414 VDD_DEC pfet_05v0 L=0.5U W=0.36U AS=0.3852P
+ AD=0.0612P PS=2.86U PD=0.7U
* device instance _3629 r0 *1 540.315,772.202 nfet_05v0
XM_3629 n_I4417 n_I4414 n_I4415 VSS nfet_05v0 L=0.6U W=0.365U AS=0.3705P
+ AD=0.0438P PS=2.77U PD=0.605U
* device instance _3630 r0 *1 541.155,772.202 nfet_05v0
XM_3630 VSS n_I4414 n_I4417 VSS nfet_05v0 L=0.6U W=0.365U AS=0.0438P
+ AD=0.282625P PS=0.605U PD=1.87U
* device instance _3631 r0 *1 542.805,772.43 nfet_05v0
XM_3631 n_188 n_I4415 VSS VSS nfet_05v0 L=0.6U W=0.82U AS=0.282625P AD=0.3608P
+ PS=1.87U PD=2.52U
* device instance _3632 r0 *1 536.075,772.2 nfet_05v0
XM_3632 VSS n_I2024 n_I4413 VSS nfet_05v0 L=0.6U W=0.36U AS=0.333P AD=0.0936P
+ PS=2.57U PD=0.88U
* device instance _3633 r0 *1 537.195,772.2 nfet_05v0
XM_3633 n_I4416 n_I4413 VSS VSS nfet_05v0 L=0.6U W=0.36U AS=0.0936P AD=0.0432P
+ PS=0.88U PD=0.6U
* device instance _3634 r0 *1 538.035,772.2 nfet_05v0
XM_3634 n_I4414 n_I4413 n_I4416 VSS nfet_05v0 L=0.6U W=0.36U AS=0.0432P
+ AD=0.369P PS=0.6U PD=2.77U
* device instance _3635 r0 *1 652.265,806.33 pfet_05v0
XM_3635 n_I4426 n_I4421 n_I4422 VDD_DEC pfet_05v0 L=0.5U W=0.36U AS=0.3456P
+ AD=0.0612P PS=2.64U PD=0.7U
* device instance _3636 r0 *1 653.105,806.33 pfet_05v0
XM_3636 n_I4426 n_I4421 VDD_DEC VDD_DEC pfet_05v0 L=0.5U W=0.36U AS=0.379P
+ AD=0.0612P PS=2.37U PD=0.7U
* device instance _3637 r0 *1 654.755,806.01 pfet_05v0
XM_3637 n_I2139 n_I4422 VDD_DEC VDD_DEC pfet_05v0 L=0.5U W=1.22U AS=0.379P
+ AD=0.5368P PS=2.37U PD=3.32U
* device instance _3638 r0 *1 648.025,806.44 pfet_05v0
XM_3638 VDD_DEC n_I2175 n_I4420 VDD_DEC pfet_05v0 L=0.5U W=0.36U AS=0.3852P
+ AD=0.1116P PS=2.86U PD=0.98U
* device instance _3639 r0 *1 649.145,806.44 pfet_05v0
XM_3639 n_I4425 n_I4420 VDD_DEC VDD_DEC pfet_05v0 L=0.5U W=0.36U AS=0.1116P
+ AD=0.0612P PS=0.98U PD=0.7U
* device instance _3640 r0 *1 649.985,806.44 pfet_05v0
XM_3640 n_I4425 n_I4420 n_I4421 VDD_DEC pfet_05v0 L=0.5U W=0.36U AS=0.3852P
+ AD=0.0612P PS=2.86U PD=0.7U
* device instance _3641 r0 *1 652.315,803.562 nfet_05v0
XM_3641 n_I4424 n_I4421 n_I4422 VSS nfet_05v0 L=0.6U W=0.365U AS=0.3705P
+ AD=0.0438P PS=2.77U PD=0.605U
* device instance _3642 r0 *1 653.155,803.562 nfet_05v0
XM_3642 VSS n_I4421 n_I4424 VSS nfet_05v0 L=0.6U W=0.365U AS=0.0438P
+ AD=0.282625P PS=0.605U PD=1.87U
* device instance _3643 r0 *1 654.805,803.79 nfet_05v0
XM_3643 n_I2139 n_I4422 VSS VSS nfet_05v0 L=0.6U W=0.82U AS=0.282625P AD=0.3608P
+ PS=1.87U PD=2.52U
* device instance _3644 r0 *1 648.075,803.56 nfet_05v0
XM_3644 VSS n_I2175 n_I4420 VSS nfet_05v0 L=0.6U W=0.36U AS=0.333P AD=0.0936P
+ PS=2.57U PD=0.88U
* device instance _3645 r0 *1 649.195,803.56 nfet_05v0
XM_3645 n_I4423 n_I4420 VSS VSS nfet_05v0 L=0.6U W=0.36U AS=0.0936P AD=0.0432P
+ PS=0.88U PD=0.6U
* device instance _3646 r0 *1 650.035,803.56 nfet_05v0
XM_3646 n_I4421 n_I4420 n_I4423 VSS nfet_05v0 L=0.6U W=0.36U AS=0.0432P
+ AD=0.369P PS=0.6U PD=2.77U
* device instance _3647 r0 *1 539.705,822.01 pfet_05v0
XM_3647 n_I4433 n_I4428 n_I4429 VDD_DEC pfet_05v0 L=0.5U W=0.36U AS=0.3456P
+ AD=0.0612P PS=2.64U PD=0.7U
* device instance _3648 r0 *1 540.545,822.01 pfet_05v0
XM_3648 n_I4433 n_I4428 VDD_DEC VDD_DEC pfet_05v0 L=0.5U W=0.36U AS=0.379P
+ AD=0.0612P PS=2.37U PD=0.7U
* device instance _3649 r0 *1 542.195,821.69 pfet_05v0
XM_3649 n_I2322 n_I4429 VDD_DEC VDD_DEC pfet_05v0 L=0.5U W=1.22U AS=0.379P
+ AD=0.5368P PS=2.37U PD=3.32U
* device instance _3650 r0 *1 535.465,822.12 pfet_05v0
XM_3650 VDD_DEC n_I2365 n_I4427 VDD_DEC pfet_05v0 L=0.5U W=0.36U AS=0.3852P
+ AD=0.1116P PS=2.86U PD=0.98U
* device instance _3651 r0 *1 536.585,822.12 pfet_05v0
XM_3651 n_I4432 n_I4427 VDD_DEC VDD_DEC pfet_05v0 L=0.5U W=0.36U AS=0.1116P
+ AD=0.0612P PS=0.98U PD=0.7U
* device instance _3652 r0 *1 537.425,822.12 pfet_05v0
XM_3652 n_I4432 n_I4427 n_I4428 VDD_DEC pfet_05v0 L=0.5U W=0.36U AS=0.3852P
+ AD=0.0612P PS=2.86U PD=0.7U
* device instance _3653 r0 *1 539.755,819.242 nfet_05v0
XM_3653 n_I4431 n_I4428 n_I4429 VSS nfet_05v0 L=0.6U W=0.365U AS=0.3705P
+ AD=0.0438P PS=2.77U PD=0.605U
* device instance _3654 r0 *1 540.595,819.242 nfet_05v0
XM_3654 VSS n_I4428 n_I4431 VSS nfet_05v0 L=0.6U W=0.365U AS=0.0438P
+ AD=0.282625P PS=0.605U PD=1.87U
* device instance _3655 r0 *1 542.245,819.47 nfet_05v0
XM_3655 n_I2322 n_I4429 VSS VSS nfet_05v0 L=0.6U W=0.82U AS=0.282625P AD=0.3608P
+ PS=1.87U PD=2.52U
* device instance _3656 r0 *1 535.515,819.24 nfet_05v0
XM_3656 VSS n_I2365 n_I4427 VSS nfet_05v0 L=0.6U W=0.36U AS=0.333P AD=0.0936P
+ PS=2.57U PD=0.88U
* device instance _3657 r0 *1 536.635,819.24 nfet_05v0
XM_3657 n_I4430 n_I4427 VSS VSS nfet_05v0 L=0.6U W=0.36U AS=0.0936P AD=0.0432P
+ PS=0.88U PD=0.6U
* device instance _3658 r0 *1 537.475,819.24 nfet_05v0
XM_3658 n_I4428 n_I4427 n_I4430 VSS nfet_05v0 L=0.6U W=0.36U AS=0.0432P
+ AD=0.369P PS=0.6U PD=2.77U
* device instance _3659 r0 *1 532.985,782.81 pfet_05v0
XM_3659 n_I4440 n_I4435 n_I4436 VDD_DEC pfet_05v0 L=0.5U W=0.36U AS=0.3456P
+ AD=0.0612P PS=2.64U PD=0.7U
* device instance _3660 r0 *1 533.825,782.81 pfet_05v0
XM_3660 n_I4440 n_I4435 VDD_DEC VDD_DEC pfet_05v0 L=0.5U W=0.36U AS=0.379P
+ AD=0.0612P PS=2.37U PD=0.7U
* device instance _3661 r0 *1 535.475,782.49 pfet_05v0
XM_3661 n_158 n_I4436 VDD_DEC VDD_DEC pfet_05v0 L=0.5U W=1.22U AS=0.379P
+ AD=0.5368P PS=2.37U PD=3.32U
* device instance _3662 r0 *1 528.745,782.92 pfet_05v0
XM_3662 VDD_DEC n_I2051 n_I4434 VDD_DEC pfet_05v0 L=0.5U W=0.36U AS=0.3852P
+ AD=0.1116P PS=2.86U PD=0.98U
* device instance _3663 r0 *1 529.865,782.92 pfet_05v0
XM_3663 n_I4439 n_I4434 VDD_DEC VDD_DEC pfet_05v0 L=0.5U W=0.36U AS=0.1116P
+ AD=0.0612P PS=0.98U PD=0.7U
* device instance _3664 r0 *1 530.705,782.92 pfet_05v0
XM_3664 n_I4439 n_I4434 n_I4435 VDD_DEC pfet_05v0 L=0.5U W=0.36U AS=0.3852P
+ AD=0.0612P PS=2.86U PD=0.7U
* device instance _3665 r0 *1 533.035,780.042 nfet_05v0
XM_3665 n_I4438 n_I4435 n_I4436 VSS nfet_05v0 L=0.6U W=0.365U AS=0.3705P
+ AD=0.0438P PS=2.77U PD=0.605U
* device instance _3666 r0 *1 533.875,780.042 nfet_05v0
XM_3666 VSS n_I4435 n_I4438 VSS nfet_05v0 L=0.6U W=0.365U AS=0.0438P
+ AD=0.282625P PS=0.605U PD=1.87U
* device instance _3667 r0 *1 535.525,780.27 nfet_05v0
XM_3667 n_158 n_I4436 VSS VSS nfet_05v0 L=0.6U W=0.82U AS=0.282625P AD=0.3608P
+ PS=1.87U PD=2.52U
* device instance _3668 r0 *1 528.795,780.04 nfet_05v0
XM_3668 VSS n_I2051 n_I4434 VSS nfet_05v0 L=0.6U W=0.36U AS=0.333P AD=0.0936P
+ PS=2.57U PD=0.88U
* device instance _3669 r0 *1 529.915,780.04 nfet_05v0
XM_3669 n_I4437 n_I4434 VSS VSS nfet_05v0 L=0.6U W=0.36U AS=0.0936P AD=0.0432P
+ PS=0.88U PD=0.6U
* device instance _3670 r0 *1 530.755,780.04 nfet_05v0
XM_3670 n_I4435 n_I4434 n_I4437 VSS nfet_05v0 L=0.6U W=0.36U AS=0.0432P
+ AD=0.369P PS=0.6U PD=2.77U
* device instance _3671 r0 *1 516.745,790.65 pfet_05v0
XM_3671 n_I4447 n_I4442 n_I4443 VDD_DEC pfet_05v0 L=0.5U W=0.36U AS=0.3456P
+ AD=0.0612P PS=2.64U PD=0.7U
* device instance _3672 r0 *1 517.585,790.65 pfet_05v0
XM_3672 n_I4447 n_I4442 VDD_DEC VDD_DEC pfet_05v0 L=0.5U W=0.36U AS=0.379P
+ AD=0.0612P PS=2.37U PD=0.7U
* device instance _3673 r0 *1 519.235,790.33 pfet_05v0
XM_3673 n_145 n_I4443 VDD_DEC VDD_DEC pfet_05v0 L=0.5U W=1.22U AS=0.379P
+ AD=0.5368P PS=2.37U PD=3.32U
* device instance _3674 r0 *1 512.505,790.76 pfet_05v0
XM_3674 VDD_DEC n_I2160 n_I4441 VDD_DEC pfet_05v0 L=0.5U W=0.36U AS=0.3852P
+ AD=0.1116P PS=2.86U PD=0.98U
* device instance _3675 r0 *1 513.625,790.76 pfet_05v0
XM_3675 n_I4446 n_I4441 VDD_DEC VDD_DEC pfet_05v0 L=0.5U W=0.36U AS=0.1116P
+ AD=0.0612P PS=0.98U PD=0.7U
* device instance _3676 r0 *1 514.465,790.76 pfet_05v0
XM_3676 n_I4446 n_I4441 n_I4442 VDD_DEC pfet_05v0 L=0.5U W=0.36U AS=0.3852P
+ AD=0.0612P PS=2.86U PD=0.7U
* device instance _3677 r0 *1 516.795,787.882 nfet_05v0
XM_3677 n_I4445 n_I4442 n_I4443 VSS nfet_05v0 L=0.6U W=0.365U AS=0.3705P
+ AD=0.0438P PS=2.77U PD=0.605U
* device instance _3678 r0 *1 517.635,787.882 nfet_05v0
XM_3678 VSS n_I4442 n_I4445 VSS nfet_05v0 L=0.6U W=0.365U AS=0.0438P
+ AD=0.282625P PS=0.605U PD=1.87U
* device instance _3679 r0 *1 519.285,788.11 nfet_05v0
XM_3679 n_145 n_I4443 VSS VSS nfet_05v0 L=0.6U W=0.82U AS=0.282625P AD=0.3608P
+ PS=1.87U PD=2.52U
* device instance _3680 r0 *1 512.555,787.88 nfet_05v0
XM_3680 VSS n_I2160 n_I4441 VSS nfet_05v0 L=0.6U W=0.36U AS=0.333P AD=0.0936P
+ PS=2.57U PD=0.88U
* device instance _3681 r0 *1 513.675,787.88 nfet_05v0
XM_3681 n_I4444 n_I4441 VSS VSS nfet_05v0 L=0.6U W=0.36U AS=0.0936P AD=0.0432P
+ PS=0.88U PD=0.6U
* device instance _3682 r0 *1 514.515,787.88 nfet_05v0
XM_3682 n_I4442 n_I4441 n_I4444 VSS nfet_05v0 L=0.6U W=0.36U AS=0.0432P
+ AD=0.369P PS=0.6U PD=2.77U
* device instance _3683 r0 *1 655.065,798.49 pfet_05v0
XM_3683 n_I4454 n_I4449 n_I4450 VDD_DEC pfet_05v0 L=0.5U W=0.36U AS=0.3456P
+ AD=0.0612P PS=2.64U PD=0.7U
* device instance _3684 r0 *1 655.905,798.49 pfet_05v0
XM_3684 n_I4454 n_I4449 VDD_DEC VDD_DEC pfet_05v0 L=0.5U W=0.36U AS=0.379P
+ AD=0.0612P PS=2.37U PD=0.7U
* device instance _3685 r0 *1 657.555,798.17 pfet_05v0
XM_3685 n_I2177 n_I4450 VDD_DEC VDD_DEC pfet_05v0 L=0.5U W=1.22U AS=0.379P
+ AD=0.5368P PS=2.37U PD=3.32U
* device instance _3686 r0 *1 650.825,798.6 pfet_05v0
XM_3686 VDD_DEC n_I2139 n_I4448 VDD_DEC pfet_05v0 L=0.5U W=0.36U AS=0.3852P
+ AD=0.1116P PS=2.86U PD=0.98U
* device instance _3687 r0 *1 651.945,798.6 pfet_05v0
XM_3687 n_I4453 n_I4448 VDD_DEC VDD_DEC pfet_05v0 L=0.5U W=0.36U AS=0.1116P
+ AD=0.0612P PS=0.98U PD=0.7U
* device instance _3688 r0 *1 652.785,798.6 pfet_05v0
XM_3688 n_I4453 n_I4448 n_I4449 VDD_DEC pfet_05v0 L=0.5U W=0.36U AS=0.3852P
+ AD=0.0612P PS=2.86U PD=0.7U
* device instance _3689 r0 *1 655.115,795.722 nfet_05v0
XM_3689 n_I4452 n_I4449 n_I4450 VSS nfet_05v0 L=0.6U W=0.365U AS=0.3705P
+ AD=0.0438P PS=2.77U PD=0.605U
* device instance _3690 r0 *1 655.955,795.722 nfet_05v0
XM_3690 VSS n_I4449 n_I4452 VSS nfet_05v0 L=0.6U W=0.365U AS=0.0438P
+ AD=0.282625P PS=0.605U PD=1.87U
* device instance _3691 r0 *1 657.605,795.95 nfet_05v0
XM_3691 n_I2177 n_I4450 VSS VSS nfet_05v0 L=0.6U W=0.82U AS=0.282625P AD=0.3608P
+ PS=1.87U PD=2.52U
* device instance _3692 r0 *1 650.875,795.72 nfet_05v0
XM_3692 VSS n_I2139 n_I4448 VSS nfet_05v0 L=0.6U W=0.36U AS=0.333P AD=0.0936P
+ PS=2.57U PD=0.88U
* device instance _3693 r0 *1 651.995,795.72 nfet_05v0
XM_3693 n_I4451 n_I4448 VSS VSS nfet_05v0 L=0.6U W=0.36U AS=0.0936P AD=0.0432P
+ PS=0.88U PD=0.6U
* device instance _3694 r0 *1 652.835,795.72 nfet_05v0
XM_3694 n_I4449 n_I4448 n_I4451 VSS nfet_05v0 L=0.6U W=0.36U AS=0.0432P
+ AD=0.369P PS=0.6U PD=2.77U
* device instance _3695 r0 *1 646.105,798.49 pfet_05v0
XM_3695 n_I4461 n_I4456 n_I4457 VDD_DEC pfet_05v0 L=0.5U W=0.36U AS=0.3456P
+ AD=0.0612P PS=2.64U PD=0.7U
* device instance _3696 r0 *1 646.945,798.49 pfet_05v0
XM_3696 n_I4461 n_I4456 VDD_DEC VDD_DEC pfet_05v0 L=0.5U W=0.36U AS=0.379P
+ AD=0.0612P PS=2.37U PD=0.7U
* device instance _3697 r0 *1 648.595,798.17 pfet_05v0
XM_3697 n_I2178 n_I4457 VDD_DEC VDD_DEC pfet_05v0 L=0.5U W=1.22U AS=0.379P
+ AD=0.5368P PS=2.37U PD=3.32U
* device instance _3698 r0 *1 641.865,798.6 pfet_05v0
XM_3698 VDD_DEC n_I2242 n_I4455 VDD_DEC pfet_05v0 L=0.5U W=0.36U AS=0.3852P
+ AD=0.1116P PS=2.86U PD=0.98U
* device instance _3699 r0 *1 642.985,798.6 pfet_05v0
XM_3699 n_I4460 n_I4455 VDD_DEC VDD_DEC pfet_05v0 L=0.5U W=0.36U AS=0.1116P
+ AD=0.0612P PS=0.98U PD=0.7U
* device instance _3700 r0 *1 643.825,798.6 pfet_05v0
XM_3700 n_I4460 n_I4455 n_I4456 VDD_DEC pfet_05v0 L=0.5U W=0.36U AS=0.3852P
+ AD=0.0612P PS=2.86U PD=0.7U
* device instance _3701 r0 *1 646.155,795.722 nfet_05v0
XM_3701 n_I4459 n_I4456 n_I4457 VSS nfet_05v0 L=0.6U W=0.365U AS=0.3705P
+ AD=0.0438P PS=2.77U PD=0.605U
* device instance _3702 r0 *1 646.995,795.722 nfet_05v0
XM_3702 VSS n_I4456 n_I4459 VSS nfet_05v0 L=0.6U W=0.365U AS=0.0438P
+ AD=0.282625P PS=0.605U PD=1.87U
* device instance _3703 r0 *1 648.645,795.95 nfet_05v0
XM_3703 n_I2178 n_I4457 VSS VSS nfet_05v0 L=0.6U W=0.82U AS=0.282625P AD=0.3608P
+ PS=1.87U PD=2.52U
* device instance _3704 r0 *1 641.915,795.72 nfet_05v0
XM_3704 VSS n_I2242 n_I4455 VSS nfet_05v0 L=0.6U W=0.36U AS=0.333P AD=0.0936P
+ PS=2.57U PD=0.88U
* device instance _3705 r0 *1 643.035,795.72 nfet_05v0
XM_3705 n_I4458 n_I4455 VSS VSS nfet_05v0 L=0.6U W=0.36U AS=0.0936P AD=0.0432P
+ PS=0.88U PD=0.6U
* device instance _3706 r0 *1 643.875,795.72 nfet_05v0
XM_3706 n_I4456 n_I4455 n_I4458 VSS nfet_05v0 L=0.6U W=0.36U AS=0.0432P
+ AD=0.369P PS=0.6U PD=2.77U
* device instance _3707 r0 *1 525.705,790.65 pfet_05v0
XM_3707 n_I4468 n_I4463 n_I4464 VDD_DEC pfet_05v0 L=0.5U W=0.36U AS=0.3456P
+ AD=0.0612P PS=2.64U PD=0.7U
* device instance _3708 r0 *1 526.545,790.65 pfet_05v0
XM_3708 n_I4468 n_I4463 VDD_DEC VDD_DEC pfet_05v0 L=0.5U W=0.36U AS=0.379P
+ AD=0.0612P PS=2.37U PD=0.7U
* device instance _3709 r0 *1 528.195,790.33 pfet_05v0
XM_3709 n_172 n_I4464 VDD_DEC VDD_DEC pfet_05v0 L=0.5U W=1.22U AS=0.379P
+ AD=0.5368P PS=2.37U PD=3.32U
* device instance _3710 r0 *1 521.465,790.76 pfet_05v0
XM_3710 VDD_DEC n_I2161 n_I4462 VDD_DEC pfet_05v0 L=0.5U W=0.36U AS=0.3852P
+ AD=0.1116P PS=2.86U PD=0.98U
* device instance _3711 r0 *1 522.585,790.76 pfet_05v0
XM_3711 n_I4467 n_I4462 VDD_DEC VDD_DEC pfet_05v0 L=0.5U W=0.36U AS=0.1116P
+ AD=0.0612P PS=0.98U PD=0.7U
* device instance _3712 r0 *1 523.425,790.76 pfet_05v0
XM_3712 n_I4467 n_I4462 n_I4463 VDD_DEC pfet_05v0 L=0.5U W=0.36U AS=0.3852P
+ AD=0.0612P PS=2.86U PD=0.7U
* device instance _3713 r0 *1 525.755,787.882 nfet_05v0
XM_3713 n_I4466 n_I4463 n_I4464 VSS nfet_05v0 L=0.6U W=0.365U AS=0.3705P
+ AD=0.0438P PS=2.77U PD=0.605U
* device instance _3714 r0 *1 526.595,787.882 nfet_05v0
XM_3714 VSS n_I4463 n_I4466 VSS nfet_05v0 L=0.6U W=0.365U AS=0.0438P
+ AD=0.282625P PS=0.605U PD=1.87U
* device instance _3715 r0 *1 528.245,788.11 nfet_05v0
XM_3715 n_172 n_I4464 VSS VSS nfet_05v0 L=0.6U W=0.82U AS=0.282625P AD=0.3608P
+ PS=1.87U PD=2.52U
* device instance _3716 r0 *1 521.515,787.88 nfet_05v0
XM_3716 VSS n_I2161 n_I4462 VSS nfet_05v0 L=0.6U W=0.36U AS=0.333P AD=0.0936P
+ PS=2.57U PD=0.88U
* device instance _3717 r0 *1 522.635,787.88 nfet_05v0
XM_3717 n_I4465 n_I4462 VSS VSS nfet_05v0 L=0.6U W=0.36U AS=0.0936P AD=0.0432P
+ PS=0.88U PD=0.6U
* device instance _3718 r0 *1 523.475,787.88 nfet_05v0
XM_3718 n_I4463 n_I4462 n_I4465 VSS nfet_05v0 L=0.6U W=0.36U AS=0.0432P
+ AD=0.369P PS=0.6U PD=2.77U
* device instance _3719 r0 *1 502.745,790.65 pfet_05v0
XM_3719 n_I4475 n_I4470 n_I4471 VDD_DEC pfet_05v0 L=0.5U W=0.36U AS=0.3456P
+ AD=0.0612P PS=2.64U PD=0.7U
* device instance _3720 r0 *1 503.585,790.65 pfet_05v0
XM_3720 n_I4475 n_I4470 VDD_DEC VDD_DEC pfet_05v0 L=0.5U W=0.36U AS=0.379P
+ AD=0.0612P PS=2.37U PD=0.7U
* device instance _3721 r0 *1 505.235,790.33 pfet_05v0
XM_3721 n_272 n_I4471 VDD_DEC VDD_DEC pfet_05v0 L=0.5U W=1.22U AS=0.379P
+ AD=0.5368P PS=2.37U PD=3.32U
* device instance _3722 r0 *1 498.505,790.76 pfet_05v0
XM_3722 VDD_DEC n_I2249 n_I4469 VDD_DEC pfet_05v0 L=0.5U W=0.36U AS=0.3852P
+ AD=0.1116P PS=2.86U PD=0.98U
* device instance _3723 r0 *1 499.625,790.76 pfet_05v0
XM_3723 n_I4474 n_I4469 VDD_DEC VDD_DEC pfet_05v0 L=0.5U W=0.36U AS=0.1116P
+ AD=0.0612P PS=0.98U PD=0.7U
* device instance _3724 r0 *1 500.465,790.76 pfet_05v0
XM_3724 n_I4474 n_I4469 n_I4470 VDD_DEC pfet_05v0 L=0.5U W=0.36U AS=0.3852P
+ AD=0.0612P PS=2.86U PD=0.7U
* device instance _3725 r0 *1 502.795,787.882 nfet_05v0
XM_3725 n_I4473 n_I4470 n_I4471 VSS nfet_05v0 L=0.6U W=0.365U AS=0.3705P
+ AD=0.0438P PS=2.77U PD=0.605U
* device instance _3726 r0 *1 503.635,787.882 nfet_05v0
XM_3726 VSS n_I4470 n_I4473 VSS nfet_05v0 L=0.6U W=0.365U AS=0.0438P
+ AD=0.282625P PS=0.605U PD=1.87U
* device instance _3727 r0 *1 505.285,788.11 nfet_05v0
XM_3727 n_272 n_I4471 VSS VSS nfet_05v0 L=0.6U W=0.82U AS=0.282625P AD=0.3608P
+ PS=1.87U PD=2.52U
* device instance _3728 r0 *1 498.555,787.88 nfet_05v0
XM_3728 VSS n_I2249 n_I4469 VSS nfet_05v0 L=0.6U W=0.36U AS=0.333P AD=0.0936P
+ PS=2.57U PD=0.88U
* device instance _3729 r0 *1 499.675,787.88 nfet_05v0
XM_3729 n_I4472 n_I4469 VSS VSS nfet_05v0 L=0.6U W=0.36U AS=0.0936P AD=0.0432P
+ PS=0.88U PD=0.6U
* device instance _3730 r0 *1 500.515,787.88 nfet_05v0
XM_3730 n_I4470 n_I4469 n_I4472 VSS nfet_05v0 L=0.6U W=0.36U AS=0.0432P
+ AD=0.369P PS=0.6U PD=2.77U
* device instance _3731 r0 *1 617.545,814.17 pfet_05v0
XM_3731 n_I4482 n_I4477 n_I4478 VDD_DEC pfet_05v0 L=0.5U W=0.36U AS=0.3456P
+ AD=0.0612P PS=2.64U PD=0.7U
* device instance _3732 r0 *1 618.385,814.17 pfet_05v0
XM_3732 n_I4482 n_I4477 VDD_DEC VDD_DEC pfet_05v0 L=0.5U W=0.36U AS=0.379P
+ AD=0.0612P PS=2.37U PD=0.7U
* device instance _3733 r0 *1 620.035,813.85 pfet_05v0
XM_3733 n_I2287 n_I4478 VDD_DEC VDD_DEC pfet_05v0 L=0.5U W=1.22U AS=0.379P
+ AD=0.5368P PS=2.37U PD=3.32U
* device instance _3734 r0 *1 613.305,814.28 pfet_05v0
XM_3734 VDD_DEC n_I2341 n_I4476 VDD_DEC pfet_05v0 L=0.5U W=0.36U AS=0.3852P
+ AD=0.1116P PS=2.86U PD=0.98U
* device instance _3735 r0 *1 614.425,814.28 pfet_05v0
XM_3735 n_I4481 n_I4476 VDD_DEC VDD_DEC pfet_05v0 L=0.5U W=0.36U AS=0.1116P
+ AD=0.0612P PS=0.98U PD=0.7U
* device instance _3736 r0 *1 615.265,814.28 pfet_05v0
XM_3736 n_I4481 n_I4476 n_I4477 VDD_DEC pfet_05v0 L=0.5U W=0.36U AS=0.3852P
+ AD=0.0612P PS=2.86U PD=0.7U
* device instance _3737 r0 *1 617.595,811.402 nfet_05v0
XM_3737 n_I4480 n_I4477 n_I4478 VSS nfet_05v0 L=0.6U W=0.365U AS=0.3705P
+ AD=0.0438P PS=2.77U PD=0.605U
* device instance _3738 r0 *1 618.435,811.402 nfet_05v0
XM_3738 VSS n_I4477 n_I4480 VSS nfet_05v0 L=0.6U W=0.365U AS=0.0438P
+ AD=0.282625P PS=0.605U PD=1.87U
* device instance _3739 r0 *1 620.085,811.63 nfet_05v0
XM_3739 n_I2287 n_I4478 VSS VSS nfet_05v0 L=0.6U W=0.82U AS=0.282625P AD=0.3608P
+ PS=1.87U PD=2.52U
* device instance _3740 r0 *1 613.355,811.4 nfet_05v0
XM_3740 VSS n_I2341 n_I4476 VSS nfet_05v0 L=0.6U W=0.36U AS=0.333P AD=0.0936P
+ PS=2.57U PD=0.88U
* device instance _3741 r0 *1 614.475,811.4 nfet_05v0
XM_3741 n_I4479 n_I4476 VSS VSS nfet_05v0 L=0.6U W=0.36U AS=0.0936P AD=0.0432P
+ PS=0.88U PD=0.6U
* device instance _3742 r0 *1 615.315,811.4 nfet_05v0
XM_3742 n_I4477 n_I4476 n_I4479 VSS nfet_05v0 L=0.6U W=0.36U AS=0.0432P
+ AD=0.369P PS=0.6U PD=2.77U
* device instance _3743 r0 *1 502.745,782.81 pfet_05v0
XM_3743 n_I4489 n_I4484 n_I4485 VDD_DEC pfet_05v0 L=0.5U W=0.36U AS=0.3456P
+ AD=0.0612P PS=2.64U PD=0.7U
* device instance _3744 r0 *1 503.585,782.81 pfet_05v0
XM_3744 n_I4489 n_I4484 VDD_DEC VDD_DEC pfet_05v0 L=0.5U W=0.36U AS=0.379P
+ AD=0.0612P PS=2.37U PD=0.7U
* device instance _3745 r0 *1 505.235,782.49 pfet_05v0
XM_3745 n_277 n_I4485 VDD_DEC VDD_DEC pfet_05v0 L=0.5U W=1.22U AS=0.379P
+ AD=0.5368P PS=2.37U PD=3.32U
* device instance _3746 r0 *1 498.505,782.92 pfet_05v0
XM_3746 VDD_DEC n_I2124 n_I4483 VDD_DEC pfet_05v0 L=0.5U W=0.36U AS=0.3852P
+ AD=0.1116P PS=2.86U PD=0.98U
* device instance _3747 r0 *1 499.625,782.92 pfet_05v0
XM_3747 n_I4488 n_I4483 VDD_DEC VDD_DEC pfet_05v0 L=0.5U W=0.36U AS=0.1116P
+ AD=0.0612P PS=0.98U PD=0.7U
* device instance _3748 r0 *1 500.465,782.92 pfet_05v0
XM_3748 n_I4488 n_I4483 n_I4484 VDD_DEC pfet_05v0 L=0.5U W=0.36U AS=0.3852P
+ AD=0.0612P PS=2.86U PD=0.7U
* device instance _3749 r0 *1 502.795,780.042 nfet_05v0
XM_3749 n_I4487 n_I4484 n_I4485 VSS nfet_05v0 L=0.6U W=0.365U AS=0.3705P
+ AD=0.0438P PS=2.77U PD=0.605U
* device instance _3750 r0 *1 503.635,780.042 nfet_05v0
XM_3750 VSS n_I4484 n_I4487 VSS nfet_05v0 L=0.6U W=0.365U AS=0.0438P
+ AD=0.282625P PS=0.605U PD=1.87U
* device instance _3751 r0 *1 505.285,780.27 nfet_05v0
XM_3751 n_277 n_I4485 VSS VSS nfet_05v0 L=0.6U W=0.82U AS=0.282625P AD=0.3608P
+ PS=1.87U PD=2.52U
* device instance _3752 r0 *1 498.555,780.04 nfet_05v0
XM_3752 VSS n_I2124 n_I4483 VSS nfet_05v0 L=0.6U W=0.36U AS=0.333P AD=0.0936P
+ PS=2.57U PD=0.88U
* device instance _3753 r0 *1 499.675,780.04 nfet_05v0
XM_3753 n_I4486 n_I4483 VSS VSS nfet_05v0 L=0.6U W=0.36U AS=0.0936P AD=0.0432P
+ PS=0.88U PD=0.6U
* device instance _3754 r0 *1 500.515,780.04 nfet_05v0
XM_3754 n_I4484 n_I4483 n_I4486 VSS nfet_05v0 L=0.6U W=0.36U AS=0.0432P
+ AD=0.369P PS=0.6U PD=2.77U
* device instance _3755 r0 *1 512.265,774.97 pfet_05v0
XM_3755 n_I4496 n_I4491 n_I4492 VDD_DEC pfet_05v0 L=0.5U W=0.36U AS=0.3456P
+ AD=0.0612P PS=2.64U PD=0.7U
* device instance _3756 r0 *1 513.105,774.97 pfet_05v0
XM_3756 n_I4496 n_I4491 VDD_DEC VDD_DEC pfet_05v0 L=0.5U W=0.36U AS=0.379P
+ AD=0.0612P PS=2.37U PD=0.7U
* device instance _3757 r0 *1 514.755,774.65 pfet_05v0
XM_3757 n_181 n_I4492 VDD_DEC VDD_DEC pfet_05v0 L=0.5U W=1.22U AS=0.379P
+ AD=0.5368P PS=2.37U PD=3.32U
* device instance _3758 r0 *1 508.025,775.08 pfet_05v0
XM_3758 VDD_DEC n_I2021 n_I4490 VDD_DEC pfet_05v0 L=0.5U W=0.36U AS=0.3852P
+ AD=0.1116P PS=2.86U PD=0.98U
* device instance _3759 r0 *1 509.145,775.08 pfet_05v0
XM_3759 n_I4495 n_I4490 VDD_DEC VDD_DEC pfet_05v0 L=0.5U W=0.36U AS=0.1116P
+ AD=0.0612P PS=0.98U PD=0.7U
* device instance _3760 r0 *1 509.985,775.08 pfet_05v0
XM_3760 n_I4495 n_I4490 n_I4491 VDD_DEC pfet_05v0 L=0.5U W=0.36U AS=0.3852P
+ AD=0.0612P PS=2.86U PD=0.7U
* device instance _3761 r0 *1 512.315,772.202 nfet_05v0
XM_3761 n_I4494 n_I4491 n_I4492 VSS nfet_05v0 L=0.6U W=0.365U AS=0.3705P
+ AD=0.0438P PS=2.77U PD=0.605U
* device instance _3762 r0 *1 513.155,772.202 nfet_05v0
XM_3762 VSS n_I4491 n_I4494 VSS nfet_05v0 L=0.6U W=0.365U AS=0.0438P
+ AD=0.282625P PS=0.605U PD=1.87U
* device instance _3763 r0 *1 514.805,772.43 nfet_05v0
XM_3763 n_181 n_I4492 VSS VSS nfet_05v0 L=0.6U W=0.82U AS=0.282625P AD=0.3608P
+ PS=1.87U PD=2.52U
* device instance _3764 r0 *1 508.075,772.2 nfet_05v0
XM_3764 VSS n_I2021 n_I4490 VSS nfet_05v0 L=0.6U W=0.36U AS=0.333P AD=0.0936P
+ PS=2.57U PD=0.88U
* device instance _3765 r0 *1 509.195,772.2 nfet_05v0
XM_3765 n_I4493 n_I4490 VSS VSS nfet_05v0 L=0.6U W=0.36U AS=0.0936P AD=0.0432P
+ PS=0.88U PD=0.6U
* device instance _3766 r0 *1 510.035,772.2 nfet_05v0
XM_3766 n_I4491 n_I4490 n_I4493 VSS nfet_05v0 L=0.6U W=0.36U AS=0.0432P
+ AD=0.369P PS=0.6U PD=2.77U
* device instance _3767 r0 *1 515.065,782.81 pfet_05v0
XM_3767 n_I4503 n_I4498 n_I4499 VDD_DEC pfet_05v0 L=0.5U W=0.36U AS=0.3456P
+ AD=0.0612P PS=2.64U PD=0.7U
* device instance _3768 r0 *1 515.905,782.81 pfet_05v0
XM_3768 n_I4503 n_I4498 VDD_DEC VDD_DEC pfet_05v0 L=0.5U W=0.36U AS=0.379P
+ AD=0.0612P PS=2.37U PD=0.7U
* device instance _3769 r0 *1 517.555,782.49 pfet_05v0
XM_3769 n_160 n_I4499 VDD_DEC VDD_DEC pfet_05v0 L=0.5U W=1.22U AS=0.379P
+ AD=0.5368P PS=2.37U PD=3.32U
* device instance _3770 r0 *1 510.825,782.92 pfet_05v0
XM_3770 VDD_DEC n_I2055 n_I4497 VDD_DEC pfet_05v0 L=0.5U W=0.36U AS=0.3852P
+ AD=0.1116P PS=2.86U PD=0.98U
* device instance _3771 r0 *1 511.945,782.92 pfet_05v0
XM_3771 n_I4502 n_I4497 VDD_DEC VDD_DEC pfet_05v0 L=0.5U W=0.36U AS=0.1116P
+ AD=0.0612P PS=0.98U PD=0.7U
* device instance _3772 r0 *1 512.785,782.92 pfet_05v0
XM_3772 n_I4502 n_I4497 n_I4498 VDD_DEC pfet_05v0 L=0.5U W=0.36U AS=0.3852P
+ AD=0.0612P PS=2.86U PD=0.7U
* device instance _3773 r0 *1 515.115,780.042 nfet_05v0
XM_3773 n_I4501 n_I4498 n_I4499 VSS nfet_05v0 L=0.6U W=0.365U AS=0.3705P
+ AD=0.0438P PS=2.77U PD=0.605U
* device instance _3774 r0 *1 515.955,780.042 nfet_05v0
XM_3774 VSS n_I4498 n_I4501 VSS nfet_05v0 L=0.6U W=0.365U AS=0.0438P
+ AD=0.282625P PS=0.605U PD=1.87U
* device instance _3775 r0 *1 517.605,780.27 nfet_05v0
XM_3775 n_160 n_I4499 VSS VSS nfet_05v0 L=0.6U W=0.82U AS=0.282625P AD=0.3608P
+ PS=1.87U PD=2.52U
* device instance _3776 r0 *1 510.875,780.04 nfet_05v0
XM_3776 VSS n_I2055 n_I4497 VSS nfet_05v0 L=0.6U W=0.36U AS=0.333P AD=0.0936P
+ PS=2.57U PD=0.88U
* device instance _3777 r0 *1 511.995,780.04 nfet_05v0
XM_3777 n_I4500 n_I4497 VSS VSS nfet_05v0 L=0.6U W=0.36U AS=0.0936P AD=0.0432P
+ PS=0.88U PD=0.6U
* device instance _3778 r0 *1 512.835,780.04 nfet_05v0
XM_3778 n_I4498 n_I4497 n_I4500 VSS nfet_05v0 L=0.6U W=0.36U AS=0.0432P
+ AD=0.369P PS=0.6U PD=2.77U
* device instance _3779 r0 *1 502.185,774.97 pfet_05v0
XM_3779 n_I4510 n_I4505 n_I4506 VDD_DEC pfet_05v0 L=0.5U W=0.36U AS=0.3456P
+ AD=0.0612P PS=2.64U PD=0.7U
* device instance _3780 r0 *1 503.025,774.97 pfet_05v0
XM_3780 n_I4510 n_I4505 VDD_DEC VDD_DEC pfet_05v0 L=0.5U W=0.36U AS=0.379P
+ AD=0.0612P PS=2.37U PD=0.7U
* device instance _3781 r0 *1 504.675,774.65 pfet_05v0
XM_3781 n_154 n_I4506 VDD_DEC VDD_DEC pfet_05v0 L=0.5U W=1.22U AS=0.379P
+ AD=0.5368P PS=2.37U PD=3.32U
* device instance _3782 r0 *1 497.945,775.08 pfet_05v0
XM_3782 VDD_DEC n_I2020 n_I4504 VDD_DEC pfet_05v0 L=0.5U W=0.36U AS=0.3852P
+ AD=0.1116P PS=2.86U PD=0.98U
* device instance _3783 r0 *1 499.065,775.08 pfet_05v0
XM_3783 n_I4509 n_I4504 VDD_DEC VDD_DEC pfet_05v0 L=0.5U W=0.36U AS=0.1116P
+ AD=0.0612P PS=0.98U PD=0.7U
* device instance _3784 r0 *1 499.905,775.08 pfet_05v0
XM_3784 n_I4509 n_I4504 n_I4505 VDD_DEC pfet_05v0 L=0.5U W=0.36U AS=0.3852P
+ AD=0.0612P PS=2.86U PD=0.7U
* device instance _3785 r0 *1 502.235,772.202 nfet_05v0
XM_3785 n_I4508 n_I4505 n_I4506 VSS nfet_05v0 L=0.6U W=0.365U AS=0.3705P
+ AD=0.0438P PS=2.77U PD=0.605U
* device instance _3786 r0 *1 503.075,772.202 nfet_05v0
XM_3786 VSS n_I4505 n_I4508 VSS nfet_05v0 L=0.6U W=0.365U AS=0.0438P
+ AD=0.282625P PS=0.605U PD=1.87U
* device instance _3787 r0 *1 504.725,772.43 nfet_05v0
XM_3787 n_154 n_I4506 VSS VSS nfet_05v0 L=0.6U W=0.82U AS=0.282625P AD=0.3608P
+ PS=1.87U PD=2.52U
* device instance _3788 r0 *1 497.995,772.2 nfet_05v0
XM_3788 VSS n_I2020 n_I4504 VSS nfet_05v0 L=0.6U W=0.36U AS=0.333P AD=0.0936P
+ PS=2.57U PD=0.88U
* device instance _3789 r0 *1 499.115,772.2 nfet_05v0
XM_3789 n_I4507 n_I4504 VSS VSS nfet_05v0 L=0.6U W=0.36U AS=0.0936P AD=0.0432P
+ PS=0.88U PD=0.6U
* device instance _3790 r0 *1 499.955,772.2 nfet_05v0
XM_3790 n_I4505 n_I4504 n_I4507 VSS nfet_05v0 L=0.6U W=0.36U AS=0.0432P
+ AD=0.369P PS=0.6U PD=2.77U
* device instance _3791 r0 *1 550.345,774.97 pfet_05v0
XM_3791 n_I4517 n_I4512 n_I4513 VDD_DEC pfet_05v0 L=0.5U W=0.36U AS=0.3456P
+ AD=0.0612P PS=2.64U PD=0.7U
* device instance _3792 r0 *1 551.185,774.97 pfet_05v0
XM_3792 n_I4517 n_I4512 VDD_DEC VDD_DEC pfet_05v0 L=0.5U W=0.36U AS=0.379P
+ AD=0.0612P PS=2.37U PD=0.7U
* device instance _3793 r0 *1 552.835,774.65 pfet_05v0
XM_3793 n_162 n_I4513 VDD_DEC VDD_DEC pfet_05v0 L=0.5U W=1.22U AS=0.379P
+ AD=0.5368P PS=2.37U PD=3.32U
* device instance _3794 r0 *1 546.105,775.08 pfet_05v0
XM_3794 VDD_DEC n_I2025 n_I4511 VDD_DEC pfet_05v0 L=0.5U W=0.36U AS=0.3852P
+ AD=0.1116P PS=2.86U PD=0.98U
* device instance _3795 r0 *1 547.225,775.08 pfet_05v0
XM_3795 n_I4516 n_I4511 VDD_DEC VDD_DEC pfet_05v0 L=0.5U W=0.36U AS=0.1116P
+ AD=0.0612P PS=0.98U PD=0.7U
* device instance _3796 r0 *1 548.065,775.08 pfet_05v0
XM_3796 n_I4516 n_I4511 n_I4512 VDD_DEC pfet_05v0 L=0.5U W=0.36U AS=0.3852P
+ AD=0.0612P PS=2.86U PD=0.7U
* device instance _3797 r0 *1 550.395,772.202 nfet_05v0
XM_3797 n_I4515 n_I4512 n_I4513 VSS nfet_05v0 L=0.6U W=0.365U AS=0.3705P
+ AD=0.0438P PS=2.77U PD=0.605U
* device instance _3798 r0 *1 551.235,772.202 nfet_05v0
XM_3798 VSS n_I4512 n_I4515 VSS nfet_05v0 L=0.6U W=0.365U AS=0.0438P
+ AD=0.282625P PS=0.605U PD=1.87U
* device instance _3799 r0 *1 552.885,772.43 nfet_05v0
XM_3799 n_162 n_I4513 VSS VSS nfet_05v0 L=0.6U W=0.82U AS=0.282625P AD=0.3608P
+ PS=1.87U PD=2.52U
* device instance _3800 r0 *1 546.155,772.2 nfet_05v0
XM_3800 VSS n_I2025 n_I4511 VSS nfet_05v0 L=0.6U W=0.36U AS=0.333P AD=0.0936P
+ PS=2.57U PD=0.88U
* device instance _3801 r0 *1 547.275,772.2 nfet_05v0
XM_3801 n_I4514 n_I4511 VSS VSS nfet_05v0 L=0.6U W=0.36U AS=0.0936P AD=0.0432P
+ PS=0.88U PD=0.6U
* device instance _3802 r0 *1 548.115,772.2 nfet_05v0
XM_3802 n_I4512 n_I4511 n_I4514 VSS nfet_05v0 L=0.6U W=0.36U AS=0.0432P
+ AD=0.369P PS=0.6U PD=2.77U
* device instance _3803 r0 *1 613.625,837.69 pfet_05v0
XM_3803 n_I4524 n_I4519 n_I4520 VDD_DEC pfet_05v0 L=0.5U W=0.36U AS=0.3456P
+ AD=0.0612P PS=2.64U PD=0.7U
* device instance _3804 r0 *1 614.465,837.69 pfet_05v0
XM_3804 n_I4524 n_I4519 VDD_DEC VDD_DEC pfet_05v0 L=0.5U W=0.36U AS=0.379P
+ AD=0.0612P PS=2.37U PD=0.7U
* device instance _3805 r0 *1 616.115,837.37 pfet_05v0
XM_3805 n_I2401 n_I4520 VDD_DEC VDD_DEC pfet_05v0 L=0.5U W=1.22U AS=0.379P
+ AD=0.5368P PS=2.37U PD=3.32U
* device instance _3806 r0 *1 609.385,837.8 pfet_05v0
XM_3806 VDD_DEC D[4] n_I4518 VDD_DEC pfet_05v0 L=0.5U W=0.36U AS=0.3852P
+ AD=0.1116P PS=2.86U PD=0.98U
* device instance _3807 r0 *1 610.505,837.8 pfet_05v0
XM_3807 n_I4523 n_I4518 VDD_DEC VDD_DEC pfet_05v0 L=0.5U W=0.36U AS=0.1116P
+ AD=0.0612P PS=0.98U PD=0.7U
* device instance _3808 r0 *1 611.345,837.8 pfet_05v0
XM_3808 n_I4523 n_I4518 n_I4519 VDD_DEC pfet_05v0 L=0.5U W=0.36U AS=0.3852P
+ AD=0.0612P PS=2.86U PD=0.7U
* device instance _3809 r0 *1 613.675,834.922 nfet_05v0
XM_3809 n_I4522 n_I4519 n_I4520 VSS nfet_05v0 L=0.6U W=0.365U AS=0.3705P
+ AD=0.0438P PS=2.77U PD=0.605U
* device instance _3810 r0 *1 614.515,834.922 nfet_05v0
XM_3810 VSS n_I4519 n_I4522 VSS nfet_05v0 L=0.6U W=0.365U AS=0.0438P
+ AD=0.282625P PS=0.605U PD=1.87U
* device instance _3811 r0 *1 616.165,835.15 nfet_05v0
XM_3811 n_I2401 n_I4520 VSS VSS nfet_05v0 L=0.6U W=0.82U AS=0.282625P AD=0.3608P
+ PS=1.87U PD=2.52U
* device instance _3812 r0 *1 609.435,834.92 nfet_05v0
XM_3812 VSS D[4] n_I4518 VSS nfet_05v0 L=0.6U W=0.36U AS=0.333P AD=0.0936P
+ PS=2.57U PD=0.88U
* device instance _3813 r0 *1 610.555,834.92 nfet_05v0
XM_3813 n_I4521 n_I4518 VSS VSS nfet_05v0 L=0.6U W=0.36U AS=0.0936P AD=0.0432P
+ PS=0.88U PD=0.6U
* device instance _3814 r0 *1 611.395,834.92 nfet_05v0
XM_3814 n_I4519 n_I4518 n_I4521 VSS nfet_05v0 L=0.6U W=0.36U AS=0.0432P
+ AD=0.369P PS=0.6U PD=2.77U
* device instance _3815 r180 *1 79.345,833.6 pfet_05v0
XM_3815 VDD_DEC VCO_EN n_I2440 VDD_DEC pfet_05v0 L=0.5U W=2U AS=1.54P AD=1.54P
+ PS=5.54U PD=5.54U
* device instance _3816 r90 *1 86.37,830.525 nfet_05v0
XM_3816 n_5 VCO_EN n_I2011 VSS nfet_05v0 L=0.6U W=2U AS=1.46P AD=1.46P PS=5.46U
+ PD=5.46U
* device instance _3817 r90 *1 82.86,830.495 pfet_05v0
XM_3817 n_5 n_I2440 n_I2011 VDD_DEC pfet_05v0 L=0.5U W=6U AS=3.14P AD=3.14P
+ PS=11.14U PD=11.14U
* device instance _3820 r0 *1 86.4,834.52 nfet_05v0
XM_3820 VSS VCO_EN n_I2440 VSS nfet_05v0 L=0.6U W=1U AS=0.73P AD=0.73P PS=3.46U
+ PD=3.46U
* device instance _3821 r0 *1 76.66,829.04 diode_nw2ps_06v0
D_3821 VSS VCO_EN diode_nw2ps_06v0 area=1.728P pj=12.48U
* device instance _3822 r0 *1 86.4,832.605 nfet_05v0
XM_3822 VSS n_I2440 n_I2011 VSS nfet_05v0 L=0.6U W=0.42U AS=0.315P AD=0.315P
+ PS=2.34U PD=2.34U
* device instance _3824 r0 *1 190.72,834.52 nfet_05v0
XM_3824 VSS VCO_EN n_I2441 VSS nfet_05v0 L=0.6U W=1U AS=0.73P AD=0.73P PS=3.46U
+ PD=3.46U
* device instance _3825 r90 *1 187.18,830.495 pfet_05v0
XM_3825 n_I2010 n_I2441 n_4 VDD_DEC pfet_05v0 L=0.5U W=6U AS=3.14P AD=3.14P
+ PS=11.14U PD=11.14U
* device instance _3828 r90 *1 190.69,830.525 nfet_05v0
XM_3828 n_I2010 VCO_EN n_4 VSS nfet_05v0 L=0.6U W=2U AS=1.46P AD=1.46P PS=5.46U
+ PD=5.46U
* device instance _3829 r180 *1 183.665,833.6 pfet_05v0
XM_3829 VDD_DEC VCO_EN n_I2441 VDD_DEC pfet_05v0 L=0.5U W=2U AS=1.54P AD=1.54P
+ PS=5.54U PD=5.54U
* device instance _3830 r180 *1 91.67,833.6 pfet_05v0
XM_3830 VDD_DEC VCO_EN n_I2442 VDD_DEC pfet_05v0 L=0.5U W=2U AS=1.54P AD=1.54P
+ PS=5.54U PD=5.54U
* device instance _3831 r90 *1 98.695,830.525 nfet_05v0
XM_3831 n_5 n_I2442 OUT VSS nfet_05v0 L=0.6U W=2U AS=1.46P AD=1.46P PS=5.46U
+ PD=5.46U
* device instance _3832 r90 *1 95.185,830.495 pfet_05v0
XM_3832 n_5 VCO_EN OUT VDD_DEC pfet_05v0 L=0.5U W=6U AS=3.14P AD=3.14P PS=11.14U
+ PD=11.14U
* device instance _3835 r0 *1 98.725,834.52 nfet_05v0
XM_3835 VSS VCO_EN n_I2442 VSS nfet_05v0 L=0.6U W=1U AS=0.73P AD=0.73P PS=3.46U
+ PD=3.46U
* device instance _3837 r180 *1 171.34,833.6 pfet_05v0
XM_3837 VDD_DEC VCO_EN n_I2443 VDD_DEC pfet_05v0 L=0.5U W=2U AS=1.54P AD=1.54P
+ PS=5.54U PD=5.54U
* device instance _3838 r90 *1 178.365,830.525 nfet_05v0
XM_3838 IN n_I2443 n_4 VSS nfet_05v0 L=0.6U W=2U AS=1.46P AD=1.46P PS=5.46U
+ PD=5.46U
* device instance _3839 r90 *1 174.855,830.495 pfet_05v0
XM_3839 IN VCO_EN n_4 VDD_DEC pfet_05v0 L=0.5U W=6U AS=3.14P AD=3.14P PS=11.14U
+ PD=11.14U
* device instance _3842 r0 *1 178.395,834.52 nfet_05v0
XM_3842 VSS VCO_EN n_I2443 VSS nfet_05v0 L=0.6U W=1U AS=0.73P AD=0.73P PS=3.46U
+ PD=3.46U
* device instance _3844 r0 *1 123.95,843.775 nfet_05v0
XM_3844 VSS n_I2444 FOUT VSS nfet_05v0 L=0.6U W=4U AS=1.93P AD=1.93P PS=8.86U
+ PD=8.86U
* device instance _3848 r0 *1 124.28,849.335 pfet_05v0
XM_3848 VDD_INV n_I2444 FOUT VDD_INV pfet_05v0 L=0.5U W=8U AS=3.94P AD=3.94P
+ PS=13.94U PD=13.94U
* device instance _3852 m90 *1 121.225,843.775 nfet_05v0
XM_3852 VSS n_I2015 n_I2444 VSS nfet_05v0 L=0.6U W=1U AS=0.73P AD=0.73P PS=3.46U
+ PD=3.46U
* device instance _3853 m90 *1 121.225,849.335 pfet_05v0
XM_3853 VDD_INV n_I2015 n_I2444 VDD_INV pfet_05v0 L=0.5U W=2U AS=1.54P AD=1.54P
+ PS=5.54U PD=5.54U
* device instance _3854 r180 *1 51.51,39.02 pfet_05v0
XM_3854 VDD_DEC n_6 n_I4525 VDD_DEC pfet_05v0 L=0.5U W=2U AS=1.54P AD=1.54P
+ PS=5.54U PD=5.54U
* device instance _3855 r180 *1 251.51,585.02 pfet_05v0
XM_3855 VDD_DEC n_270 n_I4526 VDD_DEC pfet_05v0 L=0.5U W=2U AS=1.54P AD=1.54P
+ PS=5.54U PD=5.54U
* device instance _3856 r180 *1 531.51,39.02 pfet_05v0
XM_3856 VDD_DEC n_18 n_I4527 VDD_DEC pfet_05v0 L=0.5U W=2U AS=1.54P AD=1.54P
+ PS=5.54U PD=5.54U
* device instance _3857 r180 *1 171.51,117.02 pfet_05v0
XM_3857 VDD_DEC n_28 n_I4528 VDD_DEC pfet_05v0 L=0.5U W=2U AS=1.54P AD=1.54P
+ PS=5.54U PD=5.54U
* device instance _3858 r180 *1 211.51,429.02 pfet_05v0
XM_3858 VDD_DEC n_158 n_I4529 VDD_DEC pfet_05v0 L=0.5U W=2U AS=1.54P AD=1.54P
+ PS=5.54U PD=5.54U
* device instance _3859 r180 *1 171.51,39.02 pfet_05v0
XM_3859 VDD_DEC n_9 n_I4530 VDD_DEC pfet_05v0 L=0.5U W=2U AS=1.54P AD=1.54P
+ PS=5.54U PD=5.54U
* device instance _3860 r180 *1 291.51,585.02 pfet_05v0
XM_3860 VDD_DEC n_271 n_I4531 VDD_DEC pfet_05v0 L=0.5U W=2U AS=1.54P AD=1.54P
+ PS=5.54U PD=5.54U
* device instance _3861 r180 *1 91.51,585.02 pfet_05v0
XM_3861 VDD_DEC n_266 n_I4532 VDD_DEC pfet_05v0 L=0.5U W=2U AS=1.54P AD=1.54P
+ PS=5.54U PD=5.54U
* device instance _3862 r180 *1 251.51,351.02 pfet_05v0
XM_3862 VDD_DEC n_162 n_I4533 VDD_DEC pfet_05v0 L=0.5U W=2U AS=1.54P AD=1.54P
+ PS=5.54U PD=5.54U
* device instance _3863 r180 *1 611.51,39.02 pfet_05v0
XM_3863 VDD_DEC n_20 n_I4534 VDD_DEC pfet_05v0 L=0.5U W=2U AS=1.54P AD=1.54P
+ PS=5.54U PD=5.54U
* device instance _3864 r180 *1 171.51,429.02 pfet_05v0
XM_3864 VDD_DEC n_155 n_I4535 VDD_DEC pfet_05v0 L=0.5U W=2U AS=1.54P AD=1.54P
+ PS=5.54U PD=5.54U
* device instance _3865 r180 *1 451.51,117.02 pfet_05v0
XM_3865 VDD_DEC n_35 n_I4536 VDD_DEC pfet_05v0 L=0.5U W=2U AS=1.54P AD=1.54P
+ PS=5.54U PD=5.54U
* device instance _3866 r180 *1 491.51,117.02 pfet_05v0
XM_3866 VDD_DEC n_36 n_I4537 VDD_DEC pfet_05v0 L=0.5U W=2U AS=1.54P AD=1.54P
+ PS=5.54U PD=5.54U
* device instance _3867 r180 *1 611.51,195.02 pfet_05v0
XM_3867 VDD_DEC n_111 n_I4538 VDD_DEC pfet_05v0 L=0.5U W=2U AS=1.54P AD=1.54P
+ PS=5.54U PD=5.54U
* device instance _3868 r180 *1 651.51,195.02 pfet_05v0
XM_3868 VDD_DEC n_113 n_I4539 VDD_DEC pfet_05v0 L=0.5U W=2U AS=1.54P AD=1.54P
+ PS=5.54U PD=5.54U
* device instance _3869 r180 *1 531.51,195.02 pfet_05v0
XM_3869 VDD_DEC n_107 n_I4540 VDD_DEC pfet_05v0 L=0.5U W=2U AS=1.54P AD=1.54P
+ PS=5.54U PD=5.54U
* device instance _3870 r180 *1 571.51,195.02 pfet_05v0
XM_3870 VDD_DEC n_109 n_I4541 VDD_DEC pfet_05v0 L=0.5U W=2U AS=1.54P AD=1.54P
+ PS=5.54U PD=5.54U
* device instance _3871 r180 *1 531.51,117.02 pfet_05v0
XM_3871 VDD_DEC n_37 n_I4542 VDD_DEC pfet_05v0 L=0.5U W=2U AS=1.54P AD=1.54P
+ PS=5.54U PD=5.54U
* device instance _3872 r180 *1 571.51,117.02 pfet_05v0
XM_3872 VDD_DEC n_38 n_I4543 VDD_DEC pfet_05v0 L=0.5U W=2U AS=1.54P AD=1.54P
+ PS=5.54U PD=5.54U
* device instance _3873 r180 *1 91.51,351.02 pfet_05v0
XM_3873 VDD_DEC n_150 n_I4544 VDD_DEC pfet_05v0 L=0.5U W=2U AS=1.54P AD=1.54P
+ PS=5.54U PD=5.54U
* device instance _3874 r180 *1 571.51,39.02 pfet_05v0
XM_3874 VDD_DEC n_19 n_I4545 VDD_DEC pfet_05v0 L=0.5U W=2U AS=1.54P AD=1.54P
+ PS=5.54U PD=5.54U
* device instance _3875 r180 *1 411.51,117.02 pfet_05v0
XM_3875 VDD_DEC n_34 n_I4546 VDD_DEC pfet_05v0 L=0.5U W=2U AS=1.54P AD=1.54P
+ PS=5.54U PD=5.54U
* device instance _3876 r180 *1 651.51,117.02 pfet_05v0
XM_3876 VDD_DEC n_40 n_I4547 VDD_DEC pfet_05v0 L=0.5U W=2U AS=1.54P AD=1.54P
+ PS=5.54U PD=5.54U
* device instance _3877 r180 *1 651.51,39.02 pfet_05v0
XM_3877 VDD_DEC n_21 n_I4548 VDD_DEC pfet_05v0 L=0.5U W=2U AS=1.54P AD=1.54P
+ PS=5.54U PD=5.54U
* device instance _3878 r180 *1 51.51,429.02 pfet_05v0
XM_3878 VDD_DEC n_146 n_I4549 VDD_DEC pfet_05v0 L=0.5U W=2U AS=1.54P AD=1.54P
+ PS=5.54U PD=5.54U
* device instance _3879 r180 *1 371.51,117.02 pfet_05v0
XM_3879 VDD_DEC n_33 n_I4550 VDD_DEC pfet_05v0 L=0.5U W=2U AS=1.54P AD=1.54P
+ PS=5.54U PD=5.54U
* device instance _3880 r180 *1 211.51,351.02 pfet_05v0
XM_3880 VDD_DEC n_159 n_I4551 VDD_DEC pfet_05v0 L=0.5U W=2U AS=1.54P AD=1.54P
+ PS=5.54U PD=5.54U
* device instance _3881 r180 *1 291.51,429.02 pfet_05v0
XM_3881 VDD_DEC n_164 n_I4552 VDD_DEC pfet_05v0 L=0.5U W=2U AS=1.54P AD=1.54P
+ PS=5.54U PD=5.54U
* device instance _3882 r180 *1 331.51,585.02 pfet_05v0
XM_3882 VDD_DEC n_272 n_I4553 VDD_DEC pfet_05v0 L=0.5U W=2U AS=1.54P AD=1.54P
+ PS=5.54U PD=5.54U
* device instance _3883 r180 *1 251.51,429.02 pfet_05v0
XM_3883 VDD_DEC n_161 n_I4554 VDD_DEC pfet_05v0 L=0.5U W=2U AS=1.54P AD=1.54P
+ PS=5.54U PD=5.54U
* device instance _3884 r180 *1 291.51,351.02 pfet_05v0
XM_3884 VDD_DEC n_165 n_I4555 VDD_DEC pfet_05v0 L=0.5U W=2U AS=1.54P AD=1.54P
+ PS=5.54U PD=5.54U
* device instance _3885 r180 *1 611.51,117.02 pfet_05v0
XM_3885 VDD_DEC n_39 n_I4556 VDD_DEC pfet_05v0 L=0.5U W=2U AS=1.54P AD=1.54P
+ PS=5.54U PD=5.54U
* device instance _3886 r180 *1 331.51,429.02 pfet_05v0
XM_3886 VDD_DEC n_167 n_I4557 VDD_DEC pfet_05v0 L=0.5U W=2U AS=1.54P AD=1.54P
+ PS=5.54U PD=5.54U
* device instance _3887 r180 *1 171.51,351.02 pfet_05v0
XM_3887 VDD_DEC n_156 n_I4558 VDD_DEC pfet_05v0 L=0.5U W=2U AS=1.54P AD=1.54P
+ PS=5.54U PD=5.54U
* device instance _3888 r180 *1 331.51,351.02 pfet_05v0
XM_3888 VDD_DEC n_168 n_I4559 VDD_DEC pfet_05v0 L=0.5U W=2U AS=1.54P AD=1.54P
+ PS=5.54U PD=5.54U
* device instance _3889 r180 *1 331.51,273.02 pfet_05v0
XM_3889 VDD_DEC n_96 n_I4560 VDD_DEC pfet_05v0 L=0.5U W=2U AS=1.54P AD=1.54P
+ PS=5.54U PD=5.54U
* device instance _3890 r180 *1 331.51,195.02 pfet_05v0
XM_3890 VDD_DEC n_97 n_I4561 VDD_DEC pfet_05v0 L=0.5U W=2U AS=1.54P AD=1.54P
+ PS=5.54U PD=5.54U
* device instance _3891 r180 *1 331.51,117.02 pfet_05v0
XM_3891 VDD_DEC n_32 n_I4562 VDD_DEC pfet_05v0 L=0.5U W=2U AS=1.54P AD=1.54P
+ PS=5.54U PD=5.54U
* device instance _3892 r180 *1 331.51,39.02 pfet_05v0
XM_3892 VDD_DEC n_13 n_I4563 VDD_DEC pfet_05v0 L=0.5U W=2U AS=1.54P AD=1.54P
+ PS=5.54U PD=5.54U
* device instance _3893 r180 *1 171.51,273.02 pfet_05v0
XM_3893 VDD_DEC n_88 n_I4564 VDD_DEC pfet_05v0 L=0.5U W=2U AS=1.54P AD=1.54P
+ PS=5.54U PD=5.54U
* device instance _3894 r180 *1 171.51,195.02 pfet_05v0
XM_3894 VDD_DEC n_89 n_I4565 VDD_DEC pfet_05v0 L=0.5U W=2U AS=1.54P AD=1.54P
+ PS=5.54U PD=5.54U
* device instance _3895 r180 *1 211.51,585.02 pfet_05v0
XM_3895 VDD_DEC n_269 n_I4566 VDD_DEC pfet_05v0 L=0.5U W=2U AS=1.54P AD=1.54P
+ PS=5.54U PD=5.54U
* device instance _3896 r180 *1 371.51,507.02 pfet_05v0
XM_3896 VDD_DEC n_169 n_I4567 VDD_DEC pfet_05v0 L=0.5U W=2U AS=1.54P AD=1.54P
+ PS=5.54U PD=5.54U
* device instance _3897 r180 *1 411.51,507.02 pfet_05v0
XM_3897 VDD_DEC n_172 n_I4568 VDD_DEC pfet_05v0 L=0.5U W=2U AS=1.54P AD=1.54P
+ PS=5.54U PD=5.54U
* device instance _3898 r180 *1 451.51,507.02 pfet_05v0
XM_3898 VDD_DEC n_175 n_I4569 VDD_DEC pfet_05v0 L=0.5U W=2U AS=1.54P AD=1.54P
+ PS=5.54U PD=5.54U
* device instance _3899 r180 *1 491.51,507.02 pfet_05v0
XM_3899 VDD_DEC n_178 n_I4570 VDD_DEC pfet_05v0 L=0.5U W=2U AS=1.54P AD=1.54P
+ PS=5.54U PD=5.54U
* device instance _3900 r180 *1 651.51,507.02 pfet_05v0
XM_3900 VDD_DEC n_190 n_I4571 VDD_DEC pfet_05v0 L=0.5U W=2U AS=1.54P AD=1.54P
+ PS=5.54U PD=5.54U
* device instance _3901 r180 *1 51.51,351.02 pfet_05v0
XM_3901 VDD_DEC n_147 n_I4572 VDD_DEC pfet_05v0 L=0.5U W=2U AS=1.54P AD=1.54P
+ PS=5.54U PD=5.54U
* device instance _3902 r180 *1 571.51,507.02 pfet_05v0
XM_3902 VDD_DEC n_184 n_I4573 VDD_DEC pfet_05v0 L=0.5U W=2U AS=1.54P AD=1.54P
+ PS=5.54U PD=5.54U
* device instance _3903 r180 *1 611.51,507.02 pfet_05v0
XM_3903 VDD_DEC n_187 n_I4574 VDD_DEC pfet_05v0 L=0.5U W=2U AS=1.54P AD=1.54P
+ PS=5.54U PD=5.54U
* device instance _3904 r180 *1 171.51,507.02 pfet_05v0
XM_3904 VDD_DEC n_154 n_I4575 VDD_DEC pfet_05v0 L=0.5U W=2U AS=1.54P AD=1.54P
+ PS=5.54U PD=5.54U
* device instance _3905 r180 *1 211.51,273.02 pfet_05v0
XM_3905 VDD_DEC n_90 n_I4576 VDD_DEC pfet_05v0 L=0.5U W=2U AS=1.54P AD=1.54P
+ PS=5.54U PD=5.54U
* device instance _3906 r180 *1 91.51,507.02 pfet_05v0
XM_3906 VDD_DEC n_148 n_I4577 VDD_DEC pfet_05v0 L=0.5U W=2U AS=1.54P AD=1.54P
+ PS=5.54U PD=5.54U
* device instance _3907 r180 *1 131.51,507.02 pfet_05v0
XM_3907 VDD_DEC n_151 n_I4578 VDD_DEC pfet_05v0 L=0.5U W=2U AS=1.54P AD=1.54P
+ PS=5.54U PD=5.54U
* device instance _3908 r180 *1 51.51,507.02 pfet_05v0
XM_3908 VDD_DEC n_145 n_I4579 VDD_DEC pfet_05v0 L=0.5U W=2U AS=1.54P AD=1.54P
+ PS=5.54U PD=5.54U
* device instance _3909 r180 *1 211.51,507.02 pfet_05v0
XM_3909 VDD_DEC n_157 n_I4580 VDD_DEC pfet_05v0 L=0.5U W=2U AS=1.54P AD=1.54P
+ PS=5.54U PD=5.54U
* device instance _3910 r180 *1 251.51,507.02 pfet_05v0
XM_3910 VDD_DEC n_160 n_I4581 VDD_DEC pfet_05v0 L=0.5U W=2U AS=1.54P AD=1.54P
+ PS=5.54U PD=5.54U
* device instance _3911 r180 *1 291.51,507.02 pfet_05v0
XM_3911 VDD_DEC n_163 n_I4582 VDD_DEC pfet_05v0 L=0.5U W=2U AS=1.54P AD=1.54P
+ PS=5.54U PD=5.54U
* device instance _3912 r180 *1 251.51,273.02 pfet_05v0
XM_3912 VDD_DEC n_92 n_I4583 VDD_DEC pfet_05v0 L=0.5U W=2U AS=1.54P AD=1.54P
+ PS=5.54U PD=5.54U
* device instance _3913 r180 *1 291.51,273.02 pfet_05v0
XM_3913 VDD_DEC n_94 n_I4584 VDD_DEC pfet_05v0 L=0.5U W=2U AS=1.54P AD=1.54P
+ PS=5.54U PD=5.54U
* device instance _3914 r180 *1 91.51,273.02 pfet_05v0
XM_3914 VDD_DEC n_84 n_I4585 VDD_DEC pfet_05v0 L=0.5U W=2U AS=1.54P AD=1.54P
+ PS=5.54U PD=5.54U
* device instance _3915 r180 *1 131.51,273.02 pfet_05v0
XM_3915 VDD_DEC n_86 n_I4586 VDD_DEC pfet_05v0 L=0.5U W=2U AS=1.54P AD=1.54P
+ PS=5.54U PD=5.54U
* device instance _3916 r180 *1 51.51,273.02 pfet_05v0
XM_3916 VDD_DEC n_82 n_I4587 VDD_DEC pfet_05v0 L=0.5U W=2U AS=1.54P AD=1.54P
+ PS=5.54U PD=5.54U
* device instance _3917 r180 *1 531.51,507.02 pfet_05v0
XM_3917 VDD_DEC n_181 n_I4588 VDD_DEC pfet_05v0 L=0.5U W=2U AS=1.54P AD=1.54P
+ PS=5.54U PD=5.54U
* device instance _3918 r180 *1 491.51,351.02 pfet_05v0
XM_3918 VDD_DEC n_180 n_I4589 VDD_DEC pfet_05v0 L=0.5U W=2U AS=1.54P AD=1.54P
+ PS=5.54U PD=5.54U
* device instance _3919 r180 *1 211.51,39.02 pfet_05v0
XM_3919 VDD_DEC n_10 n_I4590 VDD_DEC pfet_05v0 L=0.5U W=2U AS=1.54P AD=1.54P
+ PS=5.54U PD=5.54U
* device instance _3920 r180 *1 451.51,351.02 pfet_05v0
XM_3920 VDD_DEC n_177 n_I4591 VDD_DEC pfet_05v0 L=0.5U W=2U AS=1.54P AD=1.54P
+ PS=5.54U PD=5.54U
* device instance _3921 r180 *1 371.51,585.02 pfet_05v0
XM_3921 VDD_DEC n_273 n_I4592 VDD_DEC pfet_05v0 L=0.5U W=2U AS=1.54P AD=1.54P
+ PS=5.54U PD=5.54U
* device instance _3922 r180 *1 411.51,351.02 pfet_05v0
XM_3922 VDD_DEC n_174 n_I4593 VDD_DEC pfet_05v0 L=0.5U W=2U AS=1.54P AD=1.54P
+ PS=5.54U PD=5.54U
* device instance _3923 r180 *1 491.51,429.02 pfet_05v0
XM_3923 VDD_DEC n_179 n_I4594 VDD_DEC pfet_05v0 L=0.5U W=2U AS=1.54P AD=1.54P
+ PS=5.54U PD=5.54U
* device instance _3924 r180 *1 371.51,351.02 pfet_05v0
XM_3924 VDD_DEC n_171 n_I4595 VDD_DEC pfet_05v0 L=0.5U W=2U AS=1.54P AD=1.54P
+ PS=5.54U PD=5.54U
* device instance _3925 r180 *1 371.51,429.02 pfet_05v0
XM_3925 VDD_DEC n_170 n_I4596 VDD_DEC pfet_05v0 L=0.5U W=2U AS=1.54P AD=1.54P
+ PS=5.54U PD=5.54U
* device instance _3926 r180 *1 451.51,429.02 pfet_05v0
XM_3926 VDD_DEC n_176 n_I4597 VDD_DEC pfet_05v0 L=0.5U W=2U AS=1.54P AD=1.54P
+ PS=5.54U PD=5.54U
* device instance _3927 r180 *1 251.51,39.02 pfet_05v0
XM_3927 VDD_DEC n_11 n_I4598 VDD_DEC pfet_05v0 L=0.5U W=2U AS=1.54P AD=1.54P
+ PS=5.54U PD=5.54U
* device instance _3928 r180 *1 411.51,429.02 pfet_05v0
XM_3928 VDD_DEC n_173 n_I4599 VDD_DEC pfet_05v0 L=0.5U W=2U AS=1.54P AD=1.54P
+ PS=5.54U PD=5.54U
* device instance _3929 r180 *1 611.51,429.02 pfet_05v0
XM_3929 VDD_DEC n_188 n_I4600 VDD_DEC pfet_05v0 L=0.5U W=2U AS=1.54P AD=1.54P
+ PS=5.54U PD=5.54U
* device instance _3930 r180 *1 571.51,429.02 pfet_05v0
XM_3930 VDD_DEC n_185 n_I4601 VDD_DEC pfet_05v0 L=0.5U W=2U AS=1.54P AD=1.54P
+ PS=5.54U PD=5.54U
* device instance _3931 r180 *1 611.51,351.02 pfet_05v0
XM_3931 VDD_DEC n_189 n_I4602 VDD_DEC pfet_05v0 L=0.5U W=2U AS=1.54P AD=1.54P
+ PS=5.54U PD=5.54U
* device instance _3932 r180 *1 611.51,585.02 pfet_05v0
XM_3932 VDD_DEC n_279 n_I4603 VDD_DEC pfet_05v0 L=0.5U W=2U AS=1.54P AD=1.54P
+ PS=5.54U PD=5.54U
* device instance _3933 r180 *1 331.51,507.02 pfet_05v0
XM_3933 VDD_DEC n_166 n_I4604 VDD_DEC pfet_05v0 L=0.5U W=2U AS=1.54P AD=1.54P
+ PS=5.54U PD=5.54U
* device instance _3934 r180 *1 531.51,351.02 pfet_05v0
XM_3934 VDD_DEC n_183 n_I4605 VDD_DEC pfet_05v0 L=0.5U W=2U AS=1.54P AD=1.54P
+ PS=5.54U PD=5.54U
* device instance _3935 r180 *1 571.51,585.02 pfet_05v0
XM_3935 VDD_DEC n_278 n_I4606 VDD_DEC pfet_05v0 L=0.5U W=2U AS=1.54P AD=1.54P
+ PS=5.54U PD=5.54U
* device instance _3936 r180 *1 651.51,585.02 pfet_05v0
XM_3936 VDD_DEC n_280 n_I4607 VDD_DEC pfet_05v0 L=0.5U W=2U AS=1.54P AD=1.54P
+ PS=5.54U PD=5.54U
* device instance _3937 r180 *1 571.51,273.02 pfet_05v0
XM_3937 VDD_DEC n_108 n_I4608 VDD_DEC pfet_05v0 L=0.5U W=2U AS=1.54P AD=1.54P
+ PS=5.54U PD=5.54U
* device instance _3938 r180 *1 611.51,273.02 pfet_05v0
XM_3938 VDD_DEC n_110 n_I4609 VDD_DEC pfet_05v0 L=0.5U W=2U AS=1.54P AD=1.54P
+ PS=5.54U PD=5.54U
* device instance _3939 r180 *1 651.51,273.02 pfet_05v0
XM_3939 VDD_DEC n_112 n_I4610 VDD_DEC pfet_05v0 L=0.5U W=2U AS=1.54P AD=1.54P
+ PS=5.54U PD=5.54U
* device instance _3940 r180 *1 571.51,351.02 pfet_05v0
XM_3940 VDD_DEC n_186 n_I4611 VDD_DEC pfet_05v0 L=0.5U W=2U AS=1.54P AD=1.54P
+ PS=5.54U PD=5.54U
* device instance _3941 r180 *1 531.51,429.02 pfet_05v0
XM_3941 VDD_DEC n_182 n_I4612 VDD_DEC pfet_05v0 L=0.5U W=2U AS=1.54P AD=1.54P
+ PS=5.54U PD=5.54U
* device instance _3942 r180 *1 531.51,273.02 pfet_05v0
XM_3942 VDD_DEC n_106 n_I4613 VDD_DEC pfet_05v0 L=0.5U W=2U AS=1.54P AD=1.54P
+ PS=5.54U PD=5.54U
* device instance _3943 r180 *1 491.51,273.02 pfet_05v0
XM_3943 VDD_DEC n_104 n_I4614 VDD_DEC pfet_05v0 L=0.5U W=2U AS=1.54P AD=1.54P
+ PS=5.54U PD=5.54U
* device instance _3944 r180 *1 451.51,273.02 pfet_05v0
XM_3944 VDD_DEC n_102 n_I4615 VDD_DEC pfet_05v0 L=0.5U W=2U AS=1.54P AD=1.54P
+ PS=5.54U PD=5.54U
* device instance _3945 r180 *1 371.51,273.02 pfet_05v0
XM_3945 VDD_DEC n_98 n_I4616 VDD_DEC pfet_05v0 L=0.5U W=2U AS=1.54P AD=1.54P
+ PS=5.54U PD=5.54U
* device instance _3946 r180 *1 411.51,273.02 pfet_05v0
XM_3946 VDD_DEC n_100 n_I4617 VDD_DEC pfet_05v0 L=0.5U W=2U AS=1.54P AD=1.54P
+ PS=5.54U PD=5.54U
* device instance _3947 r180 *1 651.51,429.02 pfet_05v0
XM_3947 VDD_DEC n_191 n_I4618 VDD_DEC pfet_05v0 L=0.5U W=2U AS=1.54P AD=1.54P
+ PS=5.54U PD=5.54U
* device instance _3948 r180 *1 651.51,351.02 pfet_05v0
XM_3948 VDD_DEC n_192 n_I4619 VDD_DEC pfet_05v0 L=0.5U W=2U AS=1.54P AD=1.54P
+ PS=5.54U PD=5.54U
* device instance _3949 r180 *1 531.51,585.02 pfet_05v0
XM_3949 VDD_DEC n_277 n_I4620 VDD_DEC pfet_05v0 L=0.5U W=2U AS=1.54P AD=1.54P
+ PS=5.54U PD=5.54U
* device instance _3950 r180 *1 91.51,429.02 pfet_05v0
XM_3950 VDD_DEC n_149 n_I4621 VDD_DEC pfet_05v0 L=0.5U W=2U AS=1.54P AD=1.54P
+ PS=5.54U PD=5.54U
* device instance _3951 r180 *1 371.51,39.02 pfet_05v0
XM_3951 VDD_DEC n_14 n_I4622 VDD_DEC pfet_05v0 L=0.5U W=2U AS=1.54P AD=1.54P
+ PS=5.54U PD=5.54U
* device instance _3952 r180 *1 131.51,585.02 pfet_05v0
XM_3952 VDD_DEC n_267 n_I4623 VDD_DEC pfet_05v0 L=0.5U W=2U AS=1.54P AD=1.54P
+ PS=5.54U PD=5.54U
* device instance _3953 r180 *1 51.51,585.02 pfet_05v0
XM_3953 VDD_DEC n_265 n_I4624 VDD_DEC pfet_05v0 L=0.5U W=2U AS=1.54P AD=1.54P
+ PS=5.54U PD=5.54U
* device instance _3954 r180 *1 131.51,351.02 pfet_05v0
XM_3954 VDD_DEC n_153 n_I4625 VDD_DEC pfet_05v0 L=0.5U W=2U AS=1.54P AD=1.54P
+ PS=5.54U PD=5.54U
* device instance _3955 r180 *1 131.51,429.02 pfet_05v0
XM_3955 VDD_DEC n_152 n_I4626 VDD_DEC pfet_05v0 L=0.5U W=2U AS=1.54P AD=1.54P
+ PS=5.54U PD=5.54U
* device instance _3956 r180 *1 51.51,117.02 pfet_05v0
XM_3956 VDD_DEC n_25 n_I4627 VDD_DEC pfet_05v0 L=0.5U W=2U AS=1.54P AD=1.54P
+ PS=5.54U PD=5.54U
* device instance _3957 r180 *1 91.51,117.02 pfet_05v0
XM_3957 VDD_DEC n_26 n_I4628 VDD_DEC pfet_05v0 L=0.5U W=2U AS=1.54P AD=1.54P
+ PS=5.54U PD=5.54U
* device instance _3958 r180 *1 131.51,117.02 pfet_05v0
XM_3958 VDD_DEC n_27 n_I4629 VDD_DEC pfet_05v0 L=0.5U W=2U AS=1.54P AD=1.54P
+ PS=5.54U PD=5.54U
* device instance _3959 r180 *1 91.51,39.02 pfet_05v0
XM_3959 VDD_DEC n_7 n_I4630 VDD_DEC pfet_05v0 L=0.5U W=2U AS=1.54P AD=1.54P
+ PS=5.54U PD=5.54U
* device instance _3960 r180 *1 451.51,39.02 pfet_05v0
XM_3960 VDD_DEC n_16 n_I4631 VDD_DEC pfet_05v0 L=0.5U W=2U AS=1.54P AD=1.54P
+ PS=5.54U PD=5.54U
* device instance _3961 r180 *1 131.51,39.02 pfet_05v0
XM_3961 VDD_DEC n_8 n_I4632 VDD_DEC pfet_05v0 L=0.5U W=2U AS=1.54P AD=1.54P
+ PS=5.54U PD=5.54U
* device instance _3962 r180 *1 131.51,195.02 pfet_05v0
XM_3962 VDD_DEC n_87 n_I4633 VDD_DEC pfet_05v0 L=0.5U W=2U AS=1.54P AD=1.54P
+ PS=5.54U PD=5.54U
* device instance _3963 r180 *1 51.51,195.02 pfet_05v0
XM_3963 VDD_DEC n_83 n_I4634 VDD_DEC pfet_05v0 L=0.5U W=2U AS=1.54P AD=1.54P
+ PS=5.54U PD=5.54U
* device instance _3964 r180 *1 251.51,195.02 pfet_05v0
XM_3964 VDD_DEC n_93 n_I4635 VDD_DEC pfet_05v0 L=0.5U W=2U AS=1.54P AD=1.54P
+ PS=5.54U PD=5.54U
* device instance _3965 r180 *1 211.51,117.02 pfet_05v0
XM_3965 VDD_DEC n_29 n_I4636 VDD_DEC pfet_05v0 L=0.5U W=2U AS=1.54P AD=1.54P
+ PS=5.54U PD=5.54U
* device instance _3966 r180 *1 251.51,117.02 pfet_05v0
XM_3966 VDD_DEC n_30 n_I4637 VDD_DEC pfet_05v0 L=0.5U W=2U AS=1.54P AD=1.54P
+ PS=5.54U PD=5.54U
* device instance _3967 r180 *1 171.51,585.02 pfet_05v0
XM_3967 VDD_DEC n_268 n_I4638 VDD_DEC pfet_05v0 L=0.5U W=2U AS=1.54P AD=1.54P
+ PS=5.54U PD=5.54U
* device instance _3968 r180 *1 291.51,195.02 pfet_05v0
XM_3968 VDD_DEC n_95 n_I4639 VDD_DEC pfet_05v0 L=0.5U W=2U AS=1.54P AD=1.54P
+ PS=5.54U PD=5.54U
* device instance _3969 r180 *1 291.51,117.02 pfet_05v0
XM_3969 VDD_DEC n_31 n_I4640 VDD_DEC pfet_05v0 L=0.5U W=2U AS=1.54P AD=1.54P
+ PS=5.54U PD=5.54U
* device instance _3970 r180 *1 371.51,195.02 pfet_05v0
XM_3970 VDD_DEC n_99 n_I4641 VDD_DEC pfet_05v0 L=0.5U W=2U AS=1.54P AD=1.54P
+ PS=5.54U PD=5.54U
* device instance _3971 r180 *1 411.51,195.02 pfet_05v0
XM_3971 VDD_DEC n_101 n_I4642 VDD_DEC pfet_05v0 L=0.5U W=2U AS=1.54P AD=1.54P
+ PS=5.54U PD=5.54U
* device instance _3972 r180 *1 91.51,195.02 pfet_05v0
XM_3972 VDD_DEC n_85 n_I4643 VDD_DEC pfet_05v0 L=0.5U W=2U AS=1.54P AD=1.54P
+ PS=5.54U PD=5.54U
* device instance _3973 r180 *1 491.51,195.02 pfet_05v0
XM_3973 VDD_DEC n_105 n_I4644 VDD_DEC pfet_05v0 L=0.5U W=2U AS=1.54P AD=1.54P
+ PS=5.54U PD=5.54U
* device instance _3974 r180 *1 491.51,585.02 pfet_05v0
XM_3974 VDD_DEC n_276 n_I4645 VDD_DEC pfet_05v0 L=0.5U W=2U AS=1.54P AD=1.54P
+ PS=5.54U PD=5.54U
* device instance _3975 r180 *1 451.51,585.02 pfet_05v0
XM_3975 VDD_DEC n_275 n_I4646 VDD_DEC pfet_05v0 L=0.5U W=2U AS=1.54P AD=1.54P
+ PS=5.54U PD=5.54U
* device instance _3976 r180 *1 411.51,39.02 pfet_05v0
XM_3976 VDD_DEC n_15 n_I4647 VDD_DEC pfet_05v0 L=0.5U W=2U AS=1.54P AD=1.54P
+ PS=5.54U PD=5.54U
* device instance _3977 r180 *1 411.51,585.02 pfet_05v0
XM_3977 VDD_DEC n_274 n_I4648 VDD_DEC pfet_05v0 L=0.5U W=2U AS=1.54P AD=1.54P
+ PS=5.54U PD=5.54U
* device instance _3978 r180 *1 291.51,39.02 pfet_05v0
XM_3978 VDD_DEC n_12 n_I4649 VDD_DEC pfet_05v0 L=0.5U W=2U AS=1.54P AD=1.54P
+ PS=5.54U PD=5.54U
* device instance _3979 r180 *1 211.51,195.02 pfet_05v0
XM_3979 VDD_DEC n_91 n_I4650 VDD_DEC pfet_05v0 L=0.5U W=2U AS=1.54P AD=1.54P
+ PS=5.54U PD=5.54U
* device instance _3980 r180 *1 491.51,39.02 pfet_05v0
XM_3980 VDD_DEC n_17 n_I4651 VDD_DEC pfet_05v0 L=0.5U W=2U AS=1.54P AD=1.54P
+ PS=5.54U PD=5.54U
* device instance _3981 r180 *1 451.51,195.02 pfet_05v0
XM_3981 VDD_DEC n_103 n_I4652 VDD_DEC pfet_05v0 L=0.5U W=2U AS=1.54P AD=1.54P
+ PS=5.54U PD=5.54U
* device instance _3982 r90 *1 58.535,35.945 nfet_05v0
XM_3982 n_I257 n_6 n_5 VSS nfet_05v0 L=0.6U W=2U AS=1.46P AD=1.46P PS=5.46U
+ PD=5.46U
* device instance _3983 r90 *1 258.535,581.945 nfet_05v0
XM_3983 n_I256 n_270 n_5 VSS nfet_05v0 L=0.6U W=2U AS=1.46P AD=1.46P PS=5.46U
+ PD=5.46U
* device instance _3984 r90 *1 538.535,35.945 nfet_05v0
XM_3984 n_I255 n_18 n_5 VSS nfet_05v0 L=0.6U W=2U AS=1.46P AD=1.46P PS=5.46U
+ PD=5.46U
* device instance _3985 r90 *1 178.535,113.945 nfet_05v0
XM_3985 n_I254 n_28 n_5 VSS nfet_05v0 L=0.6U W=2U AS=1.46P AD=1.46P PS=5.46U
+ PD=5.46U
* device instance _3986 r90 *1 218.535,425.945 nfet_05v0
XM_3986 n_I253 n_158 n_5 VSS nfet_05v0 L=0.6U W=2U AS=1.46P AD=1.46P PS=5.46U
+ PD=5.46U
* device instance _3987 r90 *1 178.535,35.945 nfet_05v0
XM_3987 n_I252 n_9 n_5 VSS nfet_05v0 L=0.6U W=2U AS=1.46P AD=1.46P PS=5.46U
+ PD=5.46U
* device instance _3988 r90 *1 298.535,581.945 nfet_05v0
XM_3988 n_I251 n_271 n_5 VSS nfet_05v0 L=0.6U W=2U AS=1.46P AD=1.46P PS=5.46U
+ PD=5.46U
* device instance _3989 r90 *1 98.535,581.945 nfet_05v0
XM_3989 n_I250 n_266 n_5 VSS nfet_05v0 L=0.6U W=2U AS=1.46P AD=1.46P PS=5.46U
+ PD=5.46U
* device instance _3990 r90 *1 258.535,347.945 nfet_05v0
XM_3990 n_I249 n_162 n_5 VSS nfet_05v0 L=0.6U W=2U AS=1.46P AD=1.46P PS=5.46U
+ PD=5.46U
* device instance _3991 r90 *1 618.535,35.945 nfet_05v0
XM_3991 n_I248 n_20 n_5 VSS nfet_05v0 L=0.6U W=2U AS=1.46P AD=1.46P PS=5.46U
+ PD=5.46U
* device instance _3992 r90 *1 178.535,425.945 nfet_05v0
XM_3992 n_I247 n_155 n_5 VSS nfet_05v0 L=0.6U W=2U AS=1.46P AD=1.46P PS=5.46U
+ PD=5.46U
* device instance _3993 r90 *1 458.535,113.945 nfet_05v0
XM_3993 n_I246 n_35 n_5 VSS nfet_05v0 L=0.6U W=2U AS=1.46P AD=1.46P PS=5.46U
+ PD=5.46U
* device instance _3994 r90 *1 498.535,113.945 nfet_05v0
XM_3994 n_I245 n_36 n_5 VSS nfet_05v0 L=0.6U W=2U AS=1.46P AD=1.46P PS=5.46U
+ PD=5.46U
* device instance _3995 r90 *1 618.535,191.945 nfet_05v0
XM_3995 n_I244 n_111 n_5 VSS nfet_05v0 L=0.6U W=2U AS=1.46P AD=1.46P PS=5.46U
+ PD=5.46U
* device instance _3996 r90 *1 658.535,191.945 nfet_05v0
XM_3996 n_I243 n_113 n_5 VSS nfet_05v0 L=0.6U W=2U AS=1.46P AD=1.46P PS=5.46U
+ PD=5.46U
* device instance _3997 r90 *1 538.535,191.945 nfet_05v0
XM_3997 n_I242 n_107 n_5 VSS nfet_05v0 L=0.6U W=2U AS=1.46P AD=1.46P PS=5.46U
+ PD=5.46U
* device instance _3998 r90 *1 578.535,191.945 nfet_05v0
XM_3998 n_I241 n_109 n_5 VSS nfet_05v0 L=0.6U W=2U AS=1.46P AD=1.46P PS=5.46U
+ PD=5.46U
* device instance _3999 r90 *1 538.535,113.945 nfet_05v0
XM_3999 n_I240 n_37 n_5 VSS nfet_05v0 L=0.6U W=2U AS=1.46P AD=1.46P PS=5.46U
+ PD=5.46U
* device instance _4000 r90 *1 578.535,113.945 nfet_05v0
XM_4000 n_I239 n_38 n_5 VSS nfet_05v0 L=0.6U W=2U AS=1.46P AD=1.46P PS=5.46U
+ PD=5.46U
* device instance _4001 r90 *1 98.535,347.945 nfet_05v0
XM_4001 n_I238 n_150 n_5 VSS nfet_05v0 L=0.6U W=2U AS=1.46P AD=1.46P PS=5.46U
+ PD=5.46U
* device instance _4002 r90 *1 578.535,35.945 nfet_05v0
XM_4002 n_I237 n_19 n_5 VSS nfet_05v0 L=0.6U W=2U AS=1.46P AD=1.46P PS=5.46U
+ PD=5.46U
* device instance _4003 r90 *1 418.535,113.945 nfet_05v0
XM_4003 n_I236 n_34 n_5 VSS nfet_05v0 L=0.6U W=2U AS=1.46P AD=1.46P PS=5.46U
+ PD=5.46U
* device instance _4004 r90 *1 658.535,113.945 nfet_05v0
XM_4004 n_I235 n_40 n_5 VSS nfet_05v0 L=0.6U W=2U AS=1.46P AD=1.46P PS=5.46U
+ PD=5.46U
* device instance _4005 r90 *1 658.535,35.945 nfet_05v0
XM_4005 n_I234 n_21 n_5 VSS nfet_05v0 L=0.6U W=2U AS=1.46P AD=1.46P PS=5.46U
+ PD=5.46U
* device instance _4006 r90 *1 58.535,425.945 nfet_05v0
XM_4006 n_I233 n_146 n_5 VSS nfet_05v0 L=0.6U W=2U AS=1.46P AD=1.46P PS=5.46U
+ PD=5.46U
* device instance _4007 r90 *1 378.535,113.945 nfet_05v0
XM_4007 n_I232 n_33 n_5 VSS nfet_05v0 L=0.6U W=2U AS=1.46P AD=1.46P PS=5.46U
+ PD=5.46U
* device instance _4008 r90 *1 218.535,347.945 nfet_05v0
XM_4008 n_I231 n_159 n_5 VSS nfet_05v0 L=0.6U W=2U AS=1.46P AD=1.46P PS=5.46U
+ PD=5.46U
* device instance _4009 r90 *1 298.535,425.945 nfet_05v0
XM_4009 n_I230 n_164 n_5 VSS nfet_05v0 L=0.6U W=2U AS=1.46P AD=1.46P PS=5.46U
+ PD=5.46U
* device instance _4010 r90 *1 338.535,581.945 nfet_05v0
XM_4010 n_I229 n_272 n_5 VSS nfet_05v0 L=0.6U W=2U AS=1.46P AD=1.46P PS=5.46U
+ PD=5.46U
* device instance _4011 r90 *1 258.535,425.945 nfet_05v0
XM_4011 n_I228 n_161 n_5 VSS nfet_05v0 L=0.6U W=2U AS=1.46P AD=1.46P PS=5.46U
+ PD=5.46U
* device instance _4012 r90 *1 298.535,347.945 nfet_05v0
XM_4012 n_I227 n_165 n_5 VSS nfet_05v0 L=0.6U W=2U AS=1.46P AD=1.46P PS=5.46U
+ PD=5.46U
* device instance _4013 r90 *1 618.535,113.945 nfet_05v0
XM_4013 n_I226 n_39 n_5 VSS nfet_05v0 L=0.6U W=2U AS=1.46P AD=1.46P PS=5.46U
+ PD=5.46U
* device instance _4014 r90 *1 338.535,425.945 nfet_05v0
XM_4014 n_I225 n_167 n_5 VSS nfet_05v0 L=0.6U W=2U AS=1.46P AD=1.46P PS=5.46U
+ PD=5.46U
* device instance _4015 r90 *1 178.535,347.945 nfet_05v0
XM_4015 n_I224 n_156 n_5 VSS nfet_05v0 L=0.6U W=2U AS=1.46P AD=1.46P PS=5.46U
+ PD=5.46U
* device instance _4016 r90 *1 338.535,347.945 nfet_05v0
XM_4016 n_I223 n_168 n_5 VSS nfet_05v0 L=0.6U W=2U AS=1.46P AD=1.46P PS=5.46U
+ PD=5.46U
* device instance _4017 r90 *1 338.535,269.945 nfet_05v0
XM_4017 n_I222 n_96 n_5 VSS nfet_05v0 L=0.6U W=2U AS=1.46P AD=1.46P PS=5.46U
+ PD=5.46U
* device instance _4018 r90 *1 338.535,191.945 nfet_05v0
XM_4018 n_I221 n_97 n_5 VSS nfet_05v0 L=0.6U W=2U AS=1.46P AD=1.46P PS=5.46U
+ PD=5.46U
* device instance _4019 r90 *1 338.535,113.945 nfet_05v0
XM_4019 n_I220 n_32 n_5 VSS nfet_05v0 L=0.6U W=2U AS=1.46P AD=1.46P PS=5.46U
+ PD=5.46U
* device instance _4020 r90 *1 338.535,35.945 nfet_05v0
XM_4020 n_I219 n_13 n_5 VSS nfet_05v0 L=0.6U W=2U AS=1.46P AD=1.46P PS=5.46U
+ PD=5.46U
* device instance _4021 r90 *1 178.535,269.945 nfet_05v0
XM_4021 n_I218 n_88 n_5 VSS nfet_05v0 L=0.6U W=2U AS=1.46P AD=1.46P PS=5.46U
+ PD=5.46U
* device instance _4022 r90 *1 178.535,191.945 nfet_05v0
XM_4022 n_I217 n_89 n_5 VSS nfet_05v0 L=0.6U W=2U AS=1.46P AD=1.46P PS=5.46U
+ PD=5.46U
* device instance _4023 r90 *1 218.535,581.945 nfet_05v0
XM_4023 n_I216 n_269 n_5 VSS nfet_05v0 L=0.6U W=2U AS=1.46P AD=1.46P PS=5.46U
+ PD=5.46U
* device instance _4024 r90 *1 378.535,503.945 nfet_05v0
XM_4024 n_I215 n_169 n_5 VSS nfet_05v0 L=0.6U W=2U AS=1.46P AD=1.46P PS=5.46U
+ PD=5.46U
* device instance _4025 r90 *1 418.535,503.945 nfet_05v0
XM_4025 n_I214 n_172 n_5 VSS nfet_05v0 L=0.6U W=2U AS=1.46P AD=1.46P PS=5.46U
+ PD=5.46U
* device instance _4026 r90 *1 458.535,503.945 nfet_05v0
XM_4026 n_I213 n_175 n_5 VSS nfet_05v0 L=0.6U W=2U AS=1.46P AD=1.46P PS=5.46U
+ PD=5.46U
* device instance _4027 r90 *1 498.535,503.945 nfet_05v0
XM_4027 n_I212 n_178 n_5 VSS nfet_05v0 L=0.6U W=2U AS=1.46P AD=1.46P PS=5.46U
+ PD=5.46U
* device instance _4028 r90 *1 658.535,503.945 nfet_05v0
XM_4028 n_I211 n_190 n_5 VSS nfet_05v0 L=0.6U W=2U AS=1.46P AD=1.46P PS=5.46U
+ PD=5.46U
* device instance _4029 r90 *1 58.535,347.945 nfet_05v0
XM_4029 n_I210 n_147 n_5 VSS nfet_05v0 L=0.6U W=2U AS=1.46P AD=1.46P PS=5.46U
+ PD=5.46U
* device instance _4030 r90 *1 578.535,503.945 nfet_05v0
XM_4030 n_I209 n_184 n_5 VSS nfet_05v0 L=0.6U W=2U AS=1.46P AD=1.46P PS=5.46U
+ PD=5.46U
* device instance _4031 r90 *1 618.535,503.945 nfet_05v0
XM_4031 n_I208 n_187 n_5 VSS nfet_05v0 L=0.6U W=2U AS=1.46P AD=1.46P PS=5.46U
+ PD=5.46U
* device instance _4032 r90 *1 178.535,503.945 nfet_05v0
XM_4032 n_I207 n_154 n_5 VSS nfet_05v0 L=0.6U W=2U AS=1.46P AD=1.46P PS=5.46U
+ PD=5.46U
* device instance _4033 r90 *1 218.535,269.945 nfet_05v0
XM_4033 n_I206 n_90 n_5 VSS nfet_05v0 L=0.6U W=2U AS=1.46P AD=1.46P PS=5.46U
+ PD=5.46U
* device instance _4034 r90 *1 98.535,503.945 nfet_05v0
XM_4034 n_I205 n_148 n_5 VSS nfet_05v0 L=0.6U W=2U AS=1.46P AD=1.46P PS=5.46U
+ PD=5.46U
* device instance _4035 r90 *1 138.535,503.945 nfet_05v0
XM_4035 n_I204 n_151 n_5 VSS nfet_05v0 L=0.6U W=2U AS=1.46P AD=1.46P PS=5.46U
+ PD=5.46U
* device instance _4036 r90 *1 58.535,503.945 nfet_05v0
XM_4036 n_I203 n_145 n_5 VSS nfet_05v0 L=0.6U W=2U AS=1.46P AD=1.46P PS=5.46U
+ PD=5.46U
* device instance _4037 r90 *1 218.535,503.945 nfet_05v0
XM_4037 n_I202 n_157 n_5 VSS nfet_05v0 L=0.6U W=2U AS=1.46P AD=1.46P PS=5.46U
+ PD=5.46U
* device instance _4038 r90 *1 258.535,503.945 nfet_05v0
XM_4038 n_I201 n_160 n_5 VSS nfet_05v0 L=0.6U W=2U AS=1.46P AD=1.46P PS=5.46U
+ PD=5.46U
* device instance _4039 r90 *1 298.535,503.945 nfet_05v0
XM_4039 n_I200 n_163 n_5 VSS nfet_05v0 L=0.6U W=2U AS=1.46P AD=1.46P PS=5.46U
+ PD=5.46U
* device instance _4040 r90 *1 258.535,269.945 nfet_05v0
XM_4040 n_I199 n_92 n_5 VSS nfet_05v0 L=0.6U W=2U AS=1.46P AD=1.46P PS=5.46U
+ PD=5.46U
* device instance _4041 r90 *1 298.535,269.945 nfet_05v0
XM_4041 n_I198 n_94 n_5 VSS nfet_05v0 L=0.6U W=2U AS=1.46P AD=1.46P PS=5.46U
+ PD=5.46U
* device instance _4042 r90 *1 98.535,269.945 nfet_05v0
XM_4042 n_I197 n_84 n_5 VSS nfet_05v0 L=0.6U W=2U AS=1.46P AD=1.46P PS=5.46U
+ PD=5.46U
* device instance _4043 r90 *1 138.535,269.945 nfet_05v0
XM_4043 n_I196 n_86 n_5 VSS nfet_05v0 L=0.6U W=2U AS=1.46P AD=1.46P PS=5.46U
+ PD=5.46U
* device instance _4044 r90 *1 58.535,269.945 nfet_05v0
XM_4044 n_I195 n_82 n_5 VSS nfet_05v0 L=0.6U W=2U AS=1.46P AD=1.46P PS=5.46U
+ PD=5.46U
* device instance _4045 r90 *1 538.535,503.945 nfet_05v0
XM_4045 n_I194 n_181 n_5 VSS nfet_05v0 L=0.6U W=2U AS=1.46P AD=1.46P PS=5.46U
+ PD=5.46U
* device instance _4046 r90 *1 498.535,347.945 nfet_05v0
XM_4046 n_I193 n_180 n_5 VSS nfet_05v0 L=0.6U W=2U AS=1.46P AD=1.46P PS=5.46U
+ PD=5.46U
* device instance _4047 r90 *1 218.535,35.945 nfet_05v0
XM_4047 n_I192 n_10 n_5 VSS nfet_05v0 L=0.6U W=2U AS=1.46P AD=1.46P PS=5.46U
+ PD=5.46U
* device instance _4048 r90 *1 458.535,347.945 nfet_05v0
XM_4048 n_I191 n_177 n_5 VSS nfet_05v0 L=0.6U W=2U AS=1.46P AD=1.46P PS=5.46U
+ PD=5.46U
* device instance _4049 r90 *1 378.535,581.945 nfet_05v0
XM_4049 n_I190 n_273 n_5 VSS nfet_05v0 L=0.6U W=2U AS=1.46P AD=1.46P PS=5.46U
+ PD=5.46U
* device instance _4050 r90 *1 418.535,347.945 nfet_05v0
XM_4050 n_I189 n_174 n_5 VSS nfet_05v0 L=0.6U W=2U AS=1.46P AD=1.46P PS=5.46U
+ PD=5.46U
* device instance _4051 r90 *1 498.535,425.945 nfet_05v0
XM_4051 n_I188 n_179 n_5 VSS nfet_05v0 L=0.6U W=2U AS=1.46P AD=1.46P PS=5.46U
+ PD=5.46U
* device instance _4052 r90 *1 378.535,347.945 nfet_05v0
XM_4052 n_I187 n_171 n_5 VSS nfet_05v0 L=0.6U W=2U AS=1.46P AD=1.46P PS=5.46U
+ PD=5.46U
* device instance _4053 r90 *1 378.535,425.945 nfet_05v0
XM_4053 n_I186 n_170 n_5 VSS nfet_05v0 L=0.6U W=2U AS=1.46P AD=1.46P PS=5.46U
+ PD=5.46U
* device instance _4054 r90 *1 458.535,425.945 nfet_05v0
XM_4054 n_I185 n_176 n_5 VSS nfet_05v0 L=0.6U W=2U AS=1.46P AD=1.46P PS=5.46U
+ PD=5.46U
* device instance _4055 r90 *1 258.535,35.945 nfet_05v0
XM_4055 n_I184 n_11 n_5 VSS nfet_05v0 L=0.6U W=2U AS=1.46P AD=1.46P PS=5.46U
+ PD=5.46U
* device instance _4056 r90 *1 418.535,425.945 nfet_05v0
XM_4056 n_I183 n_173 n_5 VSS nfet_05v0 L=0.6U W=2U AS=1.46P AD=1.46P PS=5.46U
+ PD=5.46U
* device instance _4057 r90 *1 618.535,425.945 nfet_05v0
XM_4057 n_I182 n_188 n_5 VSS nfet_05v0 L=0.6U W=2U AS=1.46P AD=1.46P PS=5.46U
+ PD=5.46U
* device instance _4058 r90 *1 578.535,425.945 nfet_05v0
XM_4058 n_I181 n_185 n_5 VSS nfet_05v0 L=0.6U W=2U AS=1.46P AD=1.46P PS=5.46U
+ PD=5.46U
* device instance _4059 r90 *1 618.535,347.945 nfet_05v0
XM_4059 n_I180 n_189 n_5 VSS nfet_05v0 L=0.6U W=2U AS=1.46P AD=1.46P PS=5.46U
+ PD=5.46U
* device instance _4060 r90 *1 618.535,581.945 nfet_05v0
XM_4060 n_I179 n_279 n_5 VSS nfet_05v0 L=0.6U W=2U AS=1.46P AD=1.46P PS=5.46U
+ PD=5.46U
* device instance _4061 r90 *1 338.535,503.945 nfet_05v0
XM_4061 n_I178 n_166 n_5 VSS nfet_05v0 L=0.6U W=2U AS=1.46P AD=1.46P PS=5.46U
+ PD=5.46U
* device instance _4062 r90 *1 538.535,347.945 nfet_05v0
XM_4062 n_I177 n_183 n_5 VSS nfet_05v0 L=0.6U W=2U AS=1.46P AD=1.46P PS=5.46U
+ PD=5.46U
* device instance _4063 r90 *1 578.535,581.945 nfet_05v0
XM_4063 n_I176 n_278 n_5 VSS nfet_05v0 L=0.6U W=2U AS=1.46P AD=1.46P PS=5.46U
+ PD=5.46U
* device instance _4064 r90 *1 658.535,581.945 nfet_05v0
XM_4064 n_I175 n_280 n_5 VSS nfet_05v0 L=0.6U W=2U AS=1.46P AD=1.46P PS=5.46U
+ PD=5.46U
* device instance _4065 r90 *1 578.535,269.945 nfet_05v0
XM_4065 n_I174 n_108 n_5 VSS nfet_05v0 L=0.6U W=2U AS=1.46P AD=1.46P PS=5.46U
+ PD=5.46U
* device instance _4066 r90 *1 618.535,269.945 nfet_05v0
XM_4066 n_I173 n_110 n_5 VSS nfet_05v0 L=0.6U W=2U AS=1.46P AD=1.46P PS=5.46U
+ PD=5.46U
* device instance _4067 r90 *1 658.535,269.945 nfet_05v0
XM_4067 n_I172 n_112 n_5 VSS nfet_05v0 L=0.6U W=2U AS=1.46P AD=1.46P PS=5.46U
+ PD=5.46U
* device instance _4068 r90 *1 578.535,347.945 nfet_05v0
XM_4068 n_I171 n_186 n_5 VSS nfet_05v0 L=0.6U W=2U AS=1.46P AD=1.46P PS=5.46U
+ PD=5.46U
* device instance _4069 r90 *1 538.535,425.945 nfet_05v0
XM_4069 n_I170 n_182 n_5 VSS nfet_05v0 L=0.6U W=2U AS=1.46P AD=1.46P PS=5.46U
+ PD=5.46U
* device instance _4070 r90 *1 538.535,269.945 nfet_05v0
XM_4070 n_I169 n_106 n_5 VSS nfet_05v0 L=0.6U W=2U AS=1.46P AD=1.46P PS=5.46U
+ PD=5.46U
* device instance _4071 r90 *1 498.535,269.945 nfet_05v0
XM_4071 n_I168 n_104 n_5 VSS nfet_05v0 L=0.6U W=2U AS=1.46P AD=1.46P PS=5.46U
+ PD=5.46U
* device instance _4072 r90 *1 458.535,269.945 nfet_05v0
XM_4072 n_I167 n_102 n_5 VSS nfet_05v0 L=0.6U W=2U AS=1.46P AD=1.46P PS=5.46U
+ PD=5.46U
* device instance _4073 r90 *1 378.535,269.945 nfet_05v0
XM_4073 n_I166 n_98 n_5 VSS nfet_05v0 L=0.6U W=2U AS=1.46P AD=1.46P PS=5.46U
+ PD=5.46U
* device instance _4074 r90 *1 418.535,269.945 nfet_05v0
XM_4074 n_I165 n_100 n_5 VSS nfet_05v0 L=0.6U W=2U AS=1.46P AD=1.46P PS=5.46U
+ PD=5.46U
* device instance _4075 r90 *1 658.535,425.945 nfet_05v0
XM_4075 n_I164 n_191 n_5 VSS nfet_05v0 L=0.6U W=2U AS=1.46P AD=1.46P PS=5.46U
+ PD=5.46U
* device instance _4076 r90 *1 658.535,347.945 nfet_05v0
XM_4076 n_I163 n_192 n_5 VSS nfet_05v0 L=0.6U W=2U AS=1.46P AD=1.46P PS=5.46U
+ PD=5.46U
* device instance _4077 r90 *1 538.535,581.945 nfet_05v0
XM_4077 n_I162 n_277 n_5 VSS nfet_05v0 L=0.6U W=2U AS=1.46P AD=1.46P PS=5.46U
+ PD=5.46U
* device instance _4078 r90 *1 98.535,425.945 nfet_05v0
XM_4078 n_I161 n_149 n_5 VSS nfet_05v0 L=0.6U W=2U AS=1.46P AD=1.46P PS=5.46U
+ PD=5.46U
* device instance _4079 r90 *1 378.535,35.945 nfet_05v0
XM_4079 n_I160 n_14 n_5 VSS nfet_05v0 L=0.6U W=2U AS=1.46P AD=1.46P PS=5.46U
+ PD=5.46U
* device instance _4080 r90 *1 138.535,581.945 nfet_05v0
XM_4080 n_I159 n_267 n_5 VSS nfet_05v0 L=0.6U W=2U AS=1.46P AD=1.46P PS=5.46U
+ PD=5.46U
* device instance _4081 r90 *1 58.535,581.945 nfet_05v0
XM_4081 n_I158 n_265 n_5 VSS nfet_05v0 L=0.6U W=2U AS=1.46P AD=1.46P PS=5.46U
+ PD=5.46U
* device instance _4082 r90 *1 138.535,347.945 nfet_05v0
XM_4082 n_I157 n_153 n_5 VSS nfet_05v0 L=0.6U W=2U AS=1.46P AD=1.46P PS=5.46U
+ PD=5.46U
* device instance _4083 r90 *1 138.535,425.945 nfet_05v0
XM_4083 n_I156 n_152 n_5 VSS nfet_05v0 L=0.6U W=2U AS=1.46P AD=1.46P PS=5.46U
+ PD=5.46U
* device instance _4084 r90 *1 58.535,113.945 nfet_05v0
XM_4084 n_I155 n_25 n_5 VSS nfet_05v0 L=0.6U W=2U AS=1.46P AD=1.46P PS=5.46U
+ PD=5.46U
* device instance _4085 r90 *1 98.535,113.945 nfet_05v0
XM_4085 n_I154 n_26 n_5 VSS nfet_05v0 L=0.6U W=2U AS=1.46P AD=1.46P PS=5.46U
+ PD=5.46U
* device instance _4086 r90 *1 138.535,113.945 nfet_05v0
XM_4086 n_I153 n_27 n_5 VSS nfet_05v0 L=0.6U W=2U AS=1.46P AD=1.46P PS=5.46U
+ PD=5.46U
* device instance _4087 r90 *1 98.535,35.945 nfet_05v0
XM_4087 n_I152 n_7 n_5 VSS nfet_05v0 L=0.6U W=2U AS=1.46P AD=1.46P PS=5.46U
+ PD=5.46U
* device instance _4088 r90 *1 458.535,35.945 nfet_05v0
XM_4088 n_I151 n_16 n_5 VSS nfet_05v0 L=0.6U W=2U AS=1.46P AD=1.46P PS=5.46U
+ PD=5.46U
* device instance _4089 r90 *1 138.535,35.945 nfet_05v0
XM_4089 n_I150 n_8 n_5 VSS nfet_05v0 L=0.6U W=2U AS=1.46P AD=1.46P PS=5.46U
+ PD=5.46U
* device instance _4090 r90 *1 138.535,191.945 nfet_05v0
XM_4090 n_I149 n_87 n_5 VSS nfet_05v0 L=0.6U W=2U AS=1.46P AD=1.46P PS=5.46U
+ PD=5.46U
* device instance _4091 r90 *1 58.535,191.945 nfet_05v0
XM_4091 n_I148 n_83 n_5 VSS nfet_05v0 L=0.6U W=2U AS=1.46P AD=1.46P PS=5.46U
+ PD=5.46U
* device instance _4092 r90 *1 258.535,191.945 nfet_05v0
XM_4092 n_I147 n_93 n_5 VSS nfet_05v0 L=0.6U W=2U AS=1.46P AD=1.46P PS=5.46U
+ PD=5.46U
* device instance _4093 r90 *1 218.535,113.945 nfet_05v0
XM_4093 n_I146 n_29 n_5 VSS nfet_05v0 L=0.6U W=2U AS=1.46P AD=1.46P PS=5.46U
+ PD=5.46U
* device instance _4094 r90 *1 258.535,113.945 nfet_05v0
XM_4094 n_I145 n_30 n_5 VSS nfet_05v0 L=0.6U W=2U AS=1.46P AD=1.46P PS=5.46U
+ PD=5.46U
* device instance _4095 r90 *1 178.535,581.945 nfet_05v0
XM_4095 n_I144 n_268 n_5 VSS nfet_05v0 L=0.6U W=2U AS=1.46P AD=1.46P PS=5.46U
+ PD=5.46U
* device instance _4096 r90 *1 298.535,191.945 nfet_05v0
XM_4096 n_I143 n_95 n_5 VSS nfet_05v0 L=0.6U W=2U AS=1.46P AD=1.46P PS=5.46U
+ PD=5.46U
* device instance _4097 r90 *1 298.535,113.945 nfet_05v0
XM_4097 n_I142 n_31 n_5 VSS nfet_05v0 L=0.6U W=2U AS=1.46P AD=1.46P PS=5.46U
+ PD=5.46U
* device instance _4098 r90 *1 378.535,191.945 nfet_05v0
XM_4098 n_I141 n_99 n_5 VSS nfet_05v0 L=0.6U W=2U AS=1.46P AD=1.46P PS=5.46U
+ PD=5.46U
* device instance _4099 r90 *1 418.535,191.945 nfet_05v0
XM_4099 n_I140 n_101 n_5 VSS nfet_05v0 L=0.6U W=2U AS=1.46P AD=1.46P PS=5.46U
+ PD=5.46U
* device instance _4100 r90 *1 98.535,191.945 nfet_05v0
XM_4100 n_I139 n_85 n_5 VSS nfet_05v0 L=0.6U W=2U AS=1.46P AD=1.46P PS=5.46U
+ PD=5.46U
* device instance _4101 r90 *1 498.535,191.945 nfet_05v0
XM_4101 n_I138 n_105 n_5 VSS nfet_05v0 L=0.6U W=2U AS=1.46P AD=1.46P PS=5.46U
+ PD=5.46U
* device instance _4102 r90 *1 498.535,581.945 nfet_05v0
XM_4102 n_I137 n_276 n_5 VSS nfet_05v0 L=0.6U W=2U AS=1.46P AD=1.46P PS=5.46U
+ PD=5.46U
* device instance _4103 r90 *1 458.535,581.945 nfet_05v0
XM_4103 n_I136 n_275 n_5 VSS nfet_05v0 L=0.6U W=2U AS=1.46P AD=1.46P PS=5.46U
+ PD=5.46U
* device instance _4104 r90 *1 418.535,35.945 nfet_05v0
XM_4104 n_I135 n_15 n_5 VSS nfet_05v0 L=0.6U W=2U AS=1.46P AD=1.46P PS=5.46U
+ PD=5.46U
* device instance _4105 r90 *1 418.535,581.945 nfet_05v0
XM_4105 n_I134 n_274 n_5 VSS nfet_05v0 L=0.6U W=2U AS=1.46P AD=1.46P PS=5.46U
+ PD=5.46U
* device instance _4106 r90 *1 298.535,35.945 nfet_05v0
XM_4106 n_I133 n_12 n_5 VSS nfet_05v0 L=0.6U W=2U AS=1.46P AD=1.46P PS=5.46U
+ PD=5.46U
* device instance _4107 r90 *1 218.535,191.945 nfet_05v0
XM_4107 n_I132 n_91 n_5 VSS nfet_05v0 L=0.6U W=2U AS=1.46P AD=1.46P PS=5.46U
+ PD=5.46U
* device instance _4108 r90 *1 498.535,35.945 nfet_05v0
XM_4108 n_I131 n_17 n_5 VSS nfet_05v0 L=0.6U W=2U AS=1.46P AD=1.46P PS=5.46U
+ PD=5.46U
* device instance _4109 r90 *1 458.535,191.945 nfet_05v0
XM_4109 n_I130 n_103 n_5 VSS nfet_05v0 L=0.6U W=2U AS=1.46P AD=1.46P PS=5.46U
+ PD=5.46U
* device instance _4110 r90 *1 55.025,35.915 pfet_05v0
XM_4110 n_I257 n_I4525 n_5 VDD_DEC pfet_05v0 L=0.5U W=6U AS=3.14P AD=3.14P
+ PS=11.14U PD=11.14U
* device instance _4113 r90 *1 255.025,581.915 pfet_05v0
XM_4113 n_I256 n_I4526 n_5 VDD_DEC pfet_05v0 L=0.5U W=6U AS=3.14P AD=3.14P
+ PS=11.14U PD=11.14U
* device instance _4116 r90 *1 535.025,35.915 pfet_05v0
XM_4116 n_I255 n_I4527 n_5 VDD_DEC pfet_05v0 L=0.5U W=6U AS=3.14P AD=3.14P
+ PS=11.14U PD=11.14U
* device instance _4119 r90 *1 175.025,113.915 pfet_05v0
XM_4119 n_I254 n_I4528 n_5 VDD_DEC pfet_05v0 L=0.5U W=6U AS=3.14P AD=3.14P
+ PS=11.14U PD=11.14U
* device instance _4122 r90 *1 215.025,425.915 pfet_05v0
XM_4122 n_I253 n_I4529 n_5 VDD_DEC pfet_05v0 L=0.5U W=6U AS=3.14P AD=3.14P
+ PS=11.14U PD=11.14U
* device instance _4125 r90 *1 175.025,35.915 pfet_05v0
XM_4125 n_I252 n_I4530 n_5 VDD_DEC pfet_05v0 L=0.5U W=6U AS=3.14P AD=3.14P
+ PS=11.14U PD=11.14U
* device instance _4128 r90 *1 295.025,581.915 pfet_05v0
XM_4128 n_I251 n_I4531 n_5 VDD_DEC pfet_05v0 L=0.5U W=6U AS=3.14P AD=3.14P
+ PS=11.14U PD=11.14U
* device instance _4131 r90 *1 95.025,581.915 pfet_05v0
XM_4131 n_I250 n_I4532 n_5 VDD_DEC pfet_05v0 L=0.5U W=6U AS=3.14P AD=3.14P
+ PS=11.14U PD=11.14U
* device instance _4134 r90 *1 255.025,347.915 pfet_05v0
XM_4134 n_I249 n_I4533 n_5 VDD_DEC pfet_05v0 L=0.5U W=6U AS=3.14P AD=3.14P
+ PS=11.14U PD=11.14U
* device instance _4137 r90 *1 615.025,35.915 pfet_05v0
XM_4137 n_I248 n_I4534 n_5 VDD_DEC pfet_05v0 L=0.5U W=6U AS=3.14P AD=3.14P
+ PS=11.14U PD=11.14U
* device instance _4140 r90 *1 175.025,425.915 pfet_05v0
XM_4140 n_I247 n_I4535 n_5 VDD_DEC pfet_05v0 L=0.5U W=6U AS=3.14P AD=3.14P
+ PS=11.14U PD=11.14U
* device instance _4143 r90 *1 455.025,113.915 pfet_05v0
XM_4143 n_I246 n_I4536 n_5 VDD_DEC pfet_05v0 L=0.5U W=6U AS=3.14P AD=3.14P
+ PS=11.14U PD=11.14U
* device instance _4146 r90 *1 495.025,113.915 pfet_05v0
XM_4146 n_I245 n_I4537 n_5 VDD_DEC pfet_05v0 L=0.5U W=6U AS=3.14P AD=3.14P
+ PS=11.14U PD=11.14U
* device instance _4149 r90 *1 615.025,191.915 pfet_05v0
XM_4149 n_I244 n_I4538 n_5 VDD_DEC pfet_05v0 L=0.5U W=6U AS=3.14P AD=3.14P
+ PS=11.14U PD=11.14U
* device instance _4152 r90 *1 655.025,191.915 pfet_05v0
XM_4152 n_I243 n_I4539 n_5 VDD_DEC pfet_05v0 L=0.5U W=6U AS=3.14P AD=3.14P
+ PS=11.14U PD=11.14U
* device instance _4155 r90 *1 535.025,191.915 pfet_05v0
XM_4155 n_I242 n_I4540 n_5 VDD_DEC pfet_05v0 L=0.5U W=6U AS=3.14P AD=3.14P
+ PS=11.14U PD=11.14U
* device instance _4158 r90 *1 575.025,191.915 pfet_05v0
XM_4158 n_I241 n_I4541 n_5 VDD_DEC pfet_05v0 L=0.5U W=6U AS=3.14P AD=3.14P
+ PS=11.14U PD=11.14U
* device instance _4161 r90 *1 535.025,113.915 pfet_05v0
XM_4161 n_I240 n_I4542 n_5 VDD_DEC pfet_05v0 L=0.5U W=6U AS=3.14P AD=3.14P
+ PS=11.14U PD=11.14U
* device instance _4164 r90 *1 575.025,113.915 pfet_05v0
XM_4164 n_I239 n_I4543 n_5 VDD_DEC pfet_05v0 L=0.5U W=6U AS=3.14P AD=3.14P
+ PS=11.14U PD=11.14U
* device instance _4167 r90 *1 95.025,347.915 pfet_05v0
XM_4167 n_I238 n_I4544 n_5 VDD_DEC pfet_05v0 L=0.5U W=6U AS=3.14P AD=3.14P
+ PS=11.14U PD=11.14U
* device instance _4170 r90 *1 575.025,35.915 pfet_05v0
XM_4170 n_I237 n_I4545 n_5 VDD_DEC pfet_05v0 L=0.5U W=6U AS=3.14P AD=3.14P
+ PS=11.14U PD=11.14U
* device instance _4173 r90 *1 415.025,113.915 pfet_05v0
XM_4173 n_I236 n_I4546 n_5 VDD_DEC pfet_05v0 L=0.5U W=6U AS=3.14P AD=3.14P
+ PS=11.14U PD=11.14U
* device instance _4176 r90 *1 655.025,113.915 pfet_05v0
XM_4176 n_I235 n_I4547 n_5 VDD_DEC pfet_05v0 L=0.5U W=6U AS=3.14P AD=3.14P
+ PS=11.14U PD=11.14U
* device instance _4179 r90 *1 655.025,35.915 pfet_05v0
XM_4179 n_I234 n_I4548 n_5 VDD_DEC pfet_05v0 L=0.5U W=6U AS=3.14P AD=3.14P
+ PS=11.14U PD=11.14U
* device instance _4182 r90 *1 55.025,425.915 pfet_05v0
XM_4182 n_I233 n_I4549 n_5 VDD_DEC pfet_05v0 L=0.5U W=6U AS=3.14P AD=3.14P
+ PS=11.14U PD=11.14U
* device instance _4185 r90 *1 375.025,113.915 pfet_05v0
XM_4185 n_I232 n_I4550 n_5 VDD_DEC pfet_05v0 L=0.5U W=6U AS=3.14P AD=3.14P
+ PS=11.14U PD=11.14U
* device instance _4188 r90 *1 215.025,347.915 pfet_05v0
XM_4188 n_I231 n_I4551 n_5 VDD_DEC pfet_05v0 L=0.5U W=6U AS=3.14P AD=3.14P
+ PS=11.14U PD=11.14U
* device instance _4191 r90 *1 295.025,425.915 pfet_05v0
XM_4191 n_I230 n_I4552 n_5 VDD_DEC pfet_05v0 L=0.5U W=6U AS=3.14P AD=3.14P
+ PS=11.14U PD=11.14U
* device instance _4194 r90 *1 335.025,581.915 pfet_05v0
XM_4194 n_I229 n_I4553 n_5 VDD_DEC pfet_05v0 L=0.5U W=6U AS=3.14P AD=3.14P
+ PS=11.14U PD=11.14U
* device instance _4197 r90 *1 255.025,425.915 pfet_05v0
XM_4197 n_I228 n_I4554 n_5 VDD_DEC pfet_05v0 L=0.5U W=6U AS=3.14P AD=3.14P
+ PS=11.14U PD=11.14U
* device instance _4200 r90 *1 295.025,347.915 pfet_05v0
XM_4200 n_I227 n_I4555 n_5 VDD_DEC pfet_05v0 L=0.5U W=6U AS=3.14P AD=3.14P
+ PS=11.14U PD=11.14U
* device instance _4203 r90 *1 615.025,113.915 pfet_05v0
XM_4203 n_I226 n_I4556 n_5 VDD_DEC pfet_05v0 L=0.5U W=6U AS=3.14P AD=3.14P
+ PS=11.14U PD=11.14U
* device instance _4206 r90 *1 335.025,425.915 pfet_05v0
XM_4206 n_I225 n_I4557 n_5 VDD_DEC pfet_05v0 L=0.5U W=6U AS=3.14P AD=3.14P
+ PS=11.14U PD=11.14U
* device instance _4209 r90 *1 175.025,347.915 pfet_05v0
XM_4209 n_I224 n_I4558 n_5 VDD_DEC pfet_05v0 L=0.5U W=6U AS=3.14P AD=3.14P
+ PS=11.14U PD=11.14U
* device instance _4212 r90 *1 335.025,347.915 pfet_05v0
XM_4212 n_I223 n_I4559 n_5 VDD_DEC pfet_05v0 L=0.5U W=6U AS=3.14P AD=3.14P
+ PS=11.14U PD=11.14U
* device instance _4215 r90 *1 335.025,269.915 pfet_05v0
XM_4215 n_I222 n_I4560 n_5 VDD_DEC pfet_05v0 L=0.5U W=6U AS=3.14P AD=3.14P
+ PS=11.14U PD=11.14U
* device instance _4218 r90 *1 335.025,191.915 pfet_05v0
XM_4218 n_I221 n_I4561 n_5 VDD_DEC pfet_05v0 L=0.5U W=6U AS=3.14P AD=3.14P
+ PS=11.14U PD=11.14U
* device instance _4221 r90 *1 335.025,113.915 pfet_05v0
XM_4221 n_I220 n_I4562 n_5 VDD_DEC pfet_05v0 L=0.5U W=6U AS=3.14P AD=3.14P
+ PS=11.14U PD=11.14U
* device instance _4224 r90 *1 335.025,35.915 pfet_05v0
XM_4224 n_I219 n_I4563 n_5 VDD_DEC pfet_05v0 L=0.5U W=6U AS=3.14P AD=3.14P
+ PS=11.14U PD=11.14U
* device instance _4227 r90 *1 175.025,269.915 pfet_05v0
XM_4227 n_I218 n_I4564 n_5 VDD_DEC pfet_05v0 L=0.5U W=6U AS=3.14P AD=3.14P
+ PS=11.14U PD=11.14U
* device instance _4230 r90 *1 175.025,191.915 pfet_05v0
XM_4230 n_I217 n_I4565 n_5 VDD_DEC pfet_05v0 L=0.5U W=6U AS=3.14P AD=3.14P
+ PS=11.14U PD=11.14U
* device instance _4233 r90 *1 215.025,581.915 pfet_05v0
XM_4233 n_I216 n_I4566 n_5 VDD_DEC pfet_05v0 L=0.5U W=6U AS=3.14P AD=3.14P
+ PS=11.14U PD=11.14U
* device instance _4236 r90 *1 375.025,503.915 pfet_05v0
XM_4236 n_I215 n_I4567 n_5 VDD_DEC pfet_05v0 L=0.5U W=6U AS=3.14P AD=3.14P
+ PS=11.14U PD=11.14U
* device instance _4239 r90 *1 415.025,503.915 pfet_05v0
XM_4239 n_I214 n_I4568 n_5 VDD_DEC pfet_05v0 L=0.5U W=6U AS=3.14P AD=3.14P
+ PS=11.14U PD=11.14U
* device instance _4242 r90 *1 455.025,503.915 pfet_05v0
XM_4242 n_I213 n_I4569 n_5 VDD_DEC pfet_05v0 L=0.5U W=6U AS=3.14P AD=3.14P
+ PS=11.14U PD=11.14U
* device instance _4245 r90 *1 495.025,503.915 pfet_05v0
XM_4245 n_I212 n_I4570 n_5 VDD_DEC pfet_05v0 L=0.5U W=6U AS=3.14P AD=3.14P
+ PS=11.14U PD=11.14U
* device instance _4248 r90 *1 655.025,503.915 pfet_05v0
XM_4248 n_I211 n_I4571 n_5 VDD_DEC pfet_05v0 L=0.5U W=6U AS=3.14P AD=3.14P
+ PS=11.14U PD=11.14U
* device instance _4251 r90 *1 55.025,347.915 pfet_05v0
XM_4251 n_I210 n_I4572 n_5 VDD_DEC pfet_05v0 L=0.5U W=6U AS=3.14P AD=3.14P
+ PS=11.14U PD=11.14U
* device instance _4254 r90 *1 575.025,503.915 pfet_05v0
XM_4254 n_I209 n_I4573 n_5 VDD_DEC pfet_05v0 L=0.5U W=6U AS=3.14P AD=3.14P
+ PS=11.14U PD=11.14U
* device instance _4257 r90 *1 615.025,503.915 pfet_05v0
XM_4257 n_I208 n_I4574 n_5 VDD_DEC pfet_05v0 L=0.5U W=6U AS=3.14P AD=3.14P
+ PS=11.14U PD=11.14U
* device instance _4260 r90 *1 175.025,503.915 pfet_05v0
XM_4260 n_I207 n_I4575 n_5 VDD_DEC pfet_05v0 L=0.5U W=6U AS=3.14P AD=3.14P
+ PS=11.14U PD=11.14U
* device instance _4263 r90 *1 215.025,269.915 pfet_05v0
XM_4263 n_I206 n_I4576 n_5 VDD_DEC pfet_05v0 L=0.5U W=6U AS=3.14P AD=3.14P
+ PS=11.14U PD=11.14U
* device instance _4266 r90 *1 95.025,503.915 pfet_05v0
XM_4266 n_I205 n_I4577 n_5 VDD_DEC pfet_05v0 L=0.5U W=6U AS=3.14P AD=3.14P
+ PS=11.14U PD=11.14U
* device instance _4269 r90 *1 135.025,503.915 pfet_05v0
XM_4269 n_I204 n_I4578 n_5 VDD_DEC pfet_05v0 L=0.5U W=6U AS=3.14P AD=3.14P
+ PS=11.14U PD=11.14U
* device instance _4272 r90 *1 55.025,503.915 pfet_05v0
XM_4272 n_I203 n_I4579 n_5 VDD_DEC pfet_05v0 L=0.5U W=6U AS=3.14P AD=3.14P
+ PS=11.14U PD=11.14U
* device instance _4275 r90 *1 215.025,503.915 pfet_05v0
XM_4275 n_I202 n_I4580 n_5 VDD_DEC pfet_05v0 L=0.5U W=6U AS=3.14P AD=3.14P
+ PS=11.14U PD=11.14U
* device instance _4278 r90 *1 255.025,503.915 pfet_05v0
XM_4278 n_I201 n_I4581 n_5 VDD_DEC pfet_05v0 L=0.5U W=6U AS=3.14P AD=3.14P
+ PS=11.14U PD=11.14U
* device instance _4281 r90 *1 295.025,503.915 pfet_05v0
XM_4281 n_I200 n_I4582 n_5 VDD_DEC pfet_05v0 L=0.5U W=6U AS=3.14P AD=3.14P
+ PS=11.14U PD=11.14U
* device instance _4284 r90 *1 255.025,269.915 pfet_05v0
XM_4284 n_I199 n_I4583 n_5 VDD_DEC pfet_05v0 L=0.5U W=6U AS=3.14P AD=3.14P
+ PS=11.14U PD=11.14U
* device instance _4287 r90 *1 295.025,269.915 pfet_05v0
XM_4287 n_I198 n_I4584 n_5 VDD_DEC pfet_05v0 L=0.5U W=6U AS=3.14P AD=3.14P
+ PS=11.14U PD=11.14U
* device instance _4290 r90 *1 95.025,269.915 pfet_05v0
XM_4290 n_I197 n_I4585 n_5 VDD_DEC pfet_05v0 L=0.5U W=6U AS=3.14P AD=3.14P
+ PS=11.14U PD=11.14U
* device instance _4293 r90 *1 135.025,269.915 pfet_05v0
XM_4293 n_I196 n_I4586 n_5 VDD_DEC pfet_05v0 L=0.5U W=6U AS=3.14P AD=3.14P
+ PS=11.14U PD=11.14U
* device instance _4296 r90 *1 55.025,269.915 pfet_05v0
XM_4296 n_I195 n_I4587 n_5 VDD_DEC pfet_05v0 L=0.5U W=6U AS=3.14P AD=3.14P
+ PS=11.14U PD=11.14U
* device instance _4299 r90 *1 535.025,503.915 pfet_05v0
XM_4299 n_I194 n_I4588 n_5 VDD_DEC pfet_05v0 L=0.5U W=6U AS=3.14P AD=3.14P
+ PS=11.14U PD=11.14U
* device instance _4302 r90 *1 495.025,347.915 pfet_05v0
XM_4302 n_I193 n_I4589 n_5 VDD_DEC pfet_05v0 L=0.5U W=6U AS=3.14P AD=3.14P
+ PS=11.14U PD=11.14U
* device instance _4305 r90 *1 215.025,35.915 pfet_05v0
XM_4305 n_I192 n_I4590 n_5 VDD_DEC pfet_05v0 L=0.5U W=6U AS=3.14P AD=3.14P
+ PS=11.14U PD=11.14U
* device instance _4308 r90 *1 455.025,347.915 pfet_05v0
XM_4308 n_I191 n_I4591 n_5 VDD_DEC pfet_05v0 L=0.5U W=6U AS=3.14P AD=3.14P
+ PS=11.14U PD=11.14U
* device instance _4311 r90 *1 375.025,581.915 pfet_05v0
XM_4311 n_I190 n_I4592 n_5 VDD_DEC pfet_05v0 L=0.5U W=6U AS=3.14P AD=3.14P
+ PS=11.14U PD=11.14U
* device instance _4314 r90 *1 415.025,347.915 pfet_05v0
XM_4314 n_I189 n_I4593 n_5 VDD_DEC pfet_05v0 L=0.5U W=6U AS=3.14P AD=3.14P
+ PS=11.14U PD=11.14U
* device instance _4317 r90 *1 495.025,425.915 pfet_05v0
XM_4317 n_I188 n_I4594 n_5 VDD_DEC pfet_05v0 L=0.5U W=6U AS=3.14P AD=3.14P
+ PS=11.14U PD=11.14U
* device instance _4320 r90 *1 375.025,347.915 pfet_05v0
XM_4320 n_I187 n_I4595 n_5 VDD_DEC pfet_05v0 L=0.5U W=6U AS=3.14P AD=3.14P
+ PS=11.14U PD=11.14U
* device instance _4323 r90 *1 375.025,425.915 pfet_05v0
XM_4323 n_I186 n_I4596 n_5 VDD_DEC pfet_05v0 L=0.5U W=6U AS=3.14P AD=3.14P
+ PS=11.14U PD=11.14U
* device instance _4326 r90 *1 455.025,425.915 pfet_05v0
XM_4326 n_I185 n_I4597 n_5 VDD_DEC pfet_05v0 L=0.5U W=6U AS=3.14P AD=3.14P
+ PS=11.14U PD=11.14U
* device instance _4329 r90 *1 255.025,35.915 pfet_05v0
XM_4329 n_I184 n_I4598 n_5 VDD_DEC pfet_05v0 L=0.5U W=6U AS=3.14P AD=3.14P
+ PS=11.14U PD=11.14U
* device instance _4332 r90 *1 415.025,425.915 pfet_05v0
XM_4332 n_I183 n_I4599 n_5 VDD_DEC pfet_05v0 L=0.5U W=6U AS=3.14P AD=3.14P
+ PS=11.14U PD=11.14U
* device instance _4335 r90 *1 615.025,425.915 pfet_05v0
XM_4335 n_I182 n_I4600 n_5 VDD_DEC pfet_05v0 L=0.5U W=6U AS=3.14P AD=3.14P
+ PS=11.14U PD=11.14U
* device instance _4338 r90 *1 575.025,425.915 pfet_05v0
XM_4338 n_I181 n_I4601 n_5 VDD_DEC pfet_05v0 L=0.5U W=6U AS=3.14P AD=3.14P
+ PS=11.14U PD=11.14U
* device instance _4341 r90 *1 615.025,347.915 pfet_05v0
XM_4341 n_I180 n_I4602 n_5 VDD_DEC pfet_05v0 L=0.5U W=6U AS=3.14P AD=3.14P
+ PS=11.14U PD=11.14U
* device instance _4344 r90 *1 615.025,581.915 pfet_05v0
XM_4344 n_I179 n_I4603 n_5 VDD_DEC pfet_05v0 L=0.5U W=6U AS=3.14P AD=3.14P
+ PS=11.14U PD=11.14U
* device instance _4347 r90 *1 335.025,503.915 pfet_05v0
XM_4347 n_I178 n_I4604 n_5 VDD_DEC pfet_05v0 L=0.5U W=6U AS=3.14P AD=3.14P
+ PS=11.14U PD=11.14U
* device instance _4350 r90 *1 535.025,347.915 pfet_05v0
XM_4350 n_I177 n_I4605 n_5 VDD_DEC pfet_05v0 L=0.5U W=6U AS=3.14P AD=3.14P
+ PS=11.14U PD=11.14U
* device instance _4353 r90 *1 575.025,581.915 pfet_05v0
XM_4353 n_I176 n_I4606 n_5 VDD_DEC pfet_05v0 L=0.5U W=6U AS=3.14P AD=3.14P
+ PS=11.14U PD=11.14U
* device instance _4356 r90 *1 655.025,581.915 pfet_05v0
XM_4356 n_I175 n_I4607 n_5 VDD_DEC pfet_05v0 L=0.5U W=6U AS=3.14P AD=3.14P
+ PS=11.14U PD=11.14U
* device instance _4359 r90 *1 575.025,269.915 pfet_05v0
XM_4359 n_I174 n_I4608 n_5 VDD_DEC pfet_05v0 L=0.5U W=6U AS=3.14P AD=3.14P
+ PS=11.14U PD=11.14U
* device instance _4362 r90 *1 615.025,269.915 pfet_05v0
XM_4362 n_I173 n_I4609 n_5 VDD_DEC pfet_05v0 L=0.5U W=6U AS=3.14P AD=3.14P
+ PS=11.14U PD=11.14U
* device instance _4365 r90 *1 655.025,269.915 pfet_05v0
XM_4365 n_I172 n_I4610 n_5 VDD_DEC pfet_05v0 L=0.5U W=6U AS=3.14P AD=3.14P
+ PS=11.14U PD=11.14U
* device instance _4368 r90 *1 575.025,347.915 pfet_05v0
XM_4368 n_I171 n_I4611 n_5 VDD_DEC pfet_05v0 L=0.5U W=6U AS=3.14P AD=3.14P
+ PS=11.14U PD=11.14U
* device instance _4371 r90 *1 535.025,425.915 pfet_05v0
XM_4371 n_I170 n_I4612 n_5 VDD_DEC pfet_05v0 L=0.5U W=6U AS=3.14P AD=3.14P
+ PS=11.14U PD=11.14U
* device instance _4374 r90 *1 535.025,269.915 pfet_05v0
XM_4374 n_I169 n_I4613 n_5 VDD_DEC pfet_05v0 L=0.5U W=6U AS=3.14P AD=3.14P
+ PS=11.14U PD=11.14U
* device instance _4377 r90 *1 495.025,269.915 pfet_05v0
XM_4377 n_I168 n_I4614 n_5 VDD_DEC pfet_05v0 L=0.5U W=6U AS=3.14P AD=3.14P
+ PS=11.14U PD=11.14U
* device instance _4380 r90 *1 455.025,269.915 pfet_05v0
XM_4380 n_I167 n_I4615 n_5 VDD_DEC pfet_05v0 L=0.5U W=6U AS=3.14P AD=3.14P
+ PS=11.14U PD=11.14U
* device instance _4383 r90 *1 375.025,269.915 pfet_05v0
XM_4383 n_I166 n_I4616 n_5 VDD_DEC pfet_05v0 L=0.5U W=6U AS=3.14P AD=3.14P
+ PS=11.14U PD=11.14U
* device instance _4386 r90 *1 415.025,269.915 pfet_05v0
XM_4386 n_I165 n_I4617 n_5 VDD_DEC pfet_05v0 L=0.5U W=6U AS=3.14P AD=3.14P
+ PS=11.14U PD=11.14U
* device instance _4389 r90 *1 655.025,425.915 pfet_05v0
XM_4389 n_I164 n_I4618 n_5 VDD_DEC pfet_05v0 L=0.5U W=6U AS=3.14P AD=3.14P
+ PS=11.14U PD=11.14U
* device instance _4392 r90 *1 655.025,347.915 pfet_05v0
XM_4392 n_I163 n_I4619 n_5 VDD_DEC pfet_05v0 L=0.5U W=6U AS=3.14P AD=3.14P
+ PS=11.14U PD=11.14U
* device instance _4395 r90 *1 535.025,581.915 pfet_05v0
XM_4395 n_I162 n_I4620 n_5 VDD_DEC pfet_05v0 L=0.5U W=6U AS=3.14P AD=3.14P
+ PS=11.14U PD=11.14U
* device instance _4398 r90 *1 95.025,425.915 pfet_05v0
XM_4398 n_I161 n_I4621 n_5 VDD_DEC pfet_05v0 L=0.5U W=6U AS=3.14P AD=3.14P
+ PS=11.14U PD=11.14U
* device instance _4401 r90 *1 375.025,35.915 pfet_05v0
XM_4401 n_I160 n_I4622 n_5 VDD_DEC pfet_05v0 L=0.5U W=6U AS=3.14P AD=3.14P
+ PS=11.14U PD=11.14U
* device instance _4404 r90 *1 135.025,581.915 pfet_05v0
XM_4404 n_I159 n_I4623 n_5 VDD_DEC pfet_05v0 L=0.5U W=6U AS=3.14P AD=3.14P
+ PS=11.14U PD=11.14U
* device instance _4407 r90 *1 55.025,581.915 pfet_05v0
XM_4407 n_I158 n_I4624 n_5 VDD_DEC pfet_05v0 L=0.5U W=6U AS=3.14P AD=3.14P
+ PS=11.14U PD=11.14U
* device instance _4410 r90 *1 135.025,347.915 pfet_05v0
XM_4410 n_I157 n_I4625 n_5 VDD_DEC pfet_05v0 L=0.5U W=6U AS=3.14P AD=3.14P
+ PS=11.14U PD=11.14U
* device instance _4413 r90 *1 135.025,425.915 pfet_05v0
XM_4413 n_I156 n_I4626 n_5 VDD_DEC pfet_05v0 L=0.5U W=6U AS=3.14P AD=3.14P
+ PS=11.14U PD=11.14U
* device instance _4416 r90 *1 55.025,113.915 pfet_05v0
XM_4416 n_I155 n_I4627 n_5 VDD_DEC pfet_05v0 L=0.5U W=6U AS=3.14P AD=3.14P
+ PS=11.14U PD=11.14U
* device instance _4419 r90 *1 95.025,113.915 pfet_05v0
XM_4419 n_I154 n_I4628 n_5 VDD_DEC pfet_05v0 L=0.5U W=6U AS=3.14P AD=3.14P
+ PS=11.14U PD=11.14U
* device instance _4422 r90 *1 135.025,113.915 pfet_05v0
XM_4422 n_I153 n_I4629 n_5 VDD_DEC pfet_05v0 L=0.5U W=6U AS=3.14P AD=3.14P
+ PS=11.14U PD=11.14U
* device instance _4425 r90 *1 95.025,35.915 pfet_05v0
XM_4425 n_I152 n_I4630 n_5 VDD_DEC pfet_05v0 L=0.5U W=6U AS=3.14P AD=3.14P
+ PS=11.14U PD=11.14U
* device instance _4428 r90 *1 455.025,35.915 pfet_05v0
XM_4428 n_I151 n_I4631 n_5 VDD_DEC pfet_05v0 L=0.5U W=6U AS=3.14P AD=3.14P
+ PS=11.14U PD=11.14U
* device instance _4431 r90 *1 135.025,35.915 pfet_05v0
XM_4431 n_I150 n_I4632 n_5 VDD_DEC pfet_05v0 L=0.5U W=6U AS=3.14P AD=3.14P
+ PS=11.14U PD=11.14U
* device instance _4434 r90 *1 135.025,191.915 pfet_05v0
XM_4434 n_I149 n_I4633 n_5 VDD_DEC pfet_05v0 L=0.5U W=6U AS=3.14P AD=3.14P
+ PS=11.14U PD=11.14U
* device instance _4437 r90 *1 55.025,191.915 pfet_05v0
XM_4437 n_I148 n_I4634 n_5 VDD_DEC pfet_05v0 L=0.5U W=6U AS=3.14P AD=3.14P
+ PS=11.14U PD=11.14U
* device instance _4440 r90 *1 255.025,191.915 pfet_05v0
XM_4440 n_I147 n_I4635 n_5 VDD_DEC pfet_05v0 L=0.5U W=6U AS=3.14P AD=3.14P
+ PS=11.14U PD=11.14U
* device instance _4443 r90 *1 215.025,113.915 pfet_05v0
XM_4443 n_I146 n_I4636 n_5 VDD_DEC pfet_05v0 L=0.5U W=6U AS=3.14P AD=3.14P
+ PS=11.14U PD=11.14U
* device instance _4446 r90 *1 255.025,113.915 pfet_05v0
XM_4446 n_I145 n_I4637 n_5 VDD_DEC pfet_05v0 L=0.5U W=6U AS=3.14P AD=3.14P
+ PS=11.14U PD=11.14U
* device instance _4449 r90 *1 175.025,581.915 pfet_05v0
XM_4449 n_I144 n_I4638 n_5 VDD_DEC pfet_05v0 L=0.5U W=6U AS=3.14P AD=3.14P
+ PS=11.14U PD=11.14U
* device instance _4452 r90 *1 295.025,191.915 pfet_05v0
XM_4452 n_I143 n_I4639 n_5 VDD_DEC pfet_05v0 L=0.5U W=6U AS=3.14P AD=3.14P
+ PS=11.14U PD=11.14U
* device instance _4455 r90 *1 295.025,113.915 pfet_05v0
XM_4455 n_I142 n_I4640 n_5 VDD_DEC pfet_05v0 L=0.5U W=6U AS=3.14P AD=3.14P
+ PS=11.14U PD=11.14U
* device instance _4458 r90 *1 375.025,191.915 pfet_05v0
XM_4458 n_I141 n_I4641 n_5 VDD_DEC pfet_05v0 L=0.5U W=6U AS=3.14P AD=3.14P
+ PS=11.14U PD=11.14U
* device instance _4461 r90 *1 415.025,191.915 pfet_05v0
XM_4461 n_I140 n_I4642 n_5 VDD_DEC pfet_05v0 L=0.5U W=6U AS=3.14P AD=3.14P
+ PS=11.14U PD=11.14U
* device instance _4464 r90 *1 95.025,191.915 pfet_05v0
XM_4464 n_I139 n_I4643 n_5 VDD_DEC pfet_05v0 L=0.5U W=6U AS=3.14P AD=3.14P
+ PS=11.14U PD=11.14U
* device instance _4467 r90 *1 495.025,191.915 pfet_05v0
XM_4467 n_I138 n_I4644 n_5 VDD_DEC pfet_05v0 L=0.5U W=6U AS=3.14P AD=3.14P
+ PS=11.14U PD=11.14U
* device instance _4470 r90 *1 495.025,581.915 pfet_05v0
XM_4470 n_I137 n_I4645 n_5 VDD_DEC pfet_05v0 L=0.5U W=6U AS=3.14P AD=3.14P
+ PS=11.14U PD=11.14U
* device instance _4473 r90 *1 455.025,581.915 pfet_05v0
XM_4473 n_I136 n_I4646 n_5 VDD_DEC pfet_05v0 L=0.5U W=6U AS=3.14P AD=3.14P
+ PS=11.14U PD=11.14U
* device instance _4476 r90 *1 415.025,35.915 pfet_05v0
XM_4476 n_I135 n_I4647 n_5 VDD_DEC pfet_05v0 L=0.5U W=6U AS=3.14P AD=3.14P
+ PS=11.14U PD=11.14U
* device instance _4479 r90 *1 415.025,581.915 pfet_05v0
XM_4479 n_I134 n_I4648 n_5 VDD_DEC pfet_05v0 L=0.5U W=6U AS=3.14P AD=3.14P
+ PS=11.14U PD=11.14U
* device instance _4482 r90 *1 295.025,35.915 pfet_05v0
XM_4482 n_I133 n_I4649 n_5 VDD_DEC pfet_05v0 L=0.5U W=6U AS=3.14P AD=3.14P
+ PS=11.14U PD=11.14U
* device instance _4485 r90 *1 215.025,191.915 pfet_05v0
XM_4485 n_I132 n_I4650 n_5 VDD_DEC pfet_05v0 L=0.5U W=6U AS=3.14P AD=3.14P
+ PS=11.14U PD=11.14U
* device instance _4488 r90 *1 495.025,35.915 pfet_05v0
XM_4488 n_I131 n_I4651 n_5 VDD_DEC pfet_05v0 L=0.5U W=6U AS=3.14P AD=3.14P
+ PS=11.14U PD=11.14U
* device instance _4491 r90 *1 455.025,191.915 pfet_05v0
XM_4491 n_I130 n_I4652 n_5 VDD_DEC pfet_05v0 L=0.5U W=6U AS=3.14P AD=3.14P
+ PS=11.14U PD=11.14U
* device instance _4494 r0 *1 58.565,39.94 nfet_05v0
XM_4494 VSS n_6 n_I4525 VSS nfet_05v0 L=0.6U W=1U AS=0.73P AD=0.73P PS=3.46U
+ PD=3.46U
* device instance _4495 r0 *1 258.565,585.94 nfet_05v0
XM_4495 VSS n_270 n_I4526 VSS nfet_05v0 L=0.6U W=1U AS=0.73P AD=0.73P PS=3.46U
+ PD=3.46U
* device instance _4496 r0 *1 538.565,39.94 nfet_05v0
XM_4496 VSS n_18 n_I4527 VSS nfet_05v0 L=0.6U W=1U AS=0.73P AD=0.73P PS=3.46U
+ PD=3.46U
* device instance _4497 r0 *1 178.565,117.94 nfet_05v0
XM_4497 VSS n_28 n_I4528 VSS nfet_05v0 L=0.6U W=1U AS=0.73P AD=0.73P PS=3.46U
+ PD=3.46U
* device instance _4498 r0 *1 218.565,429.94 nfet_05v0
XM_4498 VSS n_158 n_I4529 VSS nfet_05v0 L=0.6U W=1U AS=0.73P AD=0.73P PS=3.46U
+ PD=3.46U
* device instance _4499 r0 *1 178.565,39.94 nfet_05v0
XM_4499 VSS n_9 n_I4530 VSS nfet_05v0 L=0.6U W=1U AS=0.73P AD=0.73P PS=3.46U
+ PD=3.46U
* device instance _4500 r0 *1 298.565,585.94 nfet_05v0
XM_4500 VSS n_271 n_I4531 VSS nfet_05v0 L=0.6U W=1U AS=0.73P AD=0.73P PS=3.46U
+ PD=3.46U
* device instance _4501 r0 *1 98.565,585.94 nfet_05v0
XM_4501 VSS n_266 n_I4532 VSS nfet_05v0 L=0.6U W=1U AS=0.73P AD=0.73P PS=3.46U
+ PD=3.46U
* device instance _4502 r0 *1 258.565,351.94 nfet_05v0
XM_4502 VSS n_162 n_I4533 VSS nfet_05v0 L=0.6U W=1U AS=0.73P AD=0.73P PS=3.46U
+ PD=3.46U
* device instance _4503 r0 *1 618.565,39.94 nfet_05v0
XM_4503 VSS n_20 n_I4534 VSS nfet_05v0 L=0.6U W=1U AS=0.73P AD=0.73P PS=3.46U
+ PD=3.46U
* device instance _4504 r0 *1 178.565,429.94 nfet_05v0
XM_4504 VSS n_155 n_I4535 VSS nfet_05v0 L=0.6U W=1U AS=0.73P AD=0.73P PS=3.46U
+ PD=3.46U
* device instance _4505 r0 *1 458.565,117.94 nfet_05v0
XM_4505 VSS n_35 n_I4536 VSS nfet_05v0 L=0.6U W=1U AS=0.73P AD=0.73P PS=3.46U
+ PD=3.46U
* device instance _4506 r0 *1 498.565,117.94 nfet_05v0
XM_4506 VSS n_36 n_I4537 VSS nfet_05v0 L=0.6U W=1U AS=0.73P AD=0.73P PS=3.46U
+ PD=3.46U
* device instance _4507 r0 *1 618.565,195.94 nfet_05v0
XM_4507 VSS n_111 n_I4538 VSS nfet_05v0 L=0.6U W=1U AS=0.73P AD=0.73P PS=3.46U
+ PD=3.46U
* device instance _4508 r0 *1 658.565,195.94 nfet_05v0
XM_4508 VSS n_113 n_I4539 VSS nfet_05v0 L=0.6U W=1U AS=0.73P AD=0.73P PS=3.46U
+ PD=3.46U
* device instance _4509 r0 *1 538.565,195.94 nfet_05v0
XM_4509 VSS n_107 n_I4540 VSS nfet_05v0 L=0.6U W=1U AS=0.73P AD=0.73P PS=3.46U
+ PD=3.46U
* device instance _4510 r0 *1 578.565,195.94 nfet_05v0
XM_4510 VSS n_109 n_I4541 VSS nfet_05v0 L=0.6U W=1U AS=0.73P AD=0.73P PS=3.46U
+ PD=3.46U
* device instance _4511 r0 *1 538.565,117.94 nfet_05v0
XM_4511 VSS n_37 n_I4542 VSS nfet_05v0 L=0.6U W=1U AS=0.73P AD=0.73P PS=3.46U
+ PD=3.46U
* device instance _4512 r0 *1 578.565,117.94 nfet_05v0
XM_4512 VSS n_38 n_I4543 VSS nfet_05v0 L=0.6U W=1U AS=0.73P AD=0.73P PS=3.46U
+ PD=3.46U
* device instance _4513 r0 *1 98.565,351.94 nfet_05v0
XM_4513 VSS n_150 n_I4544 VSS nfet_05v0 L=0.6U W=1U AS=0.73P AD=0.73P PS=3.46U
+ PD=3.46U
* device instance _4514 r0 *1 578.565,39.94 nfet_05v0
XM_4514 VSS n_19 n_I4545 VSS nfet_05v0 L=0.6U W=1U AS=0.73P AD=0.73P PS=3.46U
+ PD=3.46U
* device instance _4515 r0 *1 418.565,117.94 nfet_05v0
XM_4515 VSS n_34 n_I4546 VSS nfet_05v0 L=0.6U W=1U AS=0.73P AD=0.73P PS=3.46U
+ PD=3.46U
* device instance _4516 r0 *1 658.565,117.94 nfet_05v0
XM_4516 VSS n_40 n_I4547 VSS nfet_05v0 L=0.6U W=1U AS=0.73P AD=0.73P PS=3.46U
+ PD=3.46U
* device instance _4517 r0 *1 658.565,39.94 nfet_05v0
XM_4517 VSS n_21 n_I4548 VSS nfet_05v0 L=0.6U W=1U AS=0.73P AD=0.73P PS=3.46U
+ PD=3.46U
* device instance _4518 r0 *1 58.565,429.94 nfet_05v0
XM_4518 VSS n_146 n_I4549 VSS nfet_05v0 L=0.6U W=1U AS=0.73P AD=0.73P PS=3.46U
+ PD=3.46U
* device instance _4519 r0 *1 378.565,117.94 nfet_05v0
XM_4519 VSS n_33 n_I4550 VSS nfet_05v0 L=0.6U W=1U AS=0.73P AD=0.73P PS=3.46U
+ PD=3.46U
* device instance _4520 r0 *1 218.565,351.94 nfet_05v0
XM_4520 VSS n_159 n_I4551 VSS nfet_05v0 L=0.6U W=1U AS=0.73P AD=0.73P PS=3.46U
+ PD=3.46U
* device instance _4521 r0 *1 298.565,429.94 nfet_05v0
XM_4521 VSS n_164 n_I4552 VSS nfet_05v0 L=0.6U W=1U AS=0.73P AD=0.73P PS=3.46U
+ PD=3.46U
* device instance _4522 r0 *1 338.565,585.94 nfet_05v0
XM_4522 VSS n_272 n_I4553 VSS nfet_05v0 L=0.6U W=1U AS=0.73P AD=0.73P PS=3.46U
+ PD=3.46U
* device instance _4523 r0 *1 258.565,429.94 nfet_05v0
XM_4523 VSS n_161 n_I4554 VSS nfet_05v0 L=0.6U W=1U AS=0.73P AD=0.73P PS=3.46U
+ PD=3.46U
* device instance _4524 r0 *1 298.565,351.94 nfet_05v0
XM_4524 VSS n_165 n_I4555 VSS nfet_05v0 L=0.6U W=1U AS=0.73P AD=0.73P PS=3.46U
+ PD=3.46U
* device instance _4525 r0 *1 618.565,117.94 nfet_05v0
XM_4525 VSS n_39 n_I4556 VSS nfet_05v0 L=0.6U W=1U AS=0.73P AD=0.73P PS=3.46U
+ PD=3.46U
* device instance _4526 r0 *1 338.565,429.94 nfet_05v0
XM_4526 VSS n_167 n_I4557 VSS nfet_05v0 L=0.6U W=1U AS=0.73P AD=0.73P PS=3.46U
+ PD=3.46U
* device instance _4527 r0 *1 178.565,351.94 nfet_05v0
XM_4527 VSS n_156 n_I4558 VSS nfet_05v0 L=0.6U W=1U AS=0.73P AD=0.73P PS=3.46U
+ PD=3.46U
* device instance _4528 r0 *1 338.565,351.94 nfet_05v0
XM_4528 VSS n_168 n_I4559 VSS nfet_05v0 L=0.6U W=1U AS=0.73P AD=0.73P PS=3.46U
+ PD=3.46U
* device instance _4529 r0 *1 338.565,273.94 nfet_05v0
XM_4529 VSS n_96 n_I4560 VSS nfet_05v0 L=0.6U W=1U AS=0.73P AD=0.73P PS=3.46U
+ PD=3.46U
* device instance _4530 r0 *1 338.565,195.94 nfet_05v0
XM_4530 VSS n_97 n_I4561 VSS nfet_05v0 L=0.6U W=1U AS=0.73P AD=0.73P PS=3.46U
+ PD=3.46U
* device instance _4531 r0 *1 338.565,117.94 nfet_05v0
XM_4531 VSS n_32 n_I4562 VSS nfet_05v0 L=0.6U W=1U AS=0.73P AD=0.73P PS=3.46U
+ PD=3.46U
* device instance _4532 r0 *1 338.565,39.94 nfet_05v0
XM_4532 VSS n_13 n_I4563 VSS nfet_05v0 L=0.6U W=1U AS=0.73P AD=0.73P PS=3.46U
+ PD=3.46U
* device instance _4533 r0 *1 178.565,273.94 nfet_05v0
XM_4533 VSS n_88 n_I4564 VSS nfet_05v0 L=0.6U W=1U AS=0.73P AD=0.73P PS=3.46U
+ PD=3.46U
* device instance _4534 r0 *1 178.565,195.94 nfet_05v0
XM_4534 VSS n_89 n_I4565 VSS nfet_05v0 L=0.6U W=1U AS=0.73P AD=0.73P PS=3.46U
+ PD=3.46U
* device instance _4535 r0 *1 218.565,585.94 nfet_05v0
XM_4535 VSS n_269 n_I4566 VSS nfet_05v0 L=0.6U W=1U AS=0.73P AD=0.73P PS=3.46U
+ PD=3.46U
* device instance _4536 r0 *1 378.565,507.94 nfet_05v0
XM_4536 VSS n_169 n_I4567 VSS nfet_05v0 L=0.6U W=1U AS=0.73P AD=0.73P PS=3.46U
+ PD=3.46U
* device instance _4537 r0 *1 418.565,507.94 nfet_05v0
XM_4537 VSS n_172 n_I4568 VSS nfet_05v0 L=0.6U W=1U AS=0.73P AD=0.73P PS=3.46U
+ PD=3.46U
* device instance _4538 r0 *1 458.565,507.94 nfet_05v0
XM_4538 VSS n_175 n_I4569 VSS nfet_05v0 L=0.6U W=1U AS=0.73P AD=0.73P PS=3.46U
+ PD=3.46U
* device instance _4539 r0 *1 498.565,507.94 nfet_05v0
XM_4539 VSS n_178 n_I4570 VSS nfet_05v0 L=0.6U W=1U AS=0.73P AD=0.73P PS=3.46U
+ PD=3.46U
* device instance _4540 r0 *1 658.565,507.94 nfet_05v0
XM_4540 VSS n_190 n_I4571 VSS nfet_05v0 L=0.6U W=1U AS=0.73P AD=0.73P PS=3.46U
+ PD=3.46U
* device instance _4541 r0 *1 58.565,351.94 nfet_05v0
XM_4541 VSS n_147 n_I4572 VSS nfet_05v0 L=0.6U W=1U AS=0.73P AD=0.73P PS=3.46U
+ PD=3.46U
* device instance _4542 r0 *1 578.565,507.94 nfet_05v0
XM_4542 VSS n_184 n_I4573 VSS nfet_05v0 L=0.6U W=1U AS=0.73P AD=0.73P PS=3.46U
+ PD=3.46U
* device instance _4543 r0 *1 618.565,507.94 nfet_05v0
XM_4543 VSS n_187 n_I4574 VSS nfet_05v0 L=0.6U W=1U AS=0.73P AD=0.73P PS=3.46U
+ PD=3.46U
* device instance _4544 r0 *1 178.565,507.94 nfet_05v0
XM_4544 VSS n_154 n_I4575 VSS nfet_05v0 L=0.6U W=1U AS=0.73P AD=0.73P PS=3.46U
+ PD=3.46U
* device instance _4545 r0 *1 218.565,273.94 nfet_05v0
XM_4545 VSS n_90 n_I4576 VSS nfet_05v0 L=0.6U W=1U AS=0.73P AD=0.73P PS=3.46U
+ PD=3.46U
* device instance _4546 r0 *1 98.565,507.94 nfet_05v0
XM_4546 VSS n_148 n_I4577 VSS nfet_05v0 L=0.6U W=1U AS=0.73P AD=0.73P PS=3.46U
+ PD=3.46U
* device instance _4547 r0 *1 138.565,507.94 nfet_05v0
XM_4547 VSS n_151 n_I4578 VSS nfet_05v0 L=0.6U W=1U AS=0.73P AD=0.73P PS=3.46U
+ PD=3.46U
* device instance _4548 r0 *1 58.565,507.94 nfet_05v0
XM_4548 VSS n_145 n_I4579 VSS nfet_05v0 L=0.6U W=1U AS=0.73P AD=0.73P PS=3.46U
+ PD=3.46U
* device instance _4549 r0 *1 218.565,507.94 nfet_05v0
XM_4549 VSS n_157 n_I4580 VSS nfet_05v0 L=0.6U W=1U AS=0.73P AD=0.73P PS=3.46U
+ PD=3.46U
* device instance _4550 r0 *1 258.565,507.94 nfet_05v0
XM_4550 VSS n_160 n_I4581 VSS nfet_05v0 L=0.6U W=1U AS=0.73P AD=0.73P PS=3.46U
+ PD=3.46U
* device instance _4551 r0 *1 298.565,507.94 nfet_05v0
XM_4551 VSS n_163 n_I4582 VSS nfet_05v0 L=0.6U W=1U AS=0.73P AD=0.73P PS=3.46U
+ PD=3.46U
* device instance _4552 r0 *1 258.565,273.94 nfet_05v0
XM_4552 VSS n_92 n_I4583 VSS nfet_05v0 L=0.6U W=1U AS=0.73P AD=0.73P PS=3.46U
+ PD=3.46U
* device instance _4553 r0 *1 298.565,273.94 nfet_05v0
XM_4553 VSS n_94 n_I4584 VSS nfet_05v0 L=0.6U W=1U AS=0.73P AD=0.73P PS=3.46U
+ PD=3.46U
* device instance _4554 r0 *1 98.565,273.94 nfet_05v0
XM_4554 VSS n_84 n_I4585 VSS nfet_05v0 L=0.6U W=1U AS=0.73P AD=0.73P PS=3.46U
+ PD=3.46U
* device instance _4555 r0 *1 138.565,273.94 nfet_05v0
XM_4555 VSS n_86 n_I4586 VSS nfet_05v0 L=0.6U W=1U AS=0.73P AD=0.73P PS=3.46U
+ PD=3.46U
* device instance _4556 r0 *1 58.565,273.94 nfet_05v0
XM_4556 VSS n_82 n_I4587 VSS nfet_05v0 L=0.6U W=1U AS=0.73P AD=0.73P PS=3.46U
+ PD=3.46U
* device instance _4557 r0 *1 538.565,507.94 nfet_05v0
XM_4557 VSS n_181 n_I4588 VSS nfet_05v0 L=0.6U W=1U AS=0.73P AD=0.73P PS=3.46U
+ PD=3.46U
* device instance _4558 r0 *1 498.565,351.94 nfet_05v0
XM_4558 VSS n_180 n_I4589 VSS nfet_05v0 L=0.6U W=1U AS=0.73P AD=0.73P PS=3.46U
+ PD=3.46U
* device instance _4559 r0 *1 218.565,39.94 nfet_05v0
XM_4559 VSS n_10 n_I4590 VSS nfet_05v0 L=0.6U W=1U AS=0.73P AD=0.73P PS=3.46U
+ PD=3.46U
* device instance _4560 r0 *1 458.565,351.94 nfet_05v0
XM_4560 VSS n_177 n_I4591 VSS nfet_05v0 L=0.6U W=1U AS=0.73P AD=0.73P PS=3.46U
+ PD=3.46U
* device instance _4561 r0 *1 378.565,585.94 nfet_05v0
XM_4561 VSS n_273 n_I4592 VSS nfet_05v0 L=0.6U W=1U AS=0.73P AD=0.73P PS=3.46U
+ PD=3.46U
* device instance _4562 r0 *1 418.565,351.94 nfet_05v0
XM_4562 VSS n_174 n_I4593 VSS nfet_05v0 L=0.6U W=1U AS=0.73P AD=0.73P PS=3.46U
+ PD=3.46U
* device instance _4563 r0 *1 498.565,429.94 nfet_05v0
XM_4563 VSS n_179 n_I4594 VSS nfet_05v0 L=0.6U W=1U AS=0.73P AD=0.73P PS=3.46U
+ PD=3.46U
* device instance _4564 r0 *1 378.565,351.94 nfet_05v0
XM_4564 VSS n_171 n_I4595 VSS nfet_05v0 L=0.6U W=1U AS=0.73P AD=0.73P PS=3.46U
+ PD=3.46U
* device instance _4565 r0 *1 378.565,429.94 nfet_05v0
XM_4565 VSS n_170 n_I4596 VSS nfet_05v0 L=0.6U W=1U AS=0.73P AD=0.73P PS=3.46U
+ PD=3.46U
* device instance _4566 r0 *1 458.565,429.94 nfet_05v0
XM_4566 VSS n_176 n_I4597 VSS nfet_05v0 L=0.6U W=1U AS=0.73P AD=0.73P PS=3.46U
+ PD=3.46U
* device instance _4567 r0 *1 258.565,39.94 nfet_05v0
XM_4567 VSS n_11 n_I4598 VSS nfet_05v0 L=0.6U W=1U AS=0.73P AD=0.73P PS=3.46U
+ PD=3.46U
* device instance _4568 r0 *1 418.565,429.94 nfet_05v0
XM_4568 VSS n_173 n_I4599 VSS nfet_05v0 L=0.6U W=1U AS=0.73P AD=0.73P PS=3.46U
+ PD=3.46U
* device instance _4569 r0 *1 618.565,429.94 nfet_05v0
XM_4569 VSS n_188 n_I4600 VSS nfet_05v0 L=0.6U W=1U AS=0.73P AD=0.73P PS=3.46U
+ PD=3.46U
* device instance _4570 r0 *1 578.565,429.94 nfet_05v0
XM_4570 VSS n_185 n_I4601 VSS nfet_05v0 L=0.6U W=1U AS=0.73P AD=0.73P PS=3.46U
+ PD=3.46U
* device instance _4571 r0 *1 618.565,351.94 nfet_05v0
XM_4571 VSS n_189 n_I4602 VSS nfet_05v0 L=0.6U W=1U AS=0.73P AD=0.73P PS=3.46U
+ PD=3.46U
* device instance _4572 r0 *1 618.565,585.94 nfet_05v0
XM_4572 VSS n_279 n_I4603 VSS nfet_05v0 L=0.6U W=1U AS=0.73P AD=0.73P PS=3.46U
+ PD=3.46U
* device instance _4573 r0 *1 338.565,507.94 nfet_05v0
XM_4573 VSS n_166 n_I4604 VSS nfet_05v0 L=0.6U W=1U AS=0.73P AD=0.73P PS=3.46U
+ PD=3.46U
* device instance _4574 r0 *1 538.565,351.94 nfet_05v0
XM_4574 VSS n_183 n_I4605 VSS nfet_05v0 L=0.6U W=1U AS=0.73P AD=0.73P PS=3.46U
+ PD=3.46U
* device instance _4575 r0 *1 578.565,585.94 nfet_05v0
XM_4575 VSS n_278 n_I4606 VSS nfet_05v0 L=0.6U W=1U AS=0.73P AD=0.73P PS=3.46U
+ PD=3.46U
* device instance _4576 r0 *1 658.565,585.94 nfet_05v0
XM_4576 VSS n_280 n_I4607 VSS nfet_05v0 L=0.6U W=1U AS=0.73P AD=0.73P PS=3.46U
+ PD=3.46U
* device instance _4577 r0 *1 578.565,273.94 nfet_05v0
XM_4577 VSS n_108 n_I4608 VSS nfet_05v0 L=0.6U W=1U AS=0.73P AD=0.73P PS=3.46U
+ PD=3.46U
* device instance _4578 r0 *1 618.565,273.94 nfet_05v0
XM_4578 VSS n_110 n_I4609 VSS nfet_05v0 L=0.6U W=1U AS=0.73P AD=0.73P PS=3.46U
+ PD=3.46U
* device instance _4579 r0 *1 658.565,273.94 nfet_05v0
XM_4579 VSS n_112 n_I4610 VSS nfet_05v0 L=0.6U W=1U AS=0.73P AD=0.73P PS=3.46U
+ PD=3.46U
* device instance _4580 r0 *1 578.565,351.94 nfet_05v0
XM_4580 VSS n_186 n_I4611 VSS nfet_05v0 L=0.6U W=1U AS=0.73P AD=0.73P PS=3.46U
+ PD=3.46U
* device instance _4581 r0 *1 538.565,429.94 nfet_05v0
XM_4581 VSS n_182 n_I4612 VSS nfet_05v0 L=0.6U W=1U AS=0.73P AD=0.73P PS=3.46U
+ PD=3.46U
* device instance _4582 r0 *1 538.565,273.94 nfet_05v0
XM_4582 VSS n_106 n_I4613 VSS nfet_05v0 L=0.6U W=1U AS=0.73P AD=0.73P PS=3.46U
+ PD=3.46U
* device instance _4583 r0 *1 498.565,273.94 nfet_05v0
XM_4583 VSS n_104 n_I4614 VSS nfet_05v0 L=0.6U W=1U AS=0.73P AD=0.73P PS=3.46U
+ PD=3.46U
* device instance _4584 r0 *1 458.565,273.94 nfet_05v0
XM_4584 VSS n_102 n_I4615 VSS nfet_05v0 L=0.6U W=1U AS=0.73P AD=0.73P PS=3.46U
+ PD=3.46U
* device instance _4585 r0 *1 378.565,273.94 nfet_05v0
XM_4585 VSS n_98 n_I4616 VSS nfet_05v0 L=0.6U W=1U AS=0.73P AD=0.73P PS=3.46U
+ PD=3.46U
* device instance _4586 r0 *1 418.565,273.94 nfet_05v0
XM_4586 VSS n_100 n_I4617 VSS nfet_05v0 L=0.6U W=1U AS=0.73P AD=0.73P PS=3.46U
+ PD=3.46U
* device instance _4587 r0 *1 658.565,429.94 nfet_05v0
XM_4587 VSS n_191 n_I4618 VSS nfet_05v0 L=0.6U W=1U AS=0.73P AD=0.73P PS=3.46U
+ PD=3.46U
* device instance _4588 r0 *1 658.565,351.94 nfet_05v0
XM_4588 VSS n_192 n_I4619 VSS nfet_05v0 L=0.6U W=1U AS=0.73P AD=0.73P PS=3.46U
+ PD=3.46U
* device instance _4589 r0 *1 538.565,585.94 nfet_05v0
XM_4589 VSS n_277 n_I4620 VSS nfet_05v0 L=0.6U W=1U AS=0.73P AD=0.73P PS=3.46U
+ PD=3.46U
* device instance _4590 r0 *1 98.565,429.94 nfet_05v0
XM_4590 VSS n_149 n_I4621 VSS nfet_05v0 L=0.6U W=1U AS=0.73P AD=0.73P PS=3.46U
+ PD=3.46U
* device instance _4591 r0 *1 378.565,39.94 nfet_05v0
XM_4591 VSS n_14 n_I4622 VSS nfet_05v0 L=0.6U W=1U AS=0.73P AD=0.73P PS=3.46U
+ PD=3.46U
* device instance _4592 r0 *1 138.565,585.94 nfet_05v0
XM_4592 VSS n_267 n_I4623 VSS nfet_05v0 L=0.6U W=1U AS=0.73P AD=0.73P PS=3.46U
+ PD=3.46U
* device instance _4593 r0 *1 58.565,585.94 nfet_05v0
XM_4593 VSS n_265 n_I4624 VSS nfet_05v0 L=0.6U W=1U AS=0.73P AD=0.73P PS=3.46U
+ PD=3.46U
* device instance _4594 r0 *1 138.565,351.94 nfet_05v0
XM_4594 VSS n_153 n_I4625 VSS nfet_05v0 L=0.6U W=1U AS=0.73P AD=0.73P PS=3.46U
+ PD=3.46U
* device instance _4595 r0 *1 138.565,429.94 nfet_05v0
XM_4595 VSS n_152 n_I4626 VSS nfet_05v0 L=0.6U W=1U AS=0.73P AD=0.73P PS=3.46U
+ PD=3.46U
* device instance _4596 r0 *1 58.565,117.94 nfet_05v0
XM_4596 VSS n_25 n_I4627 VSS nfet_05v0 L=0.6U W=1U AS=0.73P AD=0.73P PS=3.46U
+ PD=3.46U
* device instance _4597 r0 *1 98.565,117.94 nfet_05v0
XM_4597 VSS n_26 n_I4628 VSS nfet_05v0 L=0.6U W=1U AS=0.73P AD=0.73P PS=3.46U
+ PD=3.46U
* device instance _4598 r0 *1 138.565,117.94 nfet_05v0
XM_4598 VSS n_27 n_I4629 VSS nfet_05v0 L=0.6U W=1U AS=0.73P AD=0.73P PS=3.46U
+ PD=3.46U
* device instance _4599 r0 *1 98.565,39.94 nfet_05v0
XM_4599 VSS n_7 n_I4630 VSS nfet_05v0 L=0.6U W=1U AS=0.73P AD=0.73P PS=3.46U
+ PD=3.46U
* device instance _4600 r0 *1 458.565,39.94 nfet_05v0
XM_4600 VSS n_16 n_I4631 VSS nfet_05v0 L=0.6U W=1U AS=0.73P AD=0.73P PS=3.46U
+ PD=3.46U
* device instance _4601 r0 *1 138.565,39.94 nfet_05v0
XM_4601 VSS n_8 n_I4632 VSS nfet_05v0 L=0.6U W=1U AS=0.73P AD=0.73P PS=3.46U
+ PD=3.46U
* device instance _4602 r0 *1 138.565,195.94 nfet_05v0
XM_4602 VSS n_87 n_I4633 VSS nfet_05v0 L=0.6U W=1U AS=0.73P AD=0.73P PS=3.46U
+ PD=3.46U
* device instance _4603 r0 *1 58.565,195.94 nfet_05v0
XM_4603 VSS n_83 n_I4634 VSS nfet_05v0 L=0.6U W=1U AS=0.73P AD=0.73P PS=3.46U
+ PD=3.46U
* device instance _4604 r0 *1 258.565,195.94 nfet_05v0
XM_4604 VSS n_93 n_I4635 VSS nfet_05v0 L=0.6U W=1U AS=0.73P AD=0.73P PS=3.46U
+ PD=3.46U
* device instance _4605 r0 *1 218.565,117.94 nfet_05v0
XM_4605 VSS n_29 n_I4636 VSS nfet_05v0 L=0.6U W=1U AS=0.73P AD=0.73P PS=3.46U
+ PD=3.46U
* device instance _4606 r0 *1 258.565,117.94 nfet_05v0
XM_4606 VSS n_30 n_I4637 VSS nfet_05v0 L=0.6U W=1U AS=0.73P AD=0.73P PS=3.46U
+ PD=3.46U
* device instance _4607 r0 *1 178.565,585.94 nfet_05v0
XM_4607 VSS n_268 n_I4638 VSS nfet_05v0 L=0.6U W=1U AS=0.73P AD=0.73P PS=3.46U
+ PD=3.46U
* device instance _4608 r0 *1 298.565,195.94 nfet_05v0
XM_4608 VSS n_95 n_I4639 VSS nfet_05v0 L=0.6U W=1U AS=0.73P AD=0.73P PS=3.46U
+ PD=3.46U
* device instance _4609 r0 *1 298.565,117.94 nfet_05v0
XM_4609 VSS n_31 n_I4640 VSS nfet_05v0 L=0.6U W=1U AS=0.73P AD=0.73P PS=3.46U
+ PD=3.46U
* device instance _4610 r0 *1 378.565,195.94 nfet_05v0
XM_4610 VSS n_99 n_I4641 VSS nfet_05v0 L=0.6U W=1U AS=0.73P AD=0.73P PS=3.46U
+ PD=3.46U
* device instance _4611 r0 *1 418.565,195.94 nfet_05v0
XM_4611 VSS n_101 n_I4642 VSS nfet_05v0 L=0.6U W=1U AS=0.73P AD=0.73P PS=3.46U
+ PD=3.46U
* device instance _4612 r0 *1 98.565,195.94 nfet_05v0
XM_4612 VSS n_85 n_I4643 VSS nfet_05v0 L=0.6U W=1U AS=0.73P AD=0.73P PS=3.46U
+ PD=3.46U
* device instance _4613 r0 *1 498.565,195.94 nfet_05v0
XM_4613 VSS n_105 n_I4644 VSS nfet_05v0 L=0.6U W=1U AS=0.73P AD=0.73P PS=3.46U
+ PD=3.46U
* device instance _4614 r0 *1 498.565,585.94 nfet_05v0
XM_4614 VSS n_276 n_I4645 VSS nfet_05v0 L=0.6U W=1U AS=0.73P AD=0.73P PS=3.46U
+ PD=3.46U
* device instance _4615 r0 *1 458.565,585.94 nfet_05v0
XM_4615 VSS n_275 n_I4646 VSS nfet_05v0 L=0.6U W=1U AS=0.73P AD=0.73P PS=3.46U
+ PD=3.46U
* device instance _4616 r0 *1 418.565,39.94 nfet_05v0
XM_4616 VSS n_15 n_I4647 VSS nfet_05v0 L=0.6U W=1U AS=0.73P AD=0.73P PS=3.46U
+ PD=3.46U
* device instance _4617 r0 *1 418.565,585.94 nfet_05v0
XM_4617 VSS n_274 n_I4648 VSS nfet_05v0 L=0.6U W=1U AS=0.73P AD=0.73P PS=3.46U
+ PD=3.46U
* device instance _4618 r0 *1 298.565,39.94 nfet_05v0
XM_4618 VSS n_12 n_I4649 VSS nfet_05v0 L=0.6U W=1U AS=0.73P AD=0.73P PS=3.46U
+ PD=3.46U
* device instance _4619 r0 *1 218.565,195.94 nfet_05v0
XM_4619 VSS n_91 n_I4650 VSS nfet_05v0 L=0.6U W=1U AS=0.73P AD=0.73P PS=3.46U
+ PD=3.46U
* device instance _4620 r0 *1 498.565,39.94 nfet_05v0
XM_4620 VSS n_17 n_I4651 VSS nfet_05v0 L=0.6U W=1U AS=0.73P AD=0.73P PS=3.46U
+ PD=3.46U
* device instance _4621 r0 *1 458.565,195.94 nfet_05v0
XM_4621 VSS n_103 n_I4652 VSS nfet_05v0 L=0.6U W=1U AS=0.73P AD=0.73P PS=3.46U
+ PD=3.46U
* device instance _4622 r0 *1 48.825,34.46 diode_nw2ps_06v0
D_4622 VSS n_6 diode_nw2ps_06v0 area=0.864P pj=6.24U
* device instance _4623 r0 *1 248.825,580.46 diode_nw2ps_06v0
D_4623 VSS n_270 diode_nw2ps_06v0 area=0.864P pj=6.24U
* device instance _4624 r0 *1 528.825,34.46 diode_nw2ps_06v0
D_4624 VSS n_18 diode_nw2ps_06v0 area=0.864P pj=6.24U
* device instance _4625 r0 *1 168.825,112.46 diode_nw2ps_06v0
D_4625 VSS n_28 diode_nw2ps_06v0 area=0.864P pj=6.24U
* device instance _4626 r0 *1 208.825,424.46 diode_nw2ps_06v0
D_4626 VSS n_158 diode_nw2ps_06v0 area=0.864P pj=6.24U
* device instance _4627 r0 *1 168.825,34.46 diode_nw2ps_06v0
D_4627 VSS n_9 diode_nw2ps_06v0 area=0.864P pj=6.24U
* device instance _4628 r0 *1 288.825,580.46 diode_nw2ps_06v0
D_4628 VSS n_271 diode_nw2ps_06v0 area=0.864P pj=6.24U
* device instance _4629 r0 *1 88.825,580.46 diode_nw2ps_06v0
D_4629 VSS n_266 diode_nw2ps_06v0 area=0.864P pj=6.24U
* device instance _4630 r0 *1 248.825,346.46 diode_nw2ps_06v0
D_4630 VSS n_162 diode_nw2ps_06v0 area=0.864P pj=6.24U
* device instance _4631 r0 *1 608.825,34.46 diode_nw2ps_06v0
D_4631 VSS n_20 diode_nw2ps_06v0 area=0.864P pj=6.24U
* device instance _4632 r0 *1 168.825,424.46 diode_nw2ps_06v0
D_4632 VSS n_155 diode_nw2ps_06v0 area=0.864P pj=6.24U
* device instance _4633 r0 *1 448.825,112.46 diode_nw2ps_06v0
D_4633 VSS n_35 diode_nw2ps_06v0 area=0.864P pj=6.24U
* device instance _4634 r0 *1 488.825,112.46 diode_nw2ps_06v0
D_4634 VSS n_36 diode_nw2ps_06v0 area=0.864P pj=6.24U
* device instance _4635 r0 *1 608.825,190.46 diode_nw2ps_06v0
D_4635 VSS n_111 diode_nw2ps_06v0 area=0.864P pj=6.24U
* device instance _4636 r0 *1 648.825,190.46 diode_nw2ps_06v0
D_4636 VSS n_113 diode_nw2ps_06v0 area=0.864P pj=6.24U
* device instance _4637 r0 *1 528.825,190.46 diode_nw2ps_06v0
D_4637 VSS n_107 diode_nw2ps_06v0 area=0.864P pj=6.24U
* device instance _4638 r0 *1 568.825,190.46 diode_nw2ps_06v0
D_4638 VSS n_109 diode_nw2ps_06v0 area=0.864P pj=6.24U
* device instance _4639 r0 *1 528.825,112.46 diode_nw2ps_06v0
D_4639 VSS n_37 diode_nw2ps_06v0 area=0.864P pj=6.24U
* device instance _4640 r0 *1 568.825,112.46 diode_nw2ps_06v0
D_4640 VSS n_38 diode_nw2ps_06v0 area=0.864P pj=6.24U
* device instance _4641 r0 *1 88.825,346.46 diode_nw2ps_06v0
D_4641 VSS n_150 diode_nw2ps_06v0 area=0.864P pj=6.24U
* device instance _4642 r0 *1 568.825,34.46 diode_nw2ps_06v0
D_4642 VSS n_19 diode_nw2ps_06v0 area=0.864P pj=6.24U
* device instance _4643 r0 *1 408.825,112.46 diode_nw2ps_06v0
D_4643 VSS n_34 diode_nw2ps_06v0 area=0.864P pj=6.24U
* device instance _4644 r0 *1 648.825,112.46 diode_nw2ps_06v0
D_4644 VSS n_40 diode_nw2ps_06v0 area=0.864P pj=6.24U
* device instance _4645 r0 *1 648.825,34.46 diode_nw2ps_06v0
D_4645 VSS n_21 diode_nw2ps_06v0 area=0.864P pj=6.24U
* device instance _4646 r0 *1 48.825,424.46 diode_nw2ps_06v0
D_4646 VSS n_146 diode_nw2ps_06v0 area=0.864P pj=6.24U
* device instance _4647 r0 *1 368.825,112.46 diode_nw2ps_06v0
D_4647 VSS n_33 diode_nw2ps_06v0 area=0.864P pj=6.24U
* device instance _4648 r0 *1 208.825,346.46 diode_nw2ps_06v0
D_4648 VSS n_159 diode_nw2ps_06v0 area=0.864P pj=6.24U
* device instance _4649 r0 *1 288.825,424.46 diode_nw2ps_06v0
D_4649 VSS n_164 diode_nw2ps_06v0 area=0.864P pj=6.24U
* device instance _4650 r0 *1 328.825,580.46 diode_nw2ps_06v0
D_4650 VSS n_272 diode_nw2ps_06v0 area=0.864P pj=6.24U
* device instance _4651 r0 *1 248.825,424.46 diode_nw2ps_06v0
D_4651 VSS n_161 diode_nw2ps_06v0 area=0.864P pj=6.24U
* device instance _4652 r0 *1 288.825,346.46 diode_nw2ps_06v0
D_4652 VSS n_165 diode_nw2ps_06v0 area=0.864P pj=6.24U
* device instance _4653 r0 *1 608.825,112.46 diode_nw2ps_06v0
D_4653 VSS n_39 diode_nw2ps_06v0 area=0.864P pj=6.24U
* device instance _4654 r0 *1 328.825,424.46 diode_nw2ps_06v0
D_4654 VSS n_167 diode_nw2ps_06v0 area=0.864P pj=6.24U
* device instance _4655 r0 *1 168.825,346.46 diode_nw2ps_06v0
D_4655 VSS n_156 diode_nw2ps_06v0 area=0.864P pj=6.24U
* device instance _4656 r0 *1 328.825,346.46 diode_nw2ps_06v0
D_4656 VSS n_168 diode_nw2ps_06v0 area=0.864P pj=6.24U
* device instance _4657 r0 *1 328.825,268.46 diode_nw2ps_06v0
D_4657 VSS n_96 diode_nw2ps_06v0 area=0.864P pj=6.24U
* device instance _4658 r0 *1 328.825,190.46 diode_nw2ps_06v0
D_4658 VSS n_97 diode_nw2ps_06v0 area=0.864P pj=6.24U
* device instance _4659 r0 *1 328.825,112.46 diode_nw2ps_06v0
D_4659 VSS n_32 diode_nw2ps_06v0 area=0.864P pj=6.24U
* device instance _4660 r0 *1 328.825,34.46 diode_nw2ps_06v0
D_4660 VSS n_13 diode_nw2ps_06v0 area=0.864P pj=6.24U
* device instance _4661 r0 *1 168.825,268.46 diode_nw2ps_06v0
D_4661 VSS n_88 diode_nw2ps_06v0 area=0.864P pj=6.24U
* device instance _4662 r0 *1 168.825,190.46 diode_nw2ps_06v0
D_4662 VSS n_89 diode_nw2ps_06v0 area=0.864P pj=6.24U
* device instance _4663 r0 *1 208.825,580.46 diode_nw2ps_06v0
D_4663 VSS n_269 diode_nw2ps_06v0 area=0.864P pj=6.24U
* device instance _4664 r0 *1 368.825,502.46 diode_nw2ps_06v0
D_4664 VSS n_169 diode_nw2ps_06v0 area=0.864P pj=6.24U
* device instance _4665 r0 *1 408.825,502.46 diode_nw2ps_06v0
D_4665 VSS n_172 diode_nw2ps_06v0 area=0.864P pj=6.24U
* device instance _4666 r0 *1 448.825,502.46 diode_nw2ps_06v0
D_4666 VSS n_175 diode_nw2ps_06v0 area=0.864P pj=6.24U
* device instance _4667 r0 *1 488.825,502.46 diode_nw2ps_06v0
D_4667 VSS n_178 diode_nw2ps_06v0 area=0.864P pj=6.24U
* device instance _4668 r0 *1 648.825,502.46 diode_nw2ps_06v0
D_4668 VSS n_190 diode_nw2ps_06v0 area=0.864P pj=6.24U
* device instance _4669 r0 *1 48.825,346.46 diode_nw2ps_06v0
D_4669 VSS n_147 diode_nw2ps_06v0 area=0.864P pj=6.24U
* device instance _4670 r0 *1 568.825,502.46 diode_nw2ps_06v0
D_4670 VSS n_184 diode_nw2ps_06v0 area=0.864P pj=6.24U
* device instance _4671 r0 *1 608.825,502.46 diode_nw2ps_06v0
D_4671 VSS n_187 diode_nw2ps_06v0 area=0.864P pj=6.24U
* device instance _4672 r0 *1 168.825,502.46 diode_nw2ps_06v0
D_4672 VSS n_154 diode_nw2ps_06v0 area=0.864P pj=6.24U
* device instance _4673 r0 *1 208.825,268.46 diode_nw2ps_06v0
D_4673 VSS n_90 diode_nw2ps_06v0 area=0.864P pj=6.24U
* device instance _4674 r0 *1 88.825,502.46 diode_nw2ps_06v0
D_4674 VSS n_148 diode_nw2ps_06v0 area=0.864P pj=6.24U
* device instance _4675 r0 *1 128.825,502.46 diode_nw2ps_06v0
D_4675 VSS n_151 diode_nw2ps_06v0 area=0.864P pj=6.24U
* device instance _4676 r0 *1 48.825,502.46 diode_nw2ps_06v0
D_4676 VSS n_145 diode_nw2ps_06v0 area=0.864P pj=6.24U
* device instance _4677 r0 *1 208.825,502.46 diode_nw2ps_06v0
D_4677 VSS n_157 diode_nw2ps_06v0 area=0.864P pj=6.24U
* device instance _4678 r0 *1 248.825,502.46 diode_nw2ps_06v0
D_4678 VSS n_160 diode_nw2ps_06v0 area=0.864P pj=6.24U
* device instance _4679 r0 *1 288.825,502.46 diode_nw2ps_06v0
D_4679 VSS n_163 diode_nw2ps_06v0 area=0.864P pj=6.24U
* device instance _4680 r0 *1 248.825,268.46 diode_nw2ps_06v0
D_4680 VSS n_92 diode_nw2ps_06v0 area=0.864P pj=6.24U
* device instance _4681 r0 *1 288.825,268.46 diode_nw2ps_06v0
D_4681 VSS n_94 diode_nw2ps_06v0 area=0.864P pj=6.24U
* device instance _4682 r0 *1 88.825,268.46 diode_nw2ps_06v0
D_4682 VSS n_84 diode_nw2ps_06v0 area=0.864P pj=6.24U
* device instance _4683 r0 *1 128.825,268.46 diode_nw2ps_06v0
D_4683 VSS n_86 diode_nw2ps_06v0 area=0.864P pj=6.24U
* device instance _4684 r0 *1 48.825,268.46 diode_nw2ps_06v0
D_4684 VSS n_82 diode_nw2ps_06v0 area=0.864P pj=6.24U
* device instance _4685 r0 *1 528.825,502.46 diode_nw2ps_06v0
D_4685 VSS n_181 diode_nw2ps_06v0 area=0.864P pj=6.24U
* device instance _4686 r0 *1 488.825,346.46 diode_nw2ps_06v0
D_4686 VSS n_180 diode_nw2ps_06v0 area=0.864P pj=6.24U
* device instance _4687 r0 *1 208.825,34.46 diode_nw2ps_06v0
D_4687 VSS n_10 diode_nw2ps_06v0 area=0.864P pj=6.24U
* device instance _4688 r0 *1 448.825,346.46 diode_nw2ps_06v0
D_4688 VSS n_177 diode_nw2ps_06v0 area=0.864P pj=6.24U
* device instance _4689 r0 *1 368.825,580.46 diode_nw2ps_06v0
D_4689 VSS n_273 diode_nw2ps_06v0 area=0.864P pj=6.24U
* device instance _4690 r0 *1 408.825,346.46 diode_nw2ps_06v0
D_4690 VSS n_174 diode_nw2ps_06v0 area=0.864P pj=6.24U
* device instance _4691 r0 *1 488.825,424.46 diode_nw2ps_06v0
D_4691 VSS n_179 diode_nw2ps_06v0 area=0.864P pj=6.24U
* device instance _4692 r0 *1 368.825,346.46 diode_nw2ps_06v0
D_4692 VSS n_171 diode_nw2ps_06v0 area=0.864P pj=6.24U
* device instance _4693 r0 *1 368.825,424.46 diode_nw2ps_06v0
D_4693 VSS n_170 diode_nw2ps_06v0 area=0.864P pj=6.24U
* device instance _4694 r0 *1 448.825,424.46 diode_nw2ps_06v0
D_4694 VSS n_176 diode_nw2ps_06v0 area=0.864P pj=6.24U
* device instance _4695 r0 *1 248.825,34.46 diode_nw2ps_06v0
D_4695 VSS n_11 diode_nw2ps_06v0 area=0.864P pj=6.24U
* device instance _4696 r0 *1 408.825,424.46 diode_nw2ps_06v0
D_4696 VSS n_173 diode_nw2ps_06v0 area=0.864P pj=6.24U
* device instance _4697 r0 *1 608.825,424.46 diode_nw2ps_06v0
D_4697 VSS n_188 diode_nw2ps_06v0 area=0.864P pj=6.24U
* device instance _4698 r0 *1 568.825,424.46 diode_nw2ps_06v0
D_4698 VSS n_185 diode_nw2ps_06v0 area=0.864P pj=6.24U
* device instance _4699 r0 *1 608.825,346.46 diode_nw2ps_06v0
D_4699 VSS n_189 diode_nw2ps_06v0 area=0.864P pj=6.24U
* device instance _4700 r0 *1 608.825,580.46 diode_nw2ps_06v0
D_4700 VSS n_279 diode_nw2ps_06v0 area=0.864P pj=6.24U
* device instance _4701 r0 *1 328.825,502.46 diode_nw2ps_06v0
D_4701 VSS n_166 diode_nw2ps_06v0 area=0.864P pj=6.24U
* device instance _4702 r0 *1 528.825,346.46 diode_nw2ps_06v0
D_4702 VSS n_183 diode_nw2ps_06v0 area=0.864P pj=6.24U
* device instance _4703 r0 *1 568.825,580.46 diode_nw2ps_06v0
D_4703 VSS n_278 diode_nw2ps_06v0 area=0.864P pj=6.24U
* device instance _4704 r0 *1 648.825,580.46 diode_nw2ps_06v0
D_4704 VSS n_280 diode_nw2ps_06v0 area=0.864P pj=6.24U
* device instance _4705 r0 *1 568.825,268.46 diode_nw2ps_06v0
D_4705 VSS n_108 diode_nw2ps_06v0 area=0.864P pj=6.24U
* device instance _4706 r0 *1 608.825,268.46 diode_nw2ps_06v0
D_4706 VSS n_110 diode_nw2ps_06v0 area=0.864P pj=6.24U
* device instance _4707 r0 *1 648.825,268.46 diode_nw2ps_06v0
D_4707 VSS n_112 diode_nw2ps_06v0 area=0.864P pj=6.24U
* device instance _4708 r0 *1 568.825,346.46 diode_nw2ps_06v0
D_4708 VSS n_186 diode_nw2ps_06v0 area=0.864P pj=6.24U
* device instance _4709 r0 *1 528.825,424.46 diode_nw2ps_06v0
D_4709 VSS n_182 diode_nw2ps_06v0 area=0.864P pj=6.24U
* device instance _4710 r0 *1 528.825,268.46 diode_nw2ps_06v0
D_4710 VSS n_106 diode_nw2ps_06v0 area=0.864P pj=6.24U
* device instance _4711 r0 *1 488.825,268.46 diode_nw2ps_06v0
D_4711 VSS n_104 diode_nw2ps_06v0 area=0.864P pj=6.24U
* device instance _4712 r0 *1 448.825,268.46 diode_nw2ps_06v0
D_4712 VSS n_102 diode_nw2ps_06v0 area=0.864P pj=6.24U
* device instance _4713 r0 *1 368.825,268.46 diode_nw2ps_06v0
D_4713 VSS n_98 diode_nw2ps_06v0 area=0.864P pj=6.24U
* device instance _4714 r0 *1 408.825,268.46 diode_nw2ps_06v0
D_4714 VSS n_100 diode_nw2ps_06v0 area=0.864P pj=6.24U
* device instance _4715 r0 *1 648.825,424.46 diode_nw2ps_06v0
D_4715 VSS n_191 diode_nw2ps_06v0 area=0.864P pj=6.24U
* device instance _4716 r0 *1 648.825,346.46 diode_nw2ps_06v0
D_4716 VSS n_192 diode_nw2ps_06v0 area=0.864P pj=6.24U
* device instance _4717 r0 *1 528.825,580.46 diode_nw2ps_06v0
D_4717 VSS n_277 diode_nw2ps_06v0 area=0.864P pj=6.24U
* device instance _4718 r0 *1 88.825,424.46 diode_nw2ps_06v0
D_4718 VSS n_149 diode_nw2ps_06v0 area=0.864P pj=6.24U
* device instance _4719 r0 *1 368.825,34.46 diode_nw2ps_06v0
D_4719 VSS n_14 diode_nw2ps_06v0 area=0.864P pj=6.24U
* device instance _4720 r0 *1 128.825,580.46 diode_nw2ps_06v0
D_4720 VSS n_267 diode_nw2ps_06v0 area=0.864P pj=6.24U
* device instance _4721 r0 *1 48.825,580.46 diode_nw2ps_06v0
D_4721 VSS n_265 diode_nw2ps_06v0 area=0.864P pj=6.24U
* device instance _4722 r0 *1 128.825,346.46 diode_nw2ps_06v0
D_4722 VSS n_153 diode_nw2ps_06v0 area=0.864P pj=6.24U
* device instance _4723 r0 *1 128.825,424.46 diode_nw2ps_06v0
D_4723 VSS n_152 diode_nw2ps_06v0 area=0.864P pj=6.24U
* device instance _4724 r0 *1 48.825,112.46 diode_nw2ps_06v0
D_4724 VSS n_25 diode_nw2ps_06v0 area=0.864P pj=6.24U
* device instance _4725 r0 *1 88.825,112.46 diode_nw2ps_06v0
D_4725 VSS n_26 diode_nw2ps_06v0 area=0.864P pj=6.24U
* device instance _4726 r0 *1 128.825,112.46 diode_nw2ps_06v0
D_4726 VSS n_27 diode_nw2ps_06v0 area=0.864P pj=6.24U
* device instance _4727 r0 *1 88.825,34.46 diode_nw2ps_06v0
D_4727 VSS n_7 diode_nw2ps_06v0 area=0.864P pj=6.24U
* device instance _4728 r0 *1 448.825,34.46 diode_nw2ps_06v0
D_4728 VSS n_16 diode_nw2ps_06v0 area=0.864P pj=6.24U
* device instance _4729 r0 *1 128.825,34.46 diode_nw2ps_06v0
D_4729 VSS n_8 diode_nw2ps_06v0 area=0.864P pj=6.24U
* device instance _4730 r0 *1 128.825,190.46 diode_nw2ps_06v0
D_4730 VSS n_87 diode_nw2ps_06v0 area=0.864P pj=6.24U
* device instance _4731 r0 *1 48.825,190.46 diode_nw2ps_06v0
D_4731 VSS n_83 diode_nw2ps_06v0 area=0.864P pj=6.24U
* device instance _4732 r0 *1 248.825,190.46 diode_nw2ps_06v0
D_4732 VSS n_93 diode_nw2ps_06v0 area=0.864P pj=6.24U
* device instance _4733 r0 *1 208.825,112.46 diode_nw2ps_06v0
D_4733 VSS n_29 diode_nw2ps_06v0 area=0.864P pj=6.24U
* device instance _4734 r0 *1 248.825,112.46 diode_nw2ps_06v0
D_4734 VSS n_30 diode_nw2ps_06v0 area=0.864P pj=6.24U
* device instance _4735 r0 *1 168.825,580.46 diode_nw2ps_06v0
D_4735 VSS n_268 diode_nw2ps_06v0 area=0.864P pj=6.24U
* device instance _4736 r0 *1 288.825,190.46 diode_nw2ps_06v0
D_4736 VSS n_95 diode_nw2ps_06v0 area=0.864P pj=6.24U
* device instance _4737 r0 *1 288.825,112.46 diode_nw2ps_06v0
D_4737 VSS n_31 diode_nw2ps_06v0 area=0.864P pj=6.24U
* device instance _4738 r0 *1 368.825,190.46 diode_nw2ps_06v0
D_4738 VSS n_99 diode_nw2ps_06v0 area=0.864P pj=6.24U
* device instance _4739 r0 *1 408.825,190.46 diode_nw2ps_06v0
D_4739 VSS n_101 diode_nw2ps_06v0 area=0.864P pj=6.24U
* device instance _4740 r0 *1 88.825,190.46 diode_nw2ps_06v0
D_4740 VSS n_85 diode_nw2ps_06v0 area=0.864P pj=6.24U
* device instance _4741 r0 *1 488.825,190.46 diode_nw2ps_06v0
D_4741 VSS n_105 diode_nw2ps_06v0 area=0.864P pj=6.24U
* device instance _4742 r0 *1 488.825,580.46 diode_nw2ps_06v0
D_4742 VSS n_276 diode_nw2ps_06v0 area=0.864P pj=6.24U
* device instance _4743 r0 *1 448.825,580.46 diode_nw2ps_06v0
D_4743 VSS n_275 diode_nw2ps_06v0 area=0.864P pj=6.24U
* device instance _4744 r0 *1 408.825,34.46 diode_nw2ps_06v0
D_4744 VSS n_15 diode_nw2ps_06v0 area=0.864P pj=6.24U
* device instance _4745 r0 *1 408.825,580.46 diode_nw2ps_06v0
D_4745 VSS n_274 diode_nw2ps_06v0 area=0.864P pj=6.24U
* device instance _4746 r0 *1 288.825,34.46 diode_nw2ps_06v0
D_4746 VSS n_12 diode_nw2ps_06v0 area=0.864P pj=6.24U
* device instance _4747 r0 *1 208.825,190.46 diode_nw2ps_06v0
D_4747 VSS n_91 diode_nw2ps_06v0 area=0.864P pj=6.24U
* device instance _4748 r0 *1 488.825,34.46 diode_nw2ps_06v0
D_4748 VSS n_17 diode_nw2ps_06v0 area=0.864P pj=6.24U
* device instance _4749 r0 *1 448.825,190.46 diode_nw2ps_06v0
D_4749 VSS n_103 diode_nw2ps_06v0 area=0.864P pj=6.24U
* device instance _4750 r0 *1 58.565,26.825 nfet_05v0
XM_4750 VSS n_I4653 n_I385 VSS nfet_05v0 L=0.6U W=0.42U AS=0.315P AD=0.315P
+ PS=2.34U PD=2.34U
* device instance _4751 r0 *1 258.565,572.825 nfet_05v0
XM_4751 VSS n_I4654 n_I384 VSS nfet_05v0 L=0.6U W=0.42U AS=0.315P AD=0.315P
+ PS=2.34U PD=2.34U
* device instance _4752 r0 *1 538.565,26.825 nfet_05v0
XM_4752 VSS n_I4655 n_I383 VSS nfet_05v0 L=0.6U W=0.42U AS=0.315P AD=0.315P
+ PS=2.34U PD=2.34U
* device instance _4753 r0 *1 178.565,104.825 nfet_05v0
XM_4753 VSS n_I4656 n_I382 VSS nfet_05v0 L=0.6U W=0.42U AS=0.315P AD=0.315P
+ PS=2.34U PD=2.34U
* device instance _4754 r0 *1 218.565,416.825 nfet_05v0
XM_4754 VSS n_I4657 n_I381 VSS nfet_05v0 L=0.6U W=0.42U AS=0.315P AD=0.315P
+ PS=2.34U PD=2.34U
* device instance _4755 r0 *1 178.565,26.825 nfet_05v0
XM_4755 VSS n_I4658 n_I380 VSS nfet_05v0 L=0.6U W=0.42U AS=0.315P AD=0.315P
+ PS=2.34U PD=2.34U
* device instance _4756 r0 *1 298.565,572.825 nfet_05v0
XM_4756 VSS n_I4659 n_I379 VSS nfet_05v0 L=0.6U W=0.42U AS=0.315P AD=0.315P
+ PS=2.34U PD=2.34U
* device instance _4757 r0 *1 98.565,572.825 nfet_05v0
XM_4757 VSS n_I4660 n_I378 VSS nfet_05v0 L=0.6U W=0.42U AS=0.315P AD=0.315P
+ PS=2.34U PD=2.34U
* device instance _4758 r0 *1 258.565,338.825 nfet_05v0
XM_4758 VSS n_I4661 n_I377 VSS nfet_05v0 L=0.6U W=0.42U AS=0.315P AD=0.315P
+ PS=2.34U PD=2.34U
* device instance _4759 r0 *1 618.565,26.825 nfet_05v0
XM_4759 VSS n_I4662 n_I376 VSS nfet_05v0 L=0.6U W=0.42U AS=0.315P AD=0.315P
+ PS=2.34U PD=2.34U
* device instance _4760 r0 *1 178.565,416.825 nfet_05v0
XM_4760 VSS n_I4663 n_I375 VSS nfet_05v0 L=0.6U W=0.42U AS=0.315P AD=0.315P
+ PS=2.34U PD=2.34U
* device instance _4761 r0 *1 458.565,104.825 nfet_05v0
XM_4761 VSS n_I4664 n_I374 VSS nfet_05v0 L=0.6U W=0.42U AS=0.315P AD=0.315P
+ PS=2.34U PD=2.34U
* device instance _4762 r0 *1 498.565,104.825 nfet_05v0
XM_4762 VSS n_I4665 n_I373 VSS nfet_05v0 L=0.6U W=0.42U AS=0.315P AD=0.315P
+ PS=2.34U PD=2.34U
* device instance _4763 r0 *1 618.565,182.825 nfet_05v0
XM_4763 VSS n_I4666 n_I372 VSS nfet_05v0 L=0.6U W=0.42U AS=0.315P AD=0.315P
+ PS=2.34U PD=2.34U
* device instance _4764 r0 *1 658.565,182.825 nfet_05v0
XM_4764 VSS n_I4667 n_I371 VSS nfet_05v0 L=0.6U W=0.42U AS=0.315P AD=0.315P
+ PS=2.34U PD=2.34U
* device instance _4765 r0 *1 538.565,182.825 nfet_05v0
XM_4765 VSS n_I4668 n_I370 VSS nfet_05v0 L=0.6U W=0.42U AS=0.315P AD=0.315P
+ PS=2.34U PD=2.34U
* device instance _4766 r0 *1 578.565,182.825 nfet_05v0
XM_4766 VSS n_I4669 n_I369 VSS nfet_05v0 L=0.6U W=0.42U AS=0.315P AD=0.315P
+ PS=2.34U PD=2.34U
* device instance _4767 r0 *1 538.565,104.825 nfet_05v0
XM_4767 VSS n_I4670 n_I368 VSS nfet_05v0 L=0.6U W=0.42U AS=0.315P AD=0.315P
+ PS=2.34U PD=2.34U
* device instance _4768 r0 *1 578.565,104.825 nfet_05v0
XM_4768 VSS n_I4671 n_I367 VSS nfet_05v0 L=0.6U W=0.42U AS=0.315P AD=0.315P
+ PS=2.34U PD=2.34U
* device instance _4769 r0 *1 98.565,338.825 nfet_05v0
XM_4769 VSS n_I4672 n_I366 VSS nfet_05v0 L=0.6U W=0.42U AS=0.315P AD=0.315P
+ PS=2.34U PD=2.34U
* device instance _4770 r0 *1 578.565,26.825 nfet_05v0
XM_4770 VSS n_I4673 n_I365 VSS nfet_05v0 L=0.6U W=0.42U AS=0.315P AD=0.315P
+ PS=2.34U PD=2.34U
* device instance _4771 r0 *1 418.565,104.825 nfet_05v0
XM_4771 VSS n_I4674 n_I364 VSS nfet_05v0 L=0.6U W=0.42U AS=0.315P AD=0.315P
+ PS=2.34U PD=2.34U
* device instance _4772 r0 *1 658.565,104.825 nfet_05v0
XM_4772 VSS n_I4675 n_I363 VSS nfet_05v0 L=0.6U W=0.42U AS=0.315P AD=0.315P
+ PS=2.34U PD=2.34U
* device instance _4773 r0 *1 658.565,26.825 nfet_05v0
XM_4773 VSS n_I4676 n_I362 VSS nfet_05v0 L=0.6U W=0.42U AS=0.315P AD=0.315P
+ PS=2.34U PD=2.34U
* device instance _4774 r0 *1 58.565,416.825 nfet_05v0
XM_4774 VSS n_I4677 n_I361 VSS nfet_05v0 L=0.6U W=0.42U AS=0.315P AD=0.315P
+ PS=2.34U PD=2.34U
* device instance _4775 r0 *1 378.565,104.825 nfet_05v0
XM_4775 VSS n_I4678 n_I360 VSS nfet_05v0 L=0.6U W=0.42U AS=0.315P AD=0.315P
+ PS=2.34U PD=2.34U
* device instance _4776 r0 *1 218.565,338.825 nfet_05v0
XM_4776 VSS n_I4679 n_I359 VSS nfet_05v0 L=0.6U W=0.42U AS=0.315P AD=0.315P
+ PS=2.34U PD=2.34U
* device instance _4777 r0 *1 298.565,416.825 nfet_05v0
XM_4777 VSS n_I4680 n_I358 VSS nfet_05v0 L=0.6U W=0.42U AS=0.315P AD=0.315P
+ PS=2.34U PD=2.34U
* device instance _4778 r0 *1 338.565,572.825 nfet_05v0
XM_4778 VSS n_I4681 n_I357 VSS nfet_05v0 L=0.6U W=0.42U AS=0.315P AD=0.315P
+ PS=2.34U PD=2.34U
* device instance _4779 r0 *1 258.565,416.825 nfet_05v0
XM_4779 VSS n_I4682 n_I356 VSS nfet_05v0 L=0.6U W=0.42U AS=0.315P AD=0.315P
+ PS=2.34U PD=2.34U
* device instance _4780 r0 *1 298.565,338.825 nfet_05v0
XM_4780 VSS n_I4683 n_I355 VSS nfet_05v0 L=0.6U W=0.42U AS=0.315P AD=0.315P
+ PS=2.34U PD=2.34U
* device instance _4781 r0 *1 618.565,104.825 nfet_05v0
XM_4781 VSS n_I4684 n_I354 VSS nfet_05v0 L=0.6U W=0.42U AS=0.315P AD=0.315P
+ PS=2.34U PD=2.34U
* device instance _4782 r0 *1 338.565,416.825 nfet_05v0
XM_4782 VSS n_I4685 n_I353 VSS nfet_05v0 L=0.6U W=0.42U AS=0.315P AD=0.315P
+ PS=2.34U PD=2.34U
* device instance _4783 r0 *1 178.565,338.825 nfet_05v0
XM_4783 VSS n_I4686 n_I352 VSS nfet_05v0 L=0.6U W=0.42U AS=0.315P AD=0.315P
+ PS=2.34U PD=2.34U
* device instance _4784 r0 *1 338.565,338.825 nfet_05v0
XM_4784 VSS n_I4687 n_I351 VSS nfet_05v0 L=0.6U W=0.42U AS=0.315P AD=0.315P
+ PS=2.34U PD=2.34U
* device instance _4785 r0 *1 338.565,260.825 nfet_05v0
XM_4785 VSS n_I4688 n_I350 VSS nfet_05v0 L=0.6U W=0.42U AS=0.315P AD=0.315P
+ PS=2.34U PD=2.34U
* device instance _4786 r0 *1 338.565,182.825 nfet_05v0
XM_4786 VSS n_I4689 n_I349 VSS nfet_05v0 L=0.6U W=0.42U AS=0.315P AD=0.315P
+ PS=2.34U PD=2.34U
* device instance _4787 r0 *1 338.565,104.825 nfet_05v0
XM_4787 VSS n_I4690 n_I348 VSS nfet_05v0 L=0.6U W=0.42U AS=0.315P AD=0.315P
+ PS=2.34U PD=2.34U
* device instance _4788 r0 *1 338.565,26.825 nfet_05v0
XM_4788 VSS n_I4691 n_I347 VSS nfet_05v0 L=0.6U W=0.42U AS=0.315P AD=0.315P
+ PS=2.34U PD=2.34U
* device instance _4789 r0 *1 178.565,260.825 nfet_05v0
XM_4789 VSS n_I4692 n_I346 VSS nfet_05v0 L=0.6U W=0.42U AS=0.315P AD=0.315P
+ PS=2.34U PD=2.34U
* device instance _4790 r0 *1 178.565,182.825 nfet_05v0
XM_4790 VSS n_I4693 n_I345 VSS nfet_05v0 L=0.6U W=0.42U AS=0.315P AD=0.315P
+ PS=2.34U PD=2.34U
* device instance _4791 r0 *1 218.565,572.825 nfet_05v0
XM_4791 VSS n_I4694 n_I344 VSS nfet_05v0 L=0.6U W=0.42U AS=0.315P AD=0.315P
+ PS=2.34U PD=2.34U
* device instance _4792 r0 *1 378.565,494.825 nfet_05v0
XM_4792 VSS n_I4695 n_I343 VSS nfet_05v0 L=0.6U W=0.42U AS=0.315P AD=0.315P
+ PS=2.34U PD=2.34U
* device instance _4793 r0 *1 418.565,494.825 nfet_05v0
XM_4793 VSS n_I4696 n_I342 VSS nfet_05v0 L=0.6U W=0.42U AS=0.315P AD=0.315P
+ PS=2.34U PD=2.34U
* device instance _4794 r0 *1 458.565,494.825 nfet_05v0
XM_4794 VSS n_I4697 n_I341 VSS nfet_05v0 L=0.6U W=0.42U AS=0.315P AD=0.315P
+ PS=2.34U PD=2.34U
* device instance _4795 r0 *1 498.565,494.825 nfet_05v0
XM_4795 VSS n_I4698 n_I340 VSS nfet_05v0 L=0.6U W=0.42U AS=0.315P AD=0.315P
+ PS=2.34U PD=2.34U
* device instance _4796 r0 *1 658.565,494.825 nfet_05v0
XM_4796 VSS n_I4699 n_I339 VSS nfet_05v0 L=0.6U W=0.42U AS=0.315P AD=0.315P
+ PS=2.34U PD=2.34U
* device instance _4797 r0 *1 58.565,338.825 nfet_05v0
XM_4797 VSS n_I4700 n_I338 VSS nfet_05v0 L=0.6U W=0.42U AS=0.315P AD=0.315P
+ PS=2.34U PD=2.34U
* device instance _4798 r0 *1 578.565,494.825 nfet_05v0
XM_4798 VSS n_I4701 n_I337 VSS nfet_05v0 L=0.6U W=0.42U AS=0.315P AD=0.315P
+ PS=2.34U PD=2.34U
* device instance _4799 r0 *1 618.565,494.825 nfet_05v0
XM_4799 VSS n_I4702 n_I336 VSS nfet_05v0 L=0.6U W=0.42U AS=0.315P AD=0.315P
+ PS=2.34U PD=2.34U
* device instance _4800 r0 *1 178.565,494.825 nfet_05v0
XM_4800 VSS n_I4703 n_I335 VSS nfet_05v0 L=0.6U W=0.42U AS=0.315P AD=0.315P
+ PS=2.34U PD=2.34U
* device instance _4801 r0 *1 218.565,260.825 nfet_05v0
XM_4801 VSS n_I4704 n_I334 VSS nfet_05v0 L=0.6U W=0.42U AS=0.315P AD=0.315P
+ PS=2.34U PD=2.34U
* device instance _4802 r0 *1 98.565,494.825 nfet_05v0
XM_4802 VSS n_I4705 n_I333 VSS nfet_05v0 L=0.6U W=0.42U AS=0.315P AD=0.315P
+ PS=2.34U PD=2.34U
* device instance _4803 r0 *1 138.565,494.825 nfet_05v0
XM_4803 VSS n_I4706 n_I332 VSS nfet_05v0 L=0.6U W=0.42U AS=0.315P AD=0.315P
+ PS=2.34U PD=2.34U
* device instance _4804 r0 *1 58.565,494.825 nfet_05v0
XM_4804 VSS n_I4707 n_I331 VSS nfet_05v0 L=0.6U W=0.42U AS=0.315P AD=0.315P
+ PS=2.34U PD=2.34U
* device instance _4805 r0 *1 218.565,494.825 nfet_05v0
XM_4805 VSS n_I4708 n_I330 VSS nfet_05v0 L=0.6U W=0.42U AS=0.315P AD=0.315P
+ PS=2.34U PD=2.34U
* device instance _4806 r0 *1 258.565,494.825 nfet_05v0
XM_4806 VSS n_I4709 n_I329 VSS nfet_05v0 L=0.6U W=0.42U AS=0.315P AD=0.315P
+ PS=2.34U PD=2.34U
* device instance _4807 r0 *1 298.565,494.825 nfet_05v0
XM_4807 VSS n_I4710 n_I328 VSS nfet_05v0 L=0.6U W=0.42U AS=0.315P AD=0.315P
+ PS=2.34U PD=2.34U
* device instance _4808 r0 *1 258.565,260.825 nfet_05v0
XM_4808 VSS n_I4711 n_I327 VSS nfet_05v0 L=0.6U W=0.42U AS=0.315P AD=0.315P
+ PS=2.34U PD=2.34U
* device instance _4809 r0 *1 298.565,260.825 nfet_05v0
XM_4809 VSS n_I4712 n_I326 VSS nfet_05v0 L=0.6U W=0.42U AS=0.315P AD=0.315P
+ PS=2.34U PD=2.34U
* device instance _4810 r0 *1 98.565,260.825 nfet_05v0
XM_4810 VSS n_I4713 n_I325 VSS nfet_05v0 L=0.6U W=0.42U AS=0.315P AD=0.315P
+ PS=2.34U PD=2.34U
* device instance _4811 r0 *1 138.565,260.825 nfet_05v0
XM_4811 VSS n_I4714 n_I324 VSS nfet_05v0 L=0.6U W=0.42U AS=0.315P AD=0.315P
+ PS=2.34U PD=2.34U
* device instance _4812 r0 *1 58.565,260.825 nfet_05v0
XM_4812 VSS n_I4715 n_I323 VSS nfet_05v0 L=0.6U W=0.42U AS=0.315P AD=0.315P
+ PS=2.34U PD=2.34U
* device instance _4813 r0 *1 538.565,494.825 nfet_05v0
XM_4813 VSS n_I4716 n_I322 VSS nfet_05v0 L=0.6U W=0.42U AS=0.315P AD=0.315P
+ PS=2.34U PD=2.34U
* device instance _4814 r0 *1 498.565,338.825 nfet_05v0
XM_4814 VSS n_I4717 n_I321 VSS nfet_05v0 L=0.6U W=0.42U AS=0.315P AD=0.315P
+ PS=2.34U PD=2.34U
* device instance _4815 r0 *1 218.565,26.825 nfet_05v0
XM_4815 VSS n_I4718 n_I320 VSS nfet_05v0 L=0.6U W=0.42U AS=0.315P AD=0.315P
+ PS=2.34U PD=2.34U
* device instance _4816 r0 *1 458.565,338.825 nfet_05v0
XM_4816 VSS n_I4719 n_I319 VSS nfet_05v0 L=0.6U W=0.42U AS=0.315P AD=0.315P
+ PS=2.34U PD=2.34U
* device instance _4817 r0 *1 378.565,572.825 nfet_05v0
XM_4817 VSS n_I4720 n_I318 VSS nfet_05v0 L=0.6U W=0.42U AS=0.315P AD=0.315P
+ PS=2.34U PD=2.34U
* device instance _4818 r0 *1 418.565,338.825 nfet_05v0
XM_4818 VSS n_I4721 n_I317 VSS nfet_05v0 L=0.6U W=0.42U AS=0.315P AD=0.315P
+ PS=2.34U PD=2.34U
* device instance _4819 r0 *1 498.565,416.825 nfet_05v0
XM_4819 VSS n_I4722 n_I316 VSS nfet_05v0 L=0.6U W=0.42U AS=0.315P AD=0.315P
+ PS=2.34U PD=2.34U
* device instance _4820 r0 *1 378.565,338.825 nfet_05v0
XM_4820 VSS n_I4723 n_I315 VSS nfet_05v0 L=0.6U W=0.42U AS=0.315P AD=0.315P
+ PS=2.34U PD=2.34U
* device instance _4821 r0 *1 378.565,416.825 nfet_05v0
XM_4821 VSS n_I4724 n_I314 VSS nfet_05v0 L=0.6U W=0.42U AS=0.315P AD=0.315P
+ PS=2.34U PD=2.34U
* device instance _4822 r0 *1 458.565,416.825 nfet_05v0
XM_4822 VSS n_I4725 n_I313 VSS nfet_05v0 L=0.6U W=0.42U AS=0.315P AD=0.315P
+ PS=2.34U PD=2.34U
* device instance _4823 r0 *1 258.565,26.825 nfet_05v0
XM_4823 VSS n_I4726 n_I312 VSS nfet_05v0 L=0.6U W=0.42U AS=0.315P AD=0.315P
+ PS=2.34U PD=2.34U
* device instance _4824 r0 *1 418.565,416.825 nfet_05v0
XM_4824 VSS n_I4727 n_I311 VSS nfet_05v0 L=0.6U W=0.42U AS=0.315P AD=0.315P
+ PS=2.34U PD=2.34U
* device instance _4825 r0 *1 618.565,416.825 nfet_05v0
XM_4825 VSS n_I4728 n_I310 VSS nfet_05v0 L=0.6U W=0.42U AS=0.315P AD=0.315P
+ PS=2.34U PD=2.34U
* device instance _4826 r0 *1 578.565,416.825 nfet_05v0
XM_4826 VSS n_I4729 n_I309 VSS nfet_05v0 L=0.6U W=0.42U AS=0.315P AD=0.315P
+ PS=2.34U PD=2.34U
* device instance _4827 r0 *1 618.565,338.825 nfet_05v0
XM_4827 VSS n_I4730 n_I308 VSS nfet_05v0 L=0.6U W=0.42U AS=0.315P AD=0.315P
+ PS=2.34U PD=2.34U
* device instance _4828 r0 *1 618.565,572.825 nfet_05v0
XM_4828 VSS n_I4731 n_I307 VSS nfet_05v0 L=0.6U W=0.42U AS=0.315P AD=0.315P
+ PS=2.34U PD=2.34U
* device instance _4829 r0 *1 338.565,494.825 nfet_05v0
XM_4829 VSS n_I4732 n_I306 VSS nfet_05v0 L=0.6U W=0.42U AS=0.315P AD=0.315P
+ PS=2.34U PD=2.34U
* device instance _4830 r0 *1 538.565,338.825 nfet_05v0
XM_4830 VSS n_I4733 n_I305 VSS nfet_05v0 L=0.6U W=0.42U AS=0.315P AD=0.315P
+ PS=2.34U PD=2.34U
* device instance _4831 r0 *1 578.565,572.825 nfet_05v0
XM_4831 VSS n_I4734 n_I304 VSS nfet_05v0 L=0.6U W=0.42U AS=0.315P AD=0.315P
+ PS=2.34U PD=2.34U
* device instance _4832 r0 *1 658.565,572.825 nfet_05v0
XM_4832 VSS n_I4735 n_I303 VSS nfet_05v0 L=0.6U W=0.42U AS=0.315P AD=0.315P
+ PS=2.34U PD=2.34U
* device instance _4833 r0 *1 578.565,260.825 nfet_05v0
XM_4833 VSS n_I4736 n_I302 VSS nfet_05v0 L=0.6U W=0.42U AS=0.315P AD=0.315P
+ PS=2.34U PD=2.34U
* device instance _4834 r0 *1 618.565,260.825 nfet_05v0
XM_4834 VSS n_I4737 n_I301 VSS nfet_05v0 L=0.6U W=0.42U AS=0.315P AD=0.315P
+ PS=2.34U PD=2.34U
* device instance _4835 r0 *1 658.565,260.825 nfet_05v0
XM_4835 VSS n_I4738 n_I300 VSS nfet_05v0 L=0.6U W=0.42U AS=0.315P AD=0.315P
+ PS=2.34U PD=2.34U
* device instance _4836 r0 *1 578.565,338.825 nfet_05v0
XM_4836 VSS n_I4739 n_I299 VSS nfet_05v0 L=0.6U W=0.42U AS=0.315P AD=0.315P
+ PS=2.34U PD=2.34U
* device instance _4837 r0 *1 538.565,416.825 nfet_05v0
XM_4837 VSS n_I4740 n_I298 VSS nfet_05v0 L=0.6U W=0.42U AS=0.315P AD=0.315P
+ PS=2.34U PD=2.34U
* device instance _4838 r0 *1 538.565,260.825 nfet_05v0
XM_4838 VSS n_I4741 n_I297 VSS nfet_05v0 L=0.6U W=0.42U AS=0.315P AD=0.315P
+ PS=2.34U PD=2.34U
* device instance _4839 r0 *1 498.565,260.825 nfet_05v0
XM_4839 VSS n_I4742 n_I296 VSS nfet_05v0 L=0.6U W=0.42U AS=0.315P AD=0.315P
+ PS=2.34U PD=2.34U
* device instance _4840 r0 *1 458.565,260.825 nfet_05v0
XM_4840 VSS n_I4743 n_I295 VSS nfet_05v0 L=0.6U W=0.42U AS=0.315P AD=0.315P
+ PS=2.34U PD=2.34U
* device instance _4841 r0 *1 378.565,260.825 nfet_05v0
XM_4841 VSS n_I4744 n_I294 VSS nfet_05v0 L=0.6U W=0.42U AS=0.315P AD=0.315P
+ PS=2.34U PD=2.34U
* device instance _4842 r0 *1 418.565,260.825 nfet_05v0
XM_4842 VSS n_I4745 n_I293 VSS nfet_05v0 L=0.6U W=0.42U AS=0.315P AD=0.315P
+ PS=2.34U PD=2.34U
* device instance _4843 r0 *1 658.565,416.825 nfet_05v0
XM_4843 VSS n_I4746 n_I292 VSS nfet_05v0 L=0.6U W=0.42U AS=0.315P AD=0.315P
+ PS=2.34U PD=2.34U
* device instance _4844 r0 *1 658.565,338.825 nfet_05v0
XM_4844 VSS n_I4747 n_I291 VSS nfet_05v0 L=0.6U W=0.42U AS=0.315P AD=0.315P
+ PS=2.34U PD=2.34U
* device instance _4845 r0 *1 538.565,572.825 nfet_05v0
XM_4845 VSS n_I4748 n_I290 VSS nfet_05v0 L=0.6U W=0.42U AS=0.315P AD=0.315P
+ PS=2.34U PD=2.34U
* device instance _4846 r0 *1 98.565,416.825 nfet_05v0
XM_4846 VSS n_I4749 n_I289 VSS nfet_05v0 L=0.6U W=0.42U AS=0.315P AD=0.315P
+ PS=2.34U PD=2.34U
* device instance _4847 r0 *1 378.565,26.825 nfet_05v0
XM_4847 VSS n_I4750 n_I288 VSS nfet_05v0 L=0.6U W=0.42U AS=0.315P AD=0.315P
+ PS=2.34U PD=2.34U
* device instance _4848 r0 *1 138.565,572.825 nfet_05v0
XM_4848 VSS n_I4751 n_I287 VSS nfet_05v0 L=0.6U W=0.42U AS=0.315P AD=0.315P
+ PS=2.34U PD=2.34U
* device instance _4849 r0 *1 58.565,572.825 nfet_05v0
XM_4849 VSS n_I4752 n_I286 VSS nfet_05v0 L=0.6U W=0.42U AS=0.315P AD=0.315P
+ PS=2.34U PD=2.34U
* device instance _4850 r0 *1 138.565,338.825 nfet_05v0
XM_4850 VSS n_I4753 n_I285 VSS nfet_05v0 L=0.6U W=0.42U AS=0.315P AD=0.315P
+ PS=2.34U PD=2.34U
* device instance _4851 r0 *1 138.565,416.825 nfet_05v0
XM_4851 VSS n_I4754 n_I284 VSS nfet_05v0 L=0.6U W=0.42U AS=0.315P AD=0.315P
+ PS=2.34U PD=2.34U
* device instance _4852 r0 *1 58.565,104.825 nfet_05v0
XM_4852 VSS n_I4755 n_I283 VSS nfet_05v0 L=0.6U W=0.42U AS=0.315P AD=0.315P
+ PS=2.34U PD=2.34U
* device instance _4853 r0 *1 98.565,104.825 nfet_05v0
XM_4853 VSS n_I4756 n_I282 VSS nfet_05v0 L=0.6U W=0.42U AS=0.315P AD=0.315P
+ PS=2.34U PD=2.34U
* device instance _4854 r0 *1 138.565,104.825 nfet_05v0
XM_4854 VSS n_I4757 n_I281 VSS nfet_05v0 L=0.6U W=0.42U AS=0.315P AD=0.315P
+ PS=2.34U PD=2.34U
* device instance _4855 r0 *1 98.565,26.825 nfet_05v0
XM_4855 VSS n_I4758 n_I280 VSS nfet_05v0 L=0.6U W=0.42U AS=0.315P AD=0.315P
+ PS=2.34U PD=2.34U
* device instance _4856 r0 *1 458.565,26.825 nfet_05v0
XM_4856 VSS n_I4759 n_I279 VSS nfet_05v0 L=0.6U W=0.42U AS=0.315P AD=0.315P
+ PS=2.34U PD=2.34U
* device instance _4857 r0 *1 138.565,26.825 nfet_05v0
XM_4857 VSS n_I4760 n_I278 VSS nfet_05v0 L=0.6U W=0.42U AS=0.315P AD=0.315P
+ PS=2.34U PD=2.34U
* device instance _4858 r0 *1 138.565,182.825 nfet_05v0
XM_4858 VSS n_I4761 n_I277 VSS nfet_05v0 L=0.6U W=0.42U AS=0.315P AD=0.315P
+ PS=2.34U PD=2.34U
* device instance _4859 r0 *1 58.565,182.825 nfet_05v0
XM_4859 VSS n_I4762 n_I276 VSS nfet_05v0 L=0.6U W=0.42U AS=0.315P AD=0.315P
+ PS=2.34U PD=2.34U
* device instance _4860 r0 *1 258.565,182.825 nfet_05v0
XM_4860 VSS n_I4763 n_I275 VSS nfet_05v0 L=0.6U W=0.42U AS=0.315P AD=0.315P
+ PS=2.34U PD=2.34U
* device instance _4861 r0 *1 218.565,104.825 nfet_05v0
XM_4861 VSS n_I4764 n_I274 VSS nfet_05v0 L=0.6U W=0.42U AS=0.315P AD=0.315P
+ PS=2.34U PD=2.34U
* device instance _4862 r0 *1 258.565,104.825 nfet_05v0
XM_4862 VSS n_I4765 n_I273 VSS nfet_05v0 L=0.6U W=0.42U AS=0.315P AD=0.315P
+ PS=2.34U PD=2.34U
* device instance _4863 r0 *1 178.565,572.825 nfet_05v0
XM_4863 VSS n_I4766 n_I272 VSS nfet_05v0 L=0.6U W=0.42U AS=0.315P AD=0.315P
+ PS=2.34U PD=2.34U
* device instance _4864 r0 *1 298.565,182.825 nfet_05v0
XM_4864 VSS n_I4767 n_I271 VSS nfet_05v0 L=0.6U W=0.42U AS=0.315P AD=0.315P
+ PS=2.34U PD=2.34U
* device instance _4865 r0 *1 298.565,104.825 nfet_05v0
XM_4865 VSS n_I4768 n_I270 VSS nfet_05v0 L=0.6U W=0.42U AS=0.315P AD=0.315P
+ PS=2.34U PD=2.34U
* device instance _4866 r0 *1 378.565,182.825 nfet_05v0
XM_4866 VSS n_I4769 n_I269 VSS nfet_05v0 L=0.6U W=0.42U AS=0.315P AD=0.315P
+ PS=2.34U PD=2.34U
* device instance _4867 r0 *1 418.565,182.825 nfet_05v0
XM_4867 VSS n_I4770 n_I268 VSS nfet_05v0 L=0.6U W=0.42U AS=0.315P AD=0.315P
+ PS=2.34U PD=2.34U
* device instance _4868 r0 *1 98.565,182.825 nfet_05v0
XM_4868 VSS n_I4771 n_I267 VSS nfet_05v0 L=0.6U W=0.42U AS=0.315P AD=0.315P
+ PS=2.34U PD=2.34U
* device instance _4869 r0 *1 498.565,182.825 nfet_05v0
XM_4869 VSS n_I4772 n_I266 VSS nfet_05v0 L=0.6U W=0.42U AS=0.315P AD=0.315P
+ PS=2.34U PD=2.34U
* device instance _4870 r0 *1 498.565,572.825 nfet_05v0
XM_4870 VSS n_I4773 n_I265 VSS nfet_05v0 L=0.6U W=0.42U AS=0.315P AD=0.315P
+ PS=2.34U PD=2.34U
* device instance _4871 r0 *1 458.565,572.825 nfet_05v0
XM_4871 VSS n_I4774 n_I264 VSS nfet_05v0 L=0.6U W=0.42U AS=0.315P AD=0.315P
+ PS=2.34U PD=2.34U
* device instance _4872 r0 *1 418.565,26.825 nfet_05v0
XM_4872 VSS n_I4775 n_I263 VSS nfet_05v0 L=0.6U W=0.42U AS=0.315P AD=0.315P
+ PS=2.34U PD=2.34U
* device instance _4873 r0 *1 418.565,572.825 nfet_05v0
XM_4873 VSS n_I4776 n_I262 VSS nfet_05v0 L=0.6U W=0.42U AS=0.315P AD=0.315P
+ PS=2.34U PD=2.34U
* device instance _4874 r0 *1 298.565,26.825 nfet_05v0
XM_4874 VSS n_I4777 n_I261 VSS nfet_05v0 L=0.6U W=0.42U AS=0.315P AD=0.315P
+ PS=2.34U PD=2.34U
* device instance _4875 r0 *1 218.565,182.825 nfet_05v0
XM_4875 VSS n_I4778 n_I260 VSS nfet_05v0 L=0.6U W=0.42U AS=0.315P AD=0.315P
+ PS=2.34U PD=2.34U
* device instance _4876 r0 *1 498.565,26.825 nfet_05v0
XM_4876 VSS n_I4779 n_I259 VSS nfet_05v0 L=0.6U W=0.42U AS=0.315P AD=0.315P
+ PS=2.34U PD=2.34U
* device instance _4877 r0 *1 458.565,182.825 nfet_05v0
XM_4877 VSS n_I4780 n_I258 VSS nfet_05v0 L=0.6U W=0.42U AS=0.315P AD=0.315P
+ PS=2.34U PD=2.34U
* device instance _5006 r0 *1 58.565,28.74 nfet_05v0
XM_5006 VSS n_6 n_I4653 VSS nfet_05v0 L=0.6U W=1U AS=0.73P AD=0.73P PS=3.46U
+ PD=3.46U
* device instance _5007 r0 *1 258.565,574.74 nfet_05v0
XM_5007 VSS n_270 n_I4654 VSS nfet_05v0 L=0.6U W=1U AS=0.73P AD=0.73P PS=3.46U
+ PD=3.46U
* device instance _5008 r0 *1 538.565,28.74 nfet_05v0
XM_5008 VSS n_18 n_I4655 VSS nfet_05v0 L=0.6U W=1U AS=0.73P AD=0.73P PS=3.46U
+ PD=3.46U
* device instance _5009 r0 *1 178.565,106.74 nfet_05v0
XM_5009 VSS n_28 n_I4656 VSS nfet_05v0 L=0.6U W=1U AS=0.73P AD=0.73P PS=3.46U
+ PD=3.46U
* device instance _5010 r0 *1 218.565,418.74 nfet_05v0
XM_5010 VSS n_158 n_I4657 VSS nfet_05v0 L=0.6U W=1U AS=0.73P AD=0.73P PS=3.46U
+ PD=3.46U
* device instance _5011 r0 *1 178.565,28.74 nfet_05v0
XM_5011 VSS n_9 n_I4658 VSS nfet_05v0 L=0.6U W=1U AS=0.73P AD=0.73P PS=3.46U
+ PD=3.46U
* device instance _5012 r0 *1 298.565,574.74 nfet_05v0
XM_5012 VSS n_271 n_I4659 VSS nfet_05v0 L=0.6U W=1U AS=0.73P AD=0.73P PS=3.46U
+ PD=3.46U
* device instance _5013 r0 *1 98.565,574.74 nfet_05v0
XM_5013 VSS n_266 n_I4660 VSS nfet_05v0 L=0.6U W=1U AS=0.73P AD=0.73P PS=3.46U
+ PD=3.46U
* device instance _5014 r0 *1 258.565,340.74 nfet_05v0
XM_5014 VSS n_162 n_I4661 VSS nfet_05v0 L=0.6U W=1U AS=0.73P AD=0.73P PS=3.46U
+ PD=3.46U
* device instance _5015 r0 *1 618.565,28.74 nfet_05v0
XM_5015 VSS n_20 n_I4662 VSS nfet_05v0 L=0.6U W=1U AS=0.73P AD=0.73P PS=3.46U
+ PD=3.46U
* device instance _5016 r0 *1 178.565,418.74 nfet_05v0
XM_5016 VSS n_155 n_I4663 VSS nfet_05v0 L=0.6U W=1U AS=0.73P AD=0.73P PS=3.46U
+ PD=3.46U
* device instance _5017 r0 *1 458.565,106.74 nfet_05v0
XM_5017 VSS n_35 n_I4664 VSS nfet_05v0 L=0.6U W=1U AS=0.73P AD=0.73P PS=3.46U
+ PD=3.46U
* device instance _5018 r0 *1 498.565,106.74 nfet_05v0
XM_5018 VSS n_36 n_I4665 VSS nfet_05v0 L=0.6U W=1U AS=0.73P AD=0.73P PS=3.46U
+ PD=3.46U
* device instance _5019 r0 *1 618.565,184.74 nfet_05v0
XM_5019 VSS n_111 n_I4666 VSS nfet_05v0 L=0.6U W=1U AS=0.73P AD=0.73P PS=3.46U
+ PD=3.46U
* device instance _5020 r0 *1 658.565,184.74 nfet_05v0
XM_5020 VSS n_113 n_I4667 VSS nfet_05v0 L=0.6U W=1U AS=0.73P AD=0.73P PS=3.46U
+ PD=3.46U
* device instance _5021 r0 *1 538.565,184.74 nfet_05v0
XM_5021 VSS n_107 n_I4668 VSS nfet_05v0 L=0.6U W=1U AS=0.73P AD=0.73P PS=3.46U
+ PD=3.46U
* device instance _5022 r0 *1 578.565,184.74 nfet_05v0
XM_5022 VSS n_109 n_I4669 VSS nfet_05v0 L=0.6U W=1U AS=0.73P AD=0.73P PS=3.46U
+ PD=3.46U
* device instance _5023 r0 *1 538.565,106.74 nfet_05v0
XM_5023 VSS n_37 n_I4670 VSS nfet_05v0 L=0.6U W=1U AS=0.73P AD=0.73P PS=3.46U
+ PD=3.46U
* device instance _5024 r0 *1 578.565,106.74 nfet_05v0
XM_5024 VSS n_38 n_I4671 VSS nfet_05v0 L=0.6U W=1U AS=0.73P AD=0.73P PS=3.46U
+ PD=3.46U
* device instance _5025 r0 *1 98.565,340.74 nfet_05v0
XM_5025 VSS n_150 n_I4672 VSS nfet_05v0 L=0.6U W=1U AS=0.73P AD=0.73P PS=3.46U
+ PD=3.46U
* device instance _5026 r0 *1 578.565,28.74 nfet_05v0
XM_5026 VSS n_19 n_I4673 VSS nfet_05v0 L=0.6U W=1U AS=0.73P AD=0.73P PS=3.46U
+ PD=3.46U
* device instance _5027 r0 *1 418.565,106.74 nfet_05v0
XM_5027 VSS n_34 n_I4674 VSS nfet_05v0 L=0.6U W=1U AS=0.73P AD=0.73P PS=3.46U
+ PD=3.46U
* device instance _5028 r0 *1 658.565,106.74 nfet_05v0
XM_5028 VSS n_40 n_I4675 VSS nfet_05v0 L=0.6U W=1U AS=0.73P AD=0.73P PS=3.46U
+ PD=3.46U
* device instance _5029 r0 *1 658.565,28.74 nfet_05v0
XM_5029 VSS n_21 n_I4676 VSS nfet_05v0 L=0.6U W=1U AS=0.73P AD=0.73P PS=3.46U
+ PD=3.46U
* device instance _5030 r0 *1 58.565,418.74 nfet_05v0
XM_5030 VSS n_146 n_I4677 VSS nfet_05v0 L=0.6U W=1U AS=0.73P AD=0.73P PS=3.46U
+ PD=3.46U
* device instance _5031 r0 *1 378.565,106.74 nfet_05v0
XM_5031 VSS n_33 n_I4678 VSS nfet_05v0 L=0.6U W=1U AS=0.73P AD=0.73P PS=3.46U
+ PD=3.46U
* device instance _5032 r0 *1 218.565,340.74 nfet_05v0
XM_5032 VSS n_159 n_I4679 VSS nfet_05v0 L=0.6U W=1U AS=0.73P AD=0.73P PS=3.46U
+ PD=3.46U
* device instance _5033 r0 *1 298.565,418.74 nfet_05v0
XM_5033 VSS n_164 n_I4680 VSS nfet_05v0 L=0.6U W=1U AS=0.73P AD=0.73P PS=3.46U
+ PD=3.46U
* device instance _5034 r0 *1 338.565,574.74 nfet_05v0
XM_5034 VSS n_272 n_I4681 VSS nfet_05v0 L=0.6U W=1U AS=0.73P AD=0.73P PS=3.46U
+ PD=3.46U
* device instance _5035 r0 *1 258.565,418.74 nfet_05v0
XM_5035 VSS n_161 n_I4682 VSS nfet_05v0 L=0.6U W=1U AS=0.73P AD=0.73P PS=3.46U
+ PD=3.46U
* device instance _5036 r0 *1 298.565,340.74 nfet_05v0
XM_5036 VSS n_165 n_I4683 VSS nfet_05v0 L=0.6U W=1U AS=0.73P AD=0.73P PS=3.46U
+ PD=3.46U
* device instance _5037 r0 *1 618.565,106.74 nfet_05v0
XM_5037 VSS n_39 n_I4684 VSS nfet_05v0 L=0.6U W=1U AS=0.73P AD=0.73P PS=3.46U
+ PD=3.46U
* device instance _5038 r0 *1 338.565,418.74 nfet_05v0
XM_5038 VSS n_167 n_I4685 VSS nfet_05v0 L=0.6U W=1U AS=0.73P AD=0.73P PS=3.46U
+ PD=3.46U
* device instance _5039 r0 *1 178.565,340.74 nfet_05v0
XM_5039 VSS n_156 n_I4686 VSS nfet_05v0 L=0.6U W=1U AS=0.73P AD=0.73P PS=3.46U
+ PD=3.46U
* device instance _5040 r0 *1 338.565,340.74 nfet_05v0
XM_5040 VSS n_168 n_I4687 VSS nfet_05v0 L=0.6U W=1U AS=0.73P AD=0.73P PS=3.46U
+ PD=3.46U
* device instance _5041 r0 *1 338.565,262.74 nfet_05v0
XM_5041 VSS n_96 n_I4688 VSS nfet_05v0 L=0.6U W=1U AS=0.73P AD=0.73P PS=3.46U
+ PD=3.46U
* device instance _5042 r0 *1 338.565,184.74 nfet_05v0
XM_5042 VSS n_97 n_I4689 VSS nfet_05v0 L=0.6U W=1U AS=0.73P AD=0.73P PS=3.46U
+ PD=3.46U
* device instance _5043 r0 *1 338.565,106.74 nfet_05v0
XM_5043 VSS n_32 n_I4690 VSS nfet_05v0 L=0.6U W=1U AS=0.73P AD=0.73P PS=3.46U
+ PD=3.46U
* device instance _5044 r0 *1 338.565,28.74 nfet_05v0
XM_5044 VSS n_13 n_I4691 VSS nfet_05v0 L=0.6U W=1U AS=0.73P AD=0.73P PS=3.46U
+ PD=3.46U
* device instance _5045 r0 *1 178.565,262.74 nfet_05v0
XM_5045 VSS n_88 n_I4692 VSS nfet_05v0 L=0.6U W=1U AS=0.73P AD=0.73P PS=3.46U
+ PD=3.46U
* device instance _5046 r0 *1 178.565,184.74 nfet_05v0
XM_5046 VSS n_89 n_I4693 VSS nfet_05v0 L=0.6U W=1U AS=0.73P AD=0.73P PS=3.46U
+ PD=3.46U
* device instance _5047 r0 *1 218.565,574.74 nfet_05v0
XM_5047 VSS n_269 n_I4694 VSS nfet_05v0 L=0.6U W=1U AS=0.73P AD=0.73P PS=3.46U
+ PD=3.46U
* device instance _5048 r0 *1 378.565,496.74 nfet_05v0
XM_5048 VSS n_169 n_I4695 VSS nfet_05v0 L=0.6U W=1U AS=0.73P AD=0.73P PS=3.46U
+ PD=3.46U
* device instance _5049 r0 *1 418.565,496.74 nfet_05v0
XM_5049 VSS n_172 n_I4696 VSS nfet_05v0 L=0.6U W=1U AS=0.73P AD=0.73P PS=3.46U
+ PD=3.46U
* device instance _5050 r0 *1 458.565,496.74 nfet_05v0
XM_5050 VSS n_175 n_I4697 VSS nfet_05v0 L=0.6U W=1U AS=0.73P AD=0.73P PS=3.46U
+ PD=3.46U
* device instance _5051 r0 *1 498.565,496.74 nfet_05v0
XM_5051 VSS n_178 n_I4698 VSS nfet_05v0 L=0.6U W=1U AS=0.73P AD=0.73P PS=3.46U
+ PD=3.46U
* device instance _5052 r0 *1 658.565,496.74 nfet_05v0
XM_5052 VSS n_190 n_I4699 VSS nfet_05v0 L=0.6U W=1U AS=0.73P AD=0.73P PS=3.46U
+ PD=3.46U
* device instance _5053 r0 *1 58.565,340.74 nfet_05v0
XM_5053 VSS n_147 n_I4700 VSS nfet_05v0 L=0.6U W=1U AS=0.73P AD=0.73P PS=3.46U
+ PD=3.46U
* device instance _5054 r0 *1 578.565,496.74 nfet_05v0
XM_5054 VSS n_184 n_I4701 VSS nfet_05v0 L=0.6U W=1U AS=0.73P AD=0.73P PS=3.46U
+ PD=3.46U
* device instance _5055 r0 *1 618.565,496.74 nfet_05v0
XM_5055 VSS n_187 n_I4702 VSS nfet_05v0 L=0.6U W=1U AS=0.73P AD=0.73P PS=3.46U
+ PD=3.46U
* device instance _5056 r0 *1 178.565,496.74 nfet_05v0
XM_5056 VSS n_154 n_I4703 VSS nfet_05v0 L=0.6U W=1U AS=0.73P AD=0.73P PS=3.46U
+ PD=3.46U
* device instance _5057 r0 *1 218.565,262.74 nfet_05v0
XM_5057 VSS n_90 n_I4704 VSS nfet_05v0 L=0.6U W=1U AS=0.73P AD=0.73P PS=3.46U
+ PD=3.46U
* device instance _5058 r0 *1 98.565,496.74 nfet_05v0
XM_5058 VSS n_148 n_I4705 VSS nfet_05v0 L=0.6U W=1U AS=0.73P AD=0.73P PS=3.46U
+ PD=3.46U
* device instance _5059 r0 *1 138.565,496.74 nfet_05v0
XM_5059 VSS n_151 n_I4706 VSS nfet_05v0 L=0.6U W=1U AS=0.73P AD=0.73P PS=3.46U
+ PD=3.46U
* device instance _5060 r0 *1 58.565,496.74 nfet_05v0
XM_5060 VSS n_145 n_I4707 VSS nfet_05v0 L=0.6U W=1U AS=0.73P AD=0.73P PS=3.46U
+ PD=3.46U
* device instance _5061 r0 *1 218.565,496.74 nfet_05v0
XM_5061 VSS n_157 n_I4708 VSS nfet_05v0 L=0.6U W=1U AS=0.73P AD=0.73P PS=3.46U
+ PD=3.46U
* device instance _5062 r0 *1 258.565,496.74 nfet_05v0
XM_5062 VSS n_160 n_I4709 VSS nfet_05v0 L=0.6U W=1U AS=0.73P AD=0.73P PS=3.46U
+ PD=3.46U
* device instance _5063 r0 *1 298.565,496.74 nfet_05v0
XM_5063 VSS n_163 n_I4710 VSS nfet_05v0 L=0.6U W=1U AS=0.73P AD=0.73P PS=3.46U
+ PD=3.46U
* device instance _5064 r0 *1 258.565,262.74 nfet_05v0
XM_5064 VSS n_92 n_I4711 VSS nfet_05v0 L=0.6U W=1U AS=0.73P AD=0.73P PS=3.46U
+ PD=3.46U
* device instance _5065 r0 *1 298.565,262.74 nfet_05v0
XM_5065 VSS n_94 n_I4712 VSS nfet_05v0 L=0.6U W=1U AS=0.73P AD=0.73P PS=3.46U
+ PD=3.46U
* device instance _5066 r0 *1 98.565,262.74 nfet_05v0
XM_5066 VSS n_84 n_I4713 VSS nfet_05v0 L=0.6U W=1U AS=0.73P AD=0.73P PS=3.46U
+ PD=3.46U
* device instance _5067 r0 *1 138.565,262.74 nfet_05v0
XM_5067 VSS n_86 n_I4714 VSS nfet_05v0 L=0.6U W=1U AS=0.73P AD=0.73P PS=3.46U
+ PD=3.46U
* device instance _5068 r0 *1 58.565,262.74 nfet_05v0
XM_5068 VSS n_82 n_I4715 VSS nfet_05v0 L=0.6U W=1U AS=0.73P AD=0.73P PS=3.46U
+ PD=3.46U
* device instance _5069 r0 *1 538.565,496.74 nfet_05v0
XM_5069 VSS n_181 n_I4716 VSS nfet_05v0 L=0.6U W=1U AS=0.73P AD=0.73P PS=3.46U
+ PD=3.46U
* device instance _5070 r0 *1 498.565,340.74 nfet_05v0
XM_5070 VSS n_180 n_I4717 VSS nfet_05v0 L=0.6U W=1U AS=0.73P AD=0.73P PS=3.46U
+ PD=3.46U
* device instance _5071 r0 *1 218.565,28.74 nfet_05v0
XM_5071 VSS n_10 n_I4718 VSS nfet_05v0 L=0.6U W=1U AS=0.73P AD=0.73P PS=3.46U
+ PD=3.46U
* device instance _5072 r0 *1 458.565,340.74 nfet_05v0
XM_5072 VSS n_177 n_I4719 VSS nfet_05v0 L=0.6U W=1U AS=0.73P AD=0.73P PS=3.46U
+ PD=3.46U
* device instance _5073 r0 *1 378.565,574.74 nfet_05v0
XM_5073 VSS n_273 n_I4720 VSS nfet_05v0 L=0.6U W=1U AS=0.73P AD=0.73P PS=3.46U
+ PD=3.46U
* device instance _5074 r0 *1 418.565,340.74 nfet_05v0
XM_5074 VSS n_174 n_I4721 VSS nfet_05v0 L=0.6U W=1U AS=0.73P AD=0.73P PS=3.46U
+ PD=3.46U
* device instance _5075 r0 *1 498.565,418.74 nfet_05v0
XM_5075 VSS n_179 n_I4722 VSS nfet_05v0 L=0.6U W=1U AS=0.73P AD=0.73P PS=3.46U
+ PD=3.46U
* device instance _5076 r0 *1 378.565,340.74 nfet_05v0
XM_5076 VSS n_171 n_I4723 VSS nfet_05v0 L=0.6U W=1U AS=0.73P AD=0.73P PS=3.46U
+ PD=3.46U
* device instance _5077 r0 *1 378.565,418.74 nfet_05v0
XM_5077 VSS n_170 n_I4724 VSS nfet_05v0 L=0.6U W=1U AS=0.73P AD=0.73P PS=3.46U
+ PD=3.46U
* device instance _5078 r0 *1 458.565,418.74 nfet_05v0
XM_5078 VSS n_176 n_I4725 VSS nfet_05v0 L=0.6U W=1U AS=0.73P AD=0.73P PS=3.46U
+ PD=3.46U
* device instance _5079 r0 *1 258.565,28.74 nfet_05v0
XM_5079 VSS n_11 n_I4726 VSS nfet_05v0 L=0.6U W=1U AS=0.73P AD=0.73P PS=3.46U
+ PD=3.46U
* device instance _5080 r0 *1 418.565,418.74 nfet_05v0
XM_5080 VSS n_173 n_I4727 VSS nfet_05v0 L=0.6U W=1U AS=0.73P AD=0.73P PS=3.46U
+ PD=3.46U
* device instance _5081 r0 *1 618.565,418.74 nfet_05v0
XM_5081 VSS n_188 n_I4728 VSS nfet_05v0 L=0.6U W=1U AS=0.73P AD=0.73P PS=3.46U
+ PD=3.46U
* device instance _5082 r0 *1 578.565,418.74 nfet_05v0
XM_5082 VSS n_185 n_I4729 VSS nfet_05v0 L=0.6U W=1U AS=0.73P AD=0.73P PS=3.46U
+ PD=3.46U
* device instance _5083 r0 *1 618.565,340.74 nfet_05v0
XM_5083 VSS n_189 n_I4730 VSS nfet_05v0 L=0.6U W=1U AS=0.73P AD=0.73P PS=3.46U
+ PD=3.46U
* device instance _5084 r0 *1 618.565,574.74 nfet_05v0
XM_5084 VSS n_279 n_I4731 VSS nfet_05v0 L=0.6U W=1U AS=0.73P AD=0.73P PS=3.46U
+ PD=3.46U
* device instance _5085 r0 *1 338.565,496.74 nfet_05v0
XM_5085 VSS n_166 n_I4732 VSS nfet_05v0 L=0.6U W=1U AS=0.73P AD=0.73P PS=3.46U
+ PD=3.46U
* device instance _5086 r0 *1 538.565,340.74 nfet_05v0
XM_5086 VSS n_183 n_I4733 VSS nfet_05v0 L=0.6U W=1U AS=0.73P AD=0.73P PS=3.46U
+ PD=3.46U
* device instance _5087 r0 *1 578.565,574.74 nfet_05v0
XM_5087 VSS n_278 n_I4734 VSS nfet_05v0 L=0.6U W=1U AS=0.73P AD=0.73P PS=3.46U
+ PD=3.46U
* device instance _5088 r0 *1 658.565,574.74 nfet_05v0
XM_5088 VSS n_280 n_I4735 VSS nfet_05v0 L=0.6U W=1U AS=0.73P AD=0.73P PS=3.46U
+ PD=3.46U
* device instance _5089 r0 *1 578.565,262.74 nfet_05v0
XM_5089 VSS n_108 n_I4736 VSS nfet_05v0 L=0.6U W=1U AS=0.73P AD=0.73P PS=3.46U
+ PD=3.46U
* device instance _5090 r0 *1 618.565,262.74 nfet_05v0
XM_5090 VSS n_110 n_I4737 VSS nfet_05v0 L=0.6U W=1U AS=0.73P AD=0.73P PS=3.46U
+ PD=3.46U
* device instance _5091 r0 *1 658.565,262.74 nfet_05v0
XM_5091 VSS n_112 n_I4738 VSS nfet_05v0 L=0.6U W=1U AS=0.73P AD=0.73P PS=3.46U
+ PD=3.46U
* device instance _5092 r0 *1 578.565,340.74 nfet_05v0
XM_5092 VSS n_186 n_I4739 VSS nfet_05v0 L=0.6U W=1U AS=0.73P AD=0.73P PS=3.46U
+ PD=3.46U
* device instance _5093 r0 *1 538.565,418.74 nfet_05v0
XM_5093 VSS n_182 n_I4740 VSS nfet_05v0 L=0.6U W=1U AS=0.73P AD=0.73P PS=3.46U
+ PD=3.46U
* device instance _5094 r0 *1 538.565,262.74 nfet_05v0
XM_5094 VSS n_106 n_I4741 VSS nfet_05v0 L=0.6U W=1U AS=0.73P AD=0.73P PS=3.46U
+ PD=3.46U
* device instance _5095 r0 *1 498.565,262.74 nfet_05v0
XM_5095 VSS n_104 n_I4742 VSS nfet_05v0 L=0.6U W=1U AS=0.73P AD=0.73P PS=3.46U
+ PD=3.46U
* device instance _5096 r0 *1 458.565,262.74 nfet_05v0
XM_5096 VSS n_102 n_I4743 VSS nfet_05v0 L=0.6U W=1U AS=0.73P AD=0.73P PS=3.46U
+ PD=3.46U
* device instance _5097 r0 *1 378.565,262.74 nfet_05v0
XM_5097 VSS n_98 n_I4744 VSS nfet_05v0 L=0.6U W=1U AS=0.73P AD=0.73P PS=3.46U
+ PD=3.46U
* device instance _5098 r0 *1 418.565,262.74 nfet_05v0
XM_5098 VSS n_100 n_I4745 VSS nfet_05v0 L=0.6U W=1U AS=0.73P AD=0.73P PS=3.46U
+ PD=3.46U
* device instance _5099 r0 *1 658.565,418.74 nfet_05v0
XM_5099 VSS n_191 n_I4746 VSS nfet_05v0 L=0.6U W=1U AS=0.73P AD=0.73P PS=3.46U
+ PD=3.46U
* device instance _5100 r0 *1 658.565,340.74 nfet_05v0
XM_5100 VSS n_192 n_I4747 VSS nfet_05v0 L=0.6U W=1U AS=0.73P AD=0.73P PS=3.46U
+ PD=3.46U
* device instance _5101 r0 *1 538.565,574.74 nfet_05v0
XM_5101 VSS n_277 n_I4748 VSS nfet_05v0 L=0.6U W=1U AS=0.73P AD=0.73P PS=3.46U
+ PD=3.46U
* device instance _5102 r0 *1 98.565,418.74 nfet_05v0
XM_5102 VSS n_149 n_I4749 VSS nfet_05v0 L=0.6U W=1U AS=0.73P AD=0.73P PS=3.46U
+ PD=3.46U
* device instance _5103 r0 *1 378.565,28.74 nfet_05v0
XM_5103 VSS n_14 n_I4750 VSS nfet_05v0 L=0.6U W=1U AS=0.73P AD=0.73P PS=3.46U
+ PD=3.46U
* device instance _5104 r0 *1 138.565,574.74 nfet_05v0
XM_5104 VSS n_267 n_I4751 VSS nfet_05v0 L=0.6U W=1U AS=0.73P AD=0.73P PS=3.46U
+ PD=3.46U
* device instance _5105 r0 *1 58.565,574.74 nfet_05v0
XM_5105 VSS n_265 n_I4752 VSS nfet_05v0 L=0.6U W=1U AS=0.73P AD=0.73P PS=3.46U
+ PD=3.46U
* device instance _5106 r0 *1 138.565,340.74 nfet_05v0
XM_5106 VSS n_153 n_I4753 VSS nfet_05v0 L=0.6U W=1U AS=0.73P AD=0.73P PS=3.46U
+ PD=3.46U
* device instance _5107 r0 *1 138.565,418.74 nfet_05v0
XM_5107 VSS n_152 n_I4754 VSS nfet_05v0 L=0.6U W=1U AS=0.73P AD=0.73P PS=3.46U
+ PD=3.46U
* device instance _5108 r0 *1 58.565,106.74 nfet_05v0
XM_5108 VSS n_25 n_I4755 VSS nfet_05v0 L=0.6U W=1U AS=0.73P AD=0.73P PS=3.46U
+ PD=3.46U
* device instance _5109 r0 *1 98.565,106.74 nfet_05v0
XM_5109 VSS n_26 n_I4756 VSS nfet_05v0 L=0.6U W=1U AS=0.73P AD=0.73P PS=3.46U
+ PD=3.46U
* device instance _5110 r0 *1 138.565,106.74 nfet_05v0
XM_5110 VSS n_27 n_I4757 VSS nfet_05v0 L=0.6U W=1U AS=0.73P AD=0.73P PS=3.46U
+ PD=3.46U
* device instance _5111 r0 *1 98.565,28.74 nfet_05v0
XM_5111 VSS n_7 n_I4758 VSS nfet_05v0 L=0.6U W=1U AS=0.73P AD=0.73P PS=3.46U
+ PD=3.46U
* device instance _5112 r0 *1 458.565,28.74 nfet_05v0
XM_5112 VSS n_16 n_I4759 VSS nfet_05v0 L=0.6U W=1U AS=0.73P AD=0.73P PS=3.46U
+ PD=3.46U
* device instance _5113 r0 *1 138.565,28.74 nfet_05v0
XM_5113 VSS n_8 n_I4760 VSS nfet_05v0 L=0.6U W=1U AS=0.73P AD=0.73P PS=3.46U
+ PD=3.46U
* device instance _5114 r0 *1 138.565,184.74 nfet_05v0
XM_5114 VSS n_87 n_I4761 VSS nfet_05v0 L=0.6U W=1U AS=0.73P AD=0.73P PS=3.46U
+ PD=3.46U
* device instance _5115 r0 *1 58.565,184.74 nfet_05v0
XM_5115 VSS n_83 n_I4762 VSS nfet_05v0 L=0.6U W=1U AS=0.73P AD=0.73P PS=3.46U
+ PD=3.46U
* device instance _5116 r0 *1 258.565,184.74 nfet_05v0
XM_5116 VSS n_93 n_I4763 VSS nfet_05v0 L=0.6U W=1U AS=0.73P AD=0.73P PS=3.46U
+ PD=3.46U
* device instance _5117 r0 *1 218.565,106.74 nfet_05v0
XM_5117 VSS n_29 n_I4764 VSS nfet_05v0 L=0.6U W=1U AS=0.73P AD=0.73P PS=3.46U
+ PD=3.46U
* device instance _5118 r0 *1 258.565,106.74 nfet_05v0
XM_5118 VSS n_30 n_I4765 VSS nfet_05v0 L=0.6U W=1U AS=0.73P AD=0.73P PS=3.46U
+ PD=3.46U
* device instance _5119 r0 *1 178.565,574.74 nfet_05v0
XM_5119 VSS n_268 n_I4766 VSS nfet_05v0 L=0.6U W=1U AS=0.73P AD=0.73P PS=3.46U
+ PD=3.46U
* device instance _5120 r0 *1 298.565,184.74 nfet_05v0
XM_5120 VSS n_95 n_I4767 VSS nfet_05v0 L=0.6U W=1U AS=0.73P AD=0.73P PS=3.46U
+ PD=3.46U
* device instance _5121 r0 *1 298.565,106.74 nfet_05v0
XM_5121 VSS n_31 n_I4768 VSS nfet_05v0 L=0.6U W=1U AS=0.73P AD=0.73P PS=3.46U
+ PD=3.46U
* device instance _5122 r0 *1 378.565,184.74 nfet_05v0
XM_5122 VSS n_99 n_I4769 VSS nfet_05v0 L=0.6U W=1U AS=0.73P AD=0.73P PS=3.46U
+ PD=3.46U
* device instance _5123 r0 *1 418.565,184.74 nfet_05v0
XM_5123 VSS n_101 n_I4770 VSS nfet_05v0 L=0.6U W=1U AS=0.73P AD=0.73P PS=3.46U
+ PD=3.46U
* device instance _5124 r0 *1 98.565,184.74 nfet_05v0
XM_5124 VSS n_85 n_I4771 VSS nfet_05v0 L=0.6U W=1U AS=0.73P AD=0.73P PS=3.46U
+ PD=3.46U
* device instance _5125 r0 *1 498.565,184.74 nfet_05v0
XM_5125 VSS n_105 n_I4772 VSS nfet_05v0 L=0.6U W=1U AS=0.73P AD=0.73P PS=3.46U
+ PD=3.46U
* device instance _5126 r0 *1 498.565,574.74 nfet_05v0
XM_5126 VSS n_276 n_I4773 VSS nfet_05v0 L=0.6U W=1U AS=0.73P AD=0.73P PS=3.46U
+ PD=3.46U
* device instance _5127 r0 *1 458.565,574.74 nfet_05v0
XM_5127 VSS n_275 n_I4774 VSS nfet_05v0 L=0.6U W=1U AS=0.73P AD=0.73P PS=3.46U
+ PD=3.46U
* device instance _5128 r0 *1 418.565,28.74 nfet_05v0
XM_5128 VSS n_15 n_I4775 VSS nfet_05v0 L=0.6U W=1U AS=0.73P AD=0.73P PS=3.46U
+ PD=3.46U
* device instance _5129 r0 *1 418.565,574.74 nfet_05v0
XM_5129 VSS n_274 n_I4776 VSS nfet_05v0 L=0.6U W=1U AS=0.73P AD=0.73P PS=3.46U
+ PD=3.46U
* device instance _5130 r0 *1 298.565,28.74 nfet_05v0
XM_5130 VSS n_12 n_I4777 VSS nfet_05v0 L=0.6U W=1U AS=0.73P AD=0.73P PS=3.46U
+ PD=3.46U
* device instance _5131 r0 *1 218.565,184.74 nfet_05v0
XM_5131 VSS n_91 n_I4778 VSS nfet_05v0 L=0.6U W=1U AS=0.73P AD=0.73P PS=3.46U
+ PD=3.46U
* device instance _5132 r0 *1 498.565,28.74 nfet_05v0
XM_5132 VSS n_17 n_I4779 VSS nfet_05v0 L=0.6U W=1U AS=0.73P AD=0.73P PS=3.46U
+ PD=3.46U
* device instance _5133 r0 *1 458.565,184.74 nfet_05v0
XM_5133 VSS n_103 n_I4780 VSS nfet_05v0 L=0.6U W=1U AS=0.73P AD=0.73P PS=3.46U
+ PD=3.46U
* device instance _5134 r90 *1 55.025,24.715 pfet_05v0
XM_5134 n_4 n_I4653 n_I385 VDD_DEC pfet_05v0 L=0.5U W=6U AS=3.14P AD=3.14P
+ PS=11.14U PD=11.14U
* device instance _5137 r90 *1 255.025,570.715 pfet_05v0
XM_5137 n_4 n_I4654 n_I384 VDD_DEC pfet_05v0 L=0.5U W=6U AS=3.14P AD=3.14P
+ PS=11.14U PD=11.14U
* device instance _5140 r90 *1 535.025,24.715 pfet_05v0
XM_5140 n_4 n_I4655 n_I383 VDD_DEC pfet_05v0 L=0.5U W=6U AS=3.14P AD=3.14P
+ PS=11.14U PD=11.14U
* device instance _5143 r90 *1 175.025,102.715 pfet_05v0
XM_5143 n_4 n_I4656 n_I382 VDD_DEC pfet_05v0 L=0.5U W=6U AS=3.14P AD=3.14P
+ PS=11.14U PD=11.14U
* device instance _5146 r90 *1 215.025,414.715 pfet_05v0
XM_5146 n_4 n_I4657 n_I381 VDD_DEC pfet_05v0 L=0.5U W=6U AS=3.14P AD=3.14P
+ PS=11.14U PD=11.14U
* device instance _5149 r90 *1 175.025,24.715 pfet_05v0
XM_5149 n_4 n_I4658 n_I380 VDD_DEC pfet_05v0 L=0.5U W=6U AS=3.14P AD=3.14P
+ PS=11.14U PD=11.14U
* device instance _5152 r90 *1 295.025,570.715 pfet_05v0
XM_5152 n_4 n_I4659 n_I379 VDD_DEC pfet_05v0 L=0.5U W=6U AS=3.14P AD=3.14P
+ PS=11.14U PD=11.14U
* device instance _5155 r90 *1 95.025,570.715 pfet_05v0
XM_5155 n_4 n_I4660 n_I378 VDD_DEC pfet_05v0 L=0.5U W=6U AS=3.14P AD=3.14P
+ PS=11.14U PD=11.14U
* device instance _5158 r90 *1 255.025,336.715 pfet_05v0
XM_5158 n_4 n_I4661 n_I377 VDD_DEC pfet_05v0 L=0.5U W=6U AS=3.14P AD=3.14P
+ PS=11.14U PD=11.14U
* device instance _5161 r90 *1 615.025,24.715 pfet_05v0
XM_5161 n_4 n_I4662 n_I376 VDD_DEC pfet_05v0 L=0.5U W=6U AS=3.14P AD=3.14P
+ PS=11.14U PD=11.14U
* device instance _5164 r90 *1 175.025,414.715 pfet_05v0
XM_5164 n_4 n_I4663 n_I375 VDD_DEC pfet_05v0 L=0.5U W=6U AS=3.14P AD=3.14P
+ PS=11.14U PD=11.14U
* device instance _5167 r90 *1 455.025,102.715 pfet_05v0
XM_5167 n_4 n_I4664 n_I374 VDD_DEC pfet_05v0 L=0.5U W=6U AS=3.14P AD=3.14P
+ PS=11.14U PD=11.14U
* device instance _5170 r90 *1 495.025,102.715 pfet_05v0
XM_5170 n_4 n_I4665 n_I373 VDD_DEC pfet_05v0 L=0.5U W=6U AS=3.14P AD=3.14P
+ PS=11.14U PD=11.14U
* device instance _5173 r90 *1 615.025,180.715 pfet_05v0
XM_5173 n_4 n_I4666 n_I372 VDD_DEC pfet_05v0 L=0.5U W=6U AS=3.14P AD=3.14P
+ PS=11.14U PD=11.14U
* device instance _5176 r90 *1 655.025,180.715 pfet_05v0
XM_5176 n_4 n_I4667 n_I371 VDD_DEC pfet_05v0 L=0.5U W=6U AS=3.14P AD=3.14P
+ PS=11.14U PD=11.14U
* device instance _5179 r90 *1 535.025,180.715 pfet_05v0
XM_5179 n_4 n_I4668 n_I370 VDD_DEC pfet_05v0 L=0.5U W=6U AS=3.14P AD=3.14P
+ PS=11.14U PD=11.14U
* device instance _5182 r90 *1 575.025,180.715 pfet_05v0
XM_5182 n_4 n_I4669 n_I369 VDD_DEC pfet_05v0 L=0.5U W=6U AS=3.14P AD=3.14P
+ PS=11.14U PD=11.14U
* device instance _5185 r90 *1 535.025,102.715 pfet_05v0
XM_5185 n_4 n_I4670 n_I368 VDD_DEC pfet_05v0 L=0.5U W=6U AS=3.14P AD=3.14P
+ PS=11.14U PD=11.14U
* device instance _5188 r90 *1 575.025,102.715 pfet_05v0
XM_5188 n_4 n_I4671 n_I367 VDD_DEC pfet_05v0 L=0.5U W=6U AS=3.14P AD=3.14P
+ PS=11.14U PD=11.14U
* device instance _5191 r90 *1 95.025,336.715 pfet_05v0
XM_5191 n_4 n_I4672 n_I366 VDD_DEC pfet_05v0 L=0.5U W=6U AS=3.14P AD=3.14P
+ PS=11.14U PD=11.14U
* device instance _5194 r90 *1 575.025,24.715 pfet_05v0
XM_5194 n_4 n_I4673 n_I365 VDD_DEC pfet_05v0 L=0.5U W=6U AS=3.14P AD=3.14P
+ PS=11.14U PD=11.14U
* device instance _5197 r90 *1 415.025,102.715 pfet_05v0
XM_5197 n_4 n_I4674 n_I364 VDD_DEC pfet_05v0 L=0.5U W=6U AS=3.14P AD=3.14P
+ PS=11.14U PD=11.14U
* device instance _5200 r90 *1 655.025,102.715 pfet_05v0
XM_5200 n_4 n_I4675 n_I363 VDD_DEC pfet_05v0 L=0.5U W=6U AS=3.14P AD=3.14P
+ PS=11.14U PD=11.14U
* device instance _5203 r90 *1 655.025,24.715 pfet_05v0
XM_5203 n_4 n_I4676 n_I362 VDD_DEC pfet_05v0 L=0.5U W=6U AS=3.14P AD=3.14P
+ PS=11.14U PD=11.14U
* device instance _5206 r90 *1 55.025,414.715 pfet_05v0
XM_5206 n_4 n_I4677 n_I361 VDD_DEC pfet_05v0 L=0.5U W=6U AS=3.14P AD=3.14P
+ PS=11.14U PD=11.14U
* device instance _5209 r90 *1 375.025,102.715 pfet_05v0
XM_5209 n_4 n_I4678 n_I360 VDD_DEC pfet_05v0 L=0.5U W=6U AS=3.14P AD=3.14P
+ PS=11.14U PD=11.14U
* device instance _5212 r90 *1 215.025,336.715 pfet_05v0
XM_5212 n_4 n_I4679 n_I359 VDD_DEC pfet_05v0 L=0.5U W=6U AS=3.14P AD=3.14P
+ PS=11.14U PD=11.14U
* device instance _5215 r90 *1 295.025,414.715 pfet_05v0
XM_5215 n_4 n_I4680 n_I358 VDD_DEC pfet_05v0 L=0.5U W=6U AS=3.14P AD=3.14P
+ PS=11.14U PD=11.14U
* device instance _5218 r90 *1 335.025,570.715 pfet_05v0
XM_5218 n_4 n_I4681 n_I357 VDD_DEC pfet_05v0 L=0.5U W=6U AS=3.14P AD=3.14P
+ PS=11.14U PD=11.14U
* device instance _5221 r90 *1 255.025,414.715 pfet_05v0
XM_5221 n_4 n_I4682 n_I356 VDD_DEC pfet_05v0 L=0.5U W=6U AS=3.14P AD=3.14P
+ PS=11.14U PD=11.14U
* device instance _5224 r90 *1 295.025,336.715 pfet_05v0
XM_5224 n_4 n_I4683 n_I355 VDD_DEC pfet_05v0 L=0.5U W=6U AS=3.14P AD=3.14P
+ PS=11.14U PD=11.14U
* device instance _5227 r90 *1 615.025,102.715 pfet_05v0
XM_5227 n_4 n_I4684 n_I354 VDD_DEC pfet_05v0 L=0.5U W=6U AS=3.14P AD=3.14P
+ PS=11.14U PD=11.14U
* device instance _5230 r90 *1 335.025,414.715 pfet_05v0
XM_5230 n_4 n_I4685 n_I353 VDD_DEC pfet_05v0 L=0.5U W=6U AS=3.14P AD=3.14P
+ PS=11.14U PD=11.14U
* device instance _5233 r90 *1 175.025,336.715 pfet_05v0
XM_5233 n_4 n_I4686 n_I352 VDD_DEC pfet_05v0 L=0.5U W=6U AS=3.14P AD=3.14P
+ PS=11.14U PD=11.14U
* device instance _5236 r90 *1 335.025,336.715 pfet_05v0
XM_5236 n_4 n_I4687 n_I351 VDD_DEC pfet_05v0 L=0.5U W=6U AS=3.14P AD=3.14P
+ PS=11.14U PD=11.14U
* device instance _5239 r90 *1 335.025,258.715 pfet_05v0
XM_5239 n_4 n_I4688 n_I350 VDD_DEC pfet_05v0 L=0.5U W=6U AS=3.14P AD=3.14P
+ PS=11.14U PD=11.14U
* device instance _5242 r90 *1 335.025,180.715 pfet_05v0
XM_5242 n_4 n_I4689 n_I349 VDD_DEC pfet_05v0 L=0.5U W=6U AS=3.14P AD=3.14P
+ PS=11.14U PD=11.14U
* device instance _5245 r90 *1 335.025,102.715 pfet_05v0
XM_5245 n_4 n_I4690 n_I348 VDD_DEC pfet_05v0 L=0.5U W=6U AS=3.14P AD=3.14P
+ PS=11.14U PD=11.14U
* device instance _5248 r90 *1 335.025,24.715 pfet_05v0
XM_5248 n_4 n_I4691 n_I347 VDD_DEC pfet_05v0 L=0.5U W=6U AS=3.14P AD=3.14P
+ PS=11.14U PD=11.14U
* device instance _5251 r90 *1 175.025,258.715 pfet_05v0
XM_5251 n_4 n_I4692 n_I346 VDD_DEC pfet_05v0 L=0.5U W=6U AS=3.14P AD=3.14P
+ PS=11.14U PD=11.14U
* device instance _5254 r90 *1 175.025,180.715 pfet_05v0
XM_5254 n_4 n_I4693 n_I345 VDD_DEC pfet_05v0 L=0.5U W=6U AS=3.14P AD=3.14P
+ PS=11.14U PD=11.14U
* device instance _5257 r90 *1 215.025,570.715 pfet_05v0
XM_5257 n_4 n_I4694 n_I344 VDD_DEC pfet_05v0 L=0.5U W=6U AS=3.14P AD=3.14P
+ PS=11.14U PD=11.14U
* device instance _5260 r90 *1 375.025,492.715 pfet_05v0
XM_5260 n_4 n_I4695 n_I343 VDD_DEC pfet_05v0 L=0.5U W=6U AS=3.14P AD=3.14P
+ PS=11.14U PD=11.14U
* device instance _5263 r90 *1 415.025,492.715 pfet_05v0
XM_5263 n_4 n_I4696 n_I342 VDD_DEC pfet_05v0 L=0.5U W=6U AS=3.14P AD=3.14P
+ PS=11.14U PD=11.14U
* device instance _5266 r90 *1 455.025,492.715 pfet_05v0
XM_5266 n_4 n_I4697 n_I341 VDD_DEC pfet_05v0 L=0.5U W=6U AS=3.14P AD=3.14P
+ PS=11.14U PD=11.14U
* device instance _5269 r90 *1 495.025,492.715 pfet_05v0
XM_5269 n_4 n_I4698 n_I340 VDD_DEC pfet_05v0 L=0.5U W=6U AS=3.14P AD=3.14P
+ PS=11.14U PD=11.14U
* device instance _5272 r90 *1 655.025,492.715 pfet_05v0
XM_5272 n_4 n_I4699 n_I339 VDD_DEC pfet_05v0 L=0.5U W=6U AS=3.14P AD=3.14P
+ PS=11.14U PD=11.14U
* device instance _5275 r90 *1 55.025,336.715 pfet_05v0
XM_5275 n_4 n_I4700 n_I338 VDD_DEC pfet_05v0 L=0.5U W=6U AS=3.14P AD=3.14P
+ PS=11.14U PD=11.14U
* device instance _5278 r90 *1 575.025,492.715 pfet_05v0
XM_5278 n_4 n_I4701 n_I337 VDD_DEC pfet_05v0 L=0.5U W=6U AS=3.14P AD=3.14P
+ PS=11.14U PD=11.14U
* device instance _5281 r90 *1 615.025,492.715 pfet_05v0
XM_5281 n_4 n_I4702 n_I336 VDD_DEC pfet_05v0 L=0.5U W=6U AS=3.14P AD=3.14P
+ PS=11.14U PD=11.14U
* device instance _5284 r90 *1 175.025,492.715 pfet_05v0
XM_5284 n_4 n_I4703 n_I335 VDD_DEC pfet_05v0 L=0.5U W=6U AS=3.14P AD=3.14P
+ PS=11.14U PD=11.14U
* device instance _5287 r90 *1 215.025,258.715 pfet_05v0
XM_5287 n_4 n_I4704 n_I334 VDD_DEC pfet_05v0 L=0.5U W=6U AS=3.14P AD=3.14P
+ PS=11.14U PD=11.14U
* device instance _5290 r90 *1 95.025,492.715 pfet_05v0
XM_5290 n_4 n_I4705 n_I333 VDD_DEC pfet_05v0 L=0.5U W=6U AS=3.14P AD=3.14P
+ PS=11.14U PD=11.14U
* device instance _5293 r90 *1 135.025,492.715 pfet_05v0
XM_5293 n_4 n_I4706 n_I332 VDD_DEC pfet_05v0 L=0.5U W=6U AS=3.14P AD=3.14P
+ PS=11.14U PD=11.14U
* device instance _5296 r90 *1 55.025,492.715 pfet_05v0
XM_5296 n_4 n_I4707 n_I331 VDD_DEC pfet_05v0 L=0.5U W=6U AS=3.14P AD=3.14P
+ PS=11.14U PD=11.14U
* device instance _5299 r90 *1 215.025,492.715 pfet_05v0
XM_5299 n_4 n_I4708 n_I330 VDD_DEC pfet_05v0 L=0.5U W=6U AS=3.14P AD=3.14P
+ PS=11.14U PD=11.14U
* device instance _5302 r90 *1 255.025,492.715 pfet_05v0
XM_5302 n_4 n_I4709 n_I329 VDD_DEC pfet_05v0 L=0.5U W=6U AS=3.14P AD=3.14P
+ PS=11.14U PD=11.14U
* device instance _5305 r90 *1 295.025,492.715 pfet_05v0
XM_5305 n_4 n_I4710 n_I328 VDD_DEC pfet_05v0 L=0.5U W=6U AS=3.14P AD=3.14P
+ PS=11.14U PD=11.14U
* device instance _5308 r90 *1 255.025,258.715 pfet_05v0
XM_5308 n_4 n_I4711 n_I327 VDD_DEC pfet_05v0 L=0.5U W=6U AS=3.14P AD=3.14P
+ PS=11.14U PD=11.14U
* device instance _5311 r90 *1 295.025,258.715 pfet_05v0
XM_5311 n_4 n_I4712 n_I326 VDD_DEC pfet_05v0 L=0.5U W=6U AS=3.14P AD=3.14P
+ PS=11.14U PD=11.14U
* device instance _5314 r90 *1 95.025,258.715 pfet_05v0
XM_5314 n_4 n_I4713 n_I325 VDD_DEC pfet_05v0 L=0.5U W=6U AS=3.14P AD=3.14P
+ PS=11.14U PD=11.14U
* device instance _5317 r90 *1 135.025,258.715 pfet_05v0
XM_5317 n_4 n_I4714 n_I324 VDD_DEC pfet_05v0 L=0.5U W=6U AS=3.14P AD=3.14P
+ PS=11.14U PD=11.14U
* device instance _5320 r90 *1 55.025,258.715 pfet_05v0
XM_5320 n_4 n_I4715 n_I323 VDD_DEC pfet_05v0 L=0.5U W=6U AS=3.14P AD=3.14P
+ PS=11.14U PD=11.14U
* device instance _5323 r90 *1 535.025,492.715 pfet_05v0
XM_5323 n_4 n_I4716 n_I322 VDD_DEC pfet_05v0 L=0.5U W=6U AS=3.14P AD=3.14P
+ PS=11.14U PD=11.14U
* device instance _5326 r90 *1 495.025,336.715 pfet_05v0
XM_5326 n_4 n_I4717 n_I321 VDD_DEC pfet_05v0 L=0.5U W=6U AS=3.14P AD=3.14P
+ PS=11.14U PD=11.14U
* device instance _5329 r90 *1 215.025,24.715 pfet_05v0
XM_5329 n_4 n_I4718 n_I320 VDD_DEC pfet_05v0 L=0.5U W=6U AS=3.14P AD=3.14P
+ PS=11.14U PD=11.14U
* device instance _5332 r90 *1 455.025,336.715 pfet_05v0
XM_5332 n_4 n_I4719 n_I319 VDD_DEC pfet_05v0 L=0.5U W=6U AS=3.14P AD=3.14P
+ PS=11.14U PD=11.14U
* device instance _5335 r90 *1 375.025,570.715 pfet_05v0
XM_5335 n_4 n_I4720 n_I318 VDD_DEC pfet_05v0 L=0.5U W=6U AS=3.14P AD=3.14P
+ PS=11.14U PD=11.14U
* device instance _5338 r90 *1 415.025,336.715 pfet_05v0
XM_5338 n_4 n_I4721 n_I317 VDD_DEC pfet_05v0 L=0.5U W=6U AS=3.14P AD=3.14P
+ PS=11.14U PD=11.14U
* device instance _5341 r90 *1 495.025,414.715 pfet_05v0
XM_5341 n_4 n_I4722 n_I316 VDD_DEC pfet_05v0 L=0.5U W=6U AS=3.14P AD=3.14P
+ PS=11.14U PD=11.14U
* device instance _5344 r90 *1 375.025,336.715 pfet_05v0
XM_5344 n_4 n_I4723 n_I315 VDD_DEC pfet_05v0 L=0.5U W=6U AS=3.14P AD=3.14P
+ PS=11.14U PD=11.14U
* device instance _5347 r90 *1 375.025,414.715 pfet_05v0
XM_5347 n_4 n_I4724 n_I314 VDD_DEC pfet_05v0 L=0.5U W=6U AS=3.14P AD=3.14P
+ PS=11.14U PD=11.14U
* device instance _5350 r90 *1 455.025,414.715 pfet_05v0
XM_5350 n_4 n_I4725 n_I313 VDD_DEC pfet_05v0 L=0.5U W=6U AS=3.14P AD=3.14P
+ PS=11.14U PD=11.14U
* device instance _5353 r90 *1 255.025,24.715 pfet_05v0
XM_5353 n_4 n_I4726 n_I312 VDD_DEC pfet_05v0 L=0.5U W=6U AS=3.14P AD=3.14P
+ PS=11.14U PD=11.14U
* device instance _5356 r90 *1 415.025,414.715 pfet_05v0
XM_5356 n_4 n_I4727 n_I311 VDD_DEC pfet_05v0 L=0.5U W=6U AS=3.14P AD=3.14P
+ PS=11.14U PD=11.14U
* device instance _5359 r90 *1 615.025,414.715 pfet_05v0
XM_5359 n_4 n_I4728 n_I310 VDD_DEC pfet_05v0 L=0.5U W=6U AS=3.14P AD=3.14P
+ PS=11.14U PD=11.14U
* device instance _5362 r90 *1 575.025,414.715 pfet_05v0
XM_5362 n_4 n_I4729 n_I309 VDD_DEC pfet_05v0 L=0.5U W=6U AS=3.14P AD=3.14P
+ PS=11.14U PD=11.14U
* device instance _5365 r90 *1 615.025,336.715 pfet_05v0
XM_5365 n_4 n_I4730 n_I308 VDD_DEC pfet_05v0 L=0.5U W=6U AS=3.14P AD=3.14P
+ PS=11.14U PD=11.14U
* device instance _5368 r90 *1 615.025,570.715 pfet_05v0
XM_5368 n_4 n_I4731 n_I307 VDD_DEC pfet_05v0 L=0.5U W=6U AS=3.14P AD=3.14P
+ PS=11.14U PD=11.14U
* device instance _5371 r90 *1 335.025,492.715 pfet_05v0
XM_5371 n_4 n_I4732 n_I306 VDD_DEC pfet_05v0 L=0.5U W=6U AS=3.14P AD=3.14P
+ PS=11.14U PD=11.14U
* device instance _5374 r90 *1 535.025,336.715 pfet_05v0
XM_5374 n_4 n_I4733 n_I305 VDD_DEC pfet_05v0 L=0.5U W=6U AS=3.14P AD=3.14P
+ PS=11.14U PD=11.14U
* device instance _5377 r90 *1 575.025,570.715 pfet_05v0
XM_5377 n_4 n_I4734 n_I304 VDD_DEC pfet_05v0 L=0.5U W=6U AS=3.14P AD=3.14P
+ PS=11.14U PD=11.14U
* device instance _5380 r90 *1 655.025,570.715 pfet_05v0
XM_5380 n_4 n_I4735 n_I303 VDD_DEC pfet_05v0 L=0.5U W=6U AS=3.14P AD=3.14P
+ PS=11.14U PD=11.14U
* device instance _5383 r90 *1 575.025,258.715 pfet_05v0
XM_5383 n_4 n_I4736 n_I302 VDD_DEC pfet_05v0 L=0.5U W=6U AS=3.14P AD=3.14P
+ PS=11.14U PD=11.14U
* device instance _5386 r90 *1 615.025,258.715 pfet_05v0
XM_5386 n_4 n_I4737 n_I301 VDD_DEC pfet_05v0 L=0.5U W=6U AS=3.14P AD=3.14P
+ PS=11.14U PD=11.14U
* device instance _5389 r90 *1 655.025,258.715 pfet_05v0
XM_5389 n_4 n_I4738 n_I300 VDD_DEC pfet_05v0 L=0.5U W=6U AS=3.14P AD=3.14P
+ PS=11.14U PD=11.14U
* device instance _5392 r90 *1 575.025,336.715 pfet_05v0
XM_5392 n_4 n_I4739 n_I299 VDD_DEC pfet_05v0 L=0.5U W=6U AS=3.14P AD=3.14P
+ PS=11.14U PD=11.14U
* device instance _5395 r90 *1 535.025,414.715 pfet_05v0
XM_5395 n_4 n_I4740 n_I298 VDD_DEC pfet_05v0 L=0.5U W=6U AS=3.14P AD=3.14P
+ PS=11.14U PD=11.14U
* device instance _5398 r90 *1 535.025,258.715 pfet_05v0
XM_5398 n_4 n_I4741 n_I297 VDD_DEC pfet_05v0 L=0.5U W=6U AS=3.14P AD=3.14P
+ PS=11.14U PD=11.14U
* device instance _5401 r90 *1 495.025,258.715 pfet_05v0
XM_5401 n_4 n_I4742 n_I296 VDD_DEC pfet_05v0 L=0.5U W=6U AS=3.14P AD=3.14P
+ PS=11.14U PD=11.14U
* device instance _5404 r90 *1 455.025,258.715 pfet_05v0
XM_5404 n_4 n_I4743 n_I295 VDD_DEC pfet_05v0 L=0.5U W=6U AS=3.14P AD=3.14P
+ PS=11.14U PD=11.14U
* device instance _5407 r90 *1 375.025,258.715 pfet_05v0
XM_5407 n_4 n_I4744 n_I294 VDD_DEC pfet_05v0 L=0.5U W=6U AS=3.14P AD=3.14P
+ PS=11.14U PD=11.14U
* device instance _5410 r90 *1 415.025,258.715 pfet_05v0
XM_5410 n_4 n_I4745 n_I293 VDD_DEC pfet_05v0 L=0.5U W=6U AS=3.14P AD=3.14P
+ PS=11.14U PD=11.14U
* device instance _5413 r90 *1 655.025,414.715 pfet_05v0
XM_5413 n_4 n_I4746 n_I292 VDD_DEC pfet_05v0 L=0.5U W=6U AS=3.14P AD=3.14P
+ PS=11.14U PD=11.14U
* device instance _5416 r90 *1 655.025,336.715 pfet_05v0
XM_5416 n_4 n_I4747 n_I291 VDD_DEC pfet_05v0 L=0.5U W=6U AS=3.14P AD=3.14P
+ PS=11.14U PD=11.14U
* device instance _5419 r90 *1 535.025,570.715 pfet_05v0
XM_5419 n_4 n_I4748 n_I290 VDD_DEC pfet_05v0 L=0.5U W=6U AS=3.14P AD=3.14P
+ PS=11.14U PD=11.14U
* device instance _5422 r90 *1 95.025,414.715 pfet_05v0
XM_5422 n_4 n_I4749 n_I289 VDD_DEC pfet_05v0 L=0.5U W=6U AS=3.14P AD=3.14P
+ PS=11.14U PD=11.14U
* device instance _5425 r90 *1 375.025,24.715 pfet_05v0
XM_5425 n_4 n_I4750 n_I288 VDD_DEC pfet_05v0 L=0.5U W=6U AS=3.14P AD=3.14P
+ PS=11.14U PD=11.14U
* device instance _5428 r90 *1 135.025,570.715 pfet_05v0
XM_5428 n_4 n_I4751 n_I287 VDD_DEC pfet_05v0 L=0.5U W=6U AS=3.14P AD=3.14P
+ PS=11.14U PD=11.14U
* device instance _5431 r90 *1 55.025,570.715 pfet_05v0
XM_5431 n_4 n_I4752 n_I286 VDD_DEC pfet_05v0 L=0.5U W=6U AS=3.14P AD=3.14P
+ PS=11.14U PD=11.14U
* device instance _5434 r90 *1 135.025,336.715 pfet_05v0
XM_5434 n_4 n_I4753 n_I285 VDD_DEC pfet_05v0 L=0.5U W=6U AS=3.14P AD=3.14P
+ PS=11.14U PD=11.14U
* device instance _5437 r90 *1 135.025,414.715 pfet_05v0
XM_5437 n_4 n_I4754 n_I284 VDD_DEC pfet_05v0 L=0.5U W=6U AS=3.14P AD=3.14P
+ PS=11.14U PD=11.14U
* device instance _5440 r90 *1 55.025,102.715 pfet_05v0
XM_5440 n_4 n_I4755 n_I283 VDD_DEC pfet_05v0 L=0.5U W=6U AS=3.14P AD=3.14P
+ PS=11.14U PD=11.14U
* device instance _5443 r90 *1 95.025,102.715 pfet_05v0
XM_5443 n_4 n_I4756 n_I282 VDD_DEC pfet_05v0 L=0.5U W=6U AS=3.14P AD=3.14P
+ PS=11.14U PD=11.14U
* device instance _5446 r90 *1 135.025,102.715 pfet_05v0
XM_5446 n_4 n_I4757 n_I281 VDD_DEC pfet_05v0 L=0.5U W=6U AS=3.14P AD=3.14P
+ PS=11.14U PD=11.14U
* device instance _5449 r90 *1 95.025,24.715 pfet_05v0
XM_5449 n_4 n_I4758 n_I280 VDD_DEC pfet_05v0 L=0.5U W=6U AS=3.14P AD=3.14P
+ PS=11.14U PD=11.14U
* device instance _5452 r90 *1 455.025,24.715 pfet_05v0
XM_5452 n_4 n_I4759 n_I279 VDD_DEC pfet_05v0 L=0.5U W=6U AS=3.14P AD=3.14P
+ PS=11.14U PD=11.14U
* device instance _5455 r90 *1 135.025,24.715 pfet_05v0
XM_5455 n_4 n_I4760 n_I278 VDD_DEC pfet_05v0 L=0.5U W=6U AS=3.14P AD=3.14P
+ PS=11.14U PD=11.14U
* device instance _5458 r90 *1 135.025,180.715 pfet_05v0
XM_5458 n_4 n_I4761 n_I277 VDD_DEC pfet_05v0 L=0.5U W=6U AS=3.14P AD=3.14P
+ PS=11.14U PD=11.14U
* device instance _5461 r90 *1 55.025,180.715 pfet_05v0
XM_5461 n_4 n_I4762 n_I276 VDD_DEC pfet_05v0 L=0.5U W=6U AS=3.14P AD=3.14P
+ PS=11.14U PD=11.14U
* device instance _5464 r90 *1 255.025,180.715 pfet_05v0
XM_5464 n_4 n_I4763 n_I275 VDD_DEC pfet_05v0 L=0.5U W=6U AS=3.14P AD=3.14P
+ PS=11.14U PD=11.14U
* device instance _5467 r90 *1 215.025,102.715 pfet_05v0
XM_5467 n_4 n_I4764 n_I274 VDD_DEC pfet_05v0 L=0.5U W=6U AS=3.14P AD=3.14P
+ PS=11.14U PD=11.14U
* device instance _5470 r90 *1 255.025,102.715 pfet_05v0
XM_5470 n_4 n_I4765 n_I273 VDD_DEC pfet_05v0 L=0.5U W=6U AS=3.14P AD=3.14P
+ PS=11.14U PD=11.14U
* device instance _5473 r90 *1 175.025,570.715 pfet_05v0
XM_5473 n_4 n_I4766 n_I272 VDD_DEC pfet_05v0 L=0.5U W=6U AS=3.14P AD=3.14P
+ PS=11.14U PD=11.14U
* device instance _5476 r90 *1 295.025,180.715 pfet_05v0
XM_5476 n_4 n_I4767 n_I271 VDD_DEC pfet_05v0 L=0.5U W=6U AS=3.14P AD=3.14P
+ PS=11.14U PD=11.14U
* device instance _5479 r90 *1 295.025,102.715 pfet_05v0
XM_5479 n_4 n_I4768 n_I270 VDD_DEC pfet_05v0 L=0.5U W=6U AS=3.14P AD=3.14P
+ PS=11.14U PD=11.14U
* device instance _5482 r90 *1 375.025,180.715 pfet_05v0
XM_5482 n_4 n_I4769 n_I269 VDD_DEC pfet_05v0 L=0.5U W=6U AS=3.14P AD=3.14P
+ PS=11.14U PD=11.14U
* device instance _5485 r90 *1 415.025,180.715 pfet_05v0
XM_5485 n_4 n_I4770 n_I268 VDD_DEC pfet_05v0 L=0.5U W=6U AS=3.14P AD=3.14P
+ PS=11.14U PD=11.14U
* device instance _5488 r90 *1 95.025,180.715 pfet_05v0
XM_5488 n_4 n_I4771 n_I267 VDD_DEC pfet_05v0 L=0.5U W=6U AS=3.14P AD=3.14P
+ PS=11.14U PD=11.14U
* device instance _5491 r90 *1 495.025,180.715 pfet_05v0
XM_5491 n_4 n_I4772 n_I266 VDD_DEC pfet_05v0 L=0.5U W=6U AS=3.14P AD=3.14P
+ PS=11.14U PD=11.14U
* device instance _5494 r90 *1 495.025,570.715 pfet_05v0
XM_5494 n_4 n_I4773 n_I265 VDD_DEC pfet_05v0 L=0.5U W=6U AS=3.14P AD=3.14P
+ PS=11.14U PD=11.14U
* device instance _5497 r90 *1 455.025,570.715 pfet_05v0
XM_5497 n_4 n_I4774 n_I264 VDD_DEC pfet_05v0 L=0.5U W=6U AS=3.14P AD=3.14P
+ PS=11.14U PD=11.14U
* device instance _5500 r90 *1 415.025,24.715 pfet_05v0
XM_5500 n_4 n_I4775 n_I263 VDD_DEC pfet_05v0 L=0.5U W=6U AS=3.14P AD=3.14P
+ PS=11.14U PD=11.14U
* device instance _5503 r90 *1 415.025,570.715 pfet_05v0
XM_5503 n_4 n_I4776 n_I262 VDD_DEC pfet_05v0 L=0.5U W=6U AS=3.14P AD=3.14P
+ PS=11.14U PD=11.14U
* device instance _5506 r90 *1 295.025,24.715 pfet_05v0
XM_5506 n_4 n_I4777 n_I261 VDD_DEC pfet_05v0 L=0.5U W=6U AS=3.14P AD=3.14P
+ PS=11.14U PD=11.14U
* device instance _5509 r90 *1 215.025,180.715 pfet_05v0
XM_5509 n_4 n_I4778 n_I260 VDD_DEC pfet_05v0 L=0.5U W=6U AS=3.14P AD=3.14P
+ PS=11.14U PD=11.14U
* device instance _5512 r90 *1 495.025,24.715 pfet_05v0
XM_5512 n_4 n_I4779 n_I259 VDD_DEC pfet_05v0 L=0.5U W=6U AS=3.14P AD=3.14P
+ PS=11.14U PD=11.14U
* device instance _5515 r90 *1 455.025,180.715 pfet_05v0
XM_5515 n_4 n_I4780 n_I258 VDD_DEC pfet_05v0 L=0.5U W=6U AS=3.14P AD=3.14P
+ PS=11.14U PD=11.14U
* device instance _5518 r90 *1 58.535,24.745 nfet_05v0
XM_5518 n_4 n_6 n_I385 VSS nfet_05v0 L=0.6U W=2U AS=1.46P AD=1.46P PS=5.46U
+ PD=5.46U
* device instance _5519 r90 *1 258.535,570.745 nfet_05v0
XM_5519 n_4 n_270 n_I384 VSS nfet_05v0 L=0.6U W=2U AS=1.46P AD=1.46P PS=5.46U
+ PD=5.46U
* device instance _5520 r90 *1 538.535,24.745 nfet_05v0
XM_5520 n_4 n_18 n_I383 VSS nfet_05v0 L=0.6U W=2U AS=1.46P AD=1.46P PS=5.46U
+ PD=5.46U
* device instance _5521 r90 *1 178.535,102.745 nfet_05v0
XM_5521 n_4 n_28 n_I382 VSS nfet_05v0 L=0.6U W=2U AS=1.46P AD=1.46P PS=5.46U
+ PD=5.46U
* device instance _5522 r90 *1 218.535,414.745 nfet_05v0
XM_5522 n_4 n_158 n_I381 VSS nfet_05v0 L=0.6U W=2U AS=1.46P AD=1.46P PS=5.46U
+ PD=5.46U
* device instance _5523 r90 *1 178.535,24.745 nfet_05v0
XM_5523 n_4 n_9 n_I380 VSS nfet_05v0 L=0.6U W=2U AS=1.46P AD=1.46P PS=5.46U
+ PD=5.46U
* device instance _5524 r90 *1 298.535,570.745 nfet_05v0
XM_5524 n_4 n_271 n_I379 VSS nfet_05v0 L=0.6U W=2U AS=1.46P AD=1.46P PS=5.46U
+ PD=5.46U
* device instance _5525 r90 *1 98.535,570.745 nfet_05v0
XM_5525 n_4 n_266 n_I378 VSS nfet_05v0 L=0.6U W=2U AS=1.46P AD=1.46P PS=5.46U
+ PD=5.46U
* device instance _5526 r90 *1 258.535,336.745 nfet_05v0
XM_5526 n_4 n_162 n_I377 VSS nfet_05v0 L=0.6U W=2U AS=1.46P AD=1.46P PS=5.46U
+ PD=5.46U
* device instance _5527 r90 *1 618.535,24.745 nfet_05v0
XM_5527 n_4 n_20 n_I376 VSS nfet_05v0 L=0.6U W=2U AS=1.46P AD=1.46P PS=5.46U
+ PD=5.46U
* device instance _5528 r90 *1 178.535,414.745 nfet_05v0
XM_5528 n_4 n_155 n_I375 VSS nfet_05v0 L=0.6U W=2U AS=1.46P AD=1.46P PS=5.46U
+ PD=5.46U
* device instance _5529 r90 *1 458.535,102.745 nfet_05v0
XM_5529 n_4 n_35 n_I374 VSS nfet_05v0 L=0.6U W=2U AS=1.46P AD=1.46P PS=5.46U
+ PD=5.46U
* device instance _5530 r90 *1 498.535,102.745 nfet_05v0
XM_5530 n_4 n_36 n_I373 VSS nfet_05v0 L=0.6U W=2U AS=1.46P AD=1.46P PS=5.46U
+ PD=5.46U
* device instance _5531 r90 *1 618.535,180.745 nfet_05v0
XM_5531 n_4 n_111 n_I372 VSS nfet_05v0 L=0.6U W=2U AS=1.46P AD=1.46P PS=5.46U
+ PD=5.46U
* device instance _5532 r90 *1 658.535,180.745 nfet_05v0
XM_5532 n_4 n_113 n_I371 VSS nfet_05v0 L=0.6U W=2U AS=1.46P AD=1.46P PS=5.46U
+ PD=5.46U
* device instance _5533 r90 *1 538.535,180.745 nfet_05v0
XM_5533 n_4 n_107 n_I370 VSS nfet_05v0 L=0.6U W=2U AS=1.46P AD=1.46P PS=5.46U
+ PD=5.46U
* device instance _5534 r90 *1 578.535,180.745 nfet_05v0
XM_5534 n_4 n_109 n_I369 VSS nfet_05v0 L=0.6U W=2U AS=1.46P AD=1.46P PS=5.46U
+ PD=5.46U
* device instance _5535 r90 *1 538.535,102.745 nfet_05v0
XM_5535 n_4 n_37 n_I368 VSS nfet_05v0 L=0.6U W=2U AS=1.46P AD=1.46P PS=5.46U
+ PD=5.46U
* device instance _5536 r90 *1 578.535,102.745 nfet_05v0
XM_5536 n_4 n_38 n_I367 VSS nfet_05v0 L=0.6U W=2U AS=1.46P AD=1.46P PS=5.46U
+ PD=5.46U
* device instance _5537 r90 *1 98.535,336.745 nfet_05v0
XM_5537 n_4 n_150 n_I366 VSS nfet_05v0 L=0.6U W=2U AS=1.46P AD=1.46P PS=5.46U
+ PD=5.46U
* device instance _5538 r90 *1 578.535,24.745 nfet_05v0
XM_5538 n_4 n_19 n_I365 VSS nfet_05v0 L=0.6U W=2U AS=1.46P AD=1.46P PS=5.46U
+ PD=5.46U
* device instance _5539 r90 *1 418.535,102.745 nfet_05v0
XM_5539 n_4 n_34 n_I364 VSS nfet_05v0 L=0.6U W=2U AS=1.46P AD=1.46P PS=5.46U
+ PD=5.46U
* device instance _5540 r90 *1 658.535,102.745 nfet_05v0
XM_5540 n_4 n_40 n_I363 VSS nfet_05v0 L=0.6U W=2U AS=1.46P AD=1.46P PS=5.46U
+ PD=5.46U
* device instance _5541 r90 *1 658.535,24.745 nfet_05v0
XM_5541 n_4 n_21 n_I362 VSS nfet_05v0 L=0.6U W=2U AS=1.46P AD=1.46P PS=5.46U
+ PD=5.46U
* device instance _5542 r90 *1 58.535,414.745 nfet_05v0
XM_5542 n_4 n_146 n_I361 VSS nfet_05v0 L=0.6U W=2U AS=1.46P AD=1.46P PS=5.46U
+ PD=5.46U
* device instance _5543 r90 *1 378.535,102.745 nfet_05v0
XM_5543 n_4 n_33 n_I360 VSS nfet_05v0 L=0.6U W=2U AS=1.46P AD=1.46P PS=5.46U
+ PD=5.46U
* device instance _5544 r90 *1 218.535,336.745 nfet_05v0
XM_5544 n_4 n_159 n_I359 VSS nfet_05v0 L=0.6U W=2U AS=1.46P AD=1.46P PS=5.46U
+ PD=5.46U
* device instance _5545 r90 *1 298.535,414.745 nfet_05v0
XM_5545 n_4 n_164 n_I358 VSS nfet_05v0 L=0.6U W=2U AS=1.46P AD=1.46P PS=5.46U
+ PD=5.46U
* device instance _5546 r90 *1 338.535,570.745 nfet_05v0
XM_5546 n_4 n_272 n_I357 VSS nfet_05v0 L=0.6U W=2U AS=1.46P AD=1.46P PS=5.46U
+ PD=5.46U
* device instance _5547 r90 *1 258.535,414.745 nfet_05v0
XM_5547 n_4 n_161 n_I356 VSS nfet_05v0 L=0.6U W=2U AS=1.46P AD=1.46P PS=5.46U
+ PD=5.46U
* device instance _5548 r90 *1 298.535,336.745 nfet_05v0
XM_5548 n_4 n_165 n_I355 VSS nfet_05v0 L=0.6U W=2U AS=1.46P AD=1.46P PS=5.46U
+ PD=5.46U
* device instance _5549 r90 *1 618.535,102.745 nfet_05v0
XM_5549 n_4 n_39 n_I354 VSS nfet_05v0 L=0.6U W=2U AS=1.46P AD=1.46P PS=5.46U
+ PD=5.46U
* device instance _5550 r90 *1 338.535,414.745 nfet_05v0
XM_5550 n_4 n_167 n_I353 VSS nfet_05v0 L=0.6U W=2U AS=1.46P AD=1.46P PS=5.46U
+ PD=5.46U
* device instance _5551 r90 *1 178.535,336.745 nfet_05v0
XM_5551 n_4 n_156 n_I352 VSS nfet_05v0 L=0.6U W=2U AS=1.46P AD=1.46P PS=5.46U
+ PD=5.46U
* device instance _5552 r90 *1 338.535,336.745 nfet_05v0
XM_5552 n_4 n_168 n_I351 VSS nfet_05v0 L=0.6U W=2U AS=1.46P AD=1.46P PS=5.46U
+ PD=5.46U
* device instance _5553 r90 *1 338.535,258.745 nfet_05v0
XM_5553 n_4 n_96 n_I350 VSS nfet_05v0 L=0.6U W=2U AS=1.46P AD=1.46P PS=5.46U
+ PD=5.46U
* device instance _5554 r90 *1 338.535,180.745 nfet_05v0
XM_5554 n_4 n_97 n_I349 VSS nfet_05v0 L=0.6U W=2U AS=1.46P AD=1.46P PS=5.46U
+ PD=5.46U
* device instance _5555 r90 *1 338.535,102.745 nfet_05v0
XM_5555 n_4 n_32 n_I348 VSS nfet_05v0 L=0.6U W=2U AS=1.46P AD=1.46P PS=5.46U
+ PD=5.46U
* device instance _5556 r90 *1 338.535,24.745 nfet_05v0
XM_5556 n_4 n_13 n_I347 VSS nfet_05v0 L=0.6U W=2U AS=1.46P AD=1.46P PS=5.46U
+ PD=5.46U
* device instance _5557 r90 *1 178.535,258.745 nfet_05v0
XM_5557 n_4 n_88 n_I346 VSS nfet_05v0 L=0.6U W=2U AS=1.46P AD=1.46P PS=5.46U
+ PD=5.46U
* device instance _5558 r90 *1 178.535,180.745 nfet_05v0
XM_5558 n_4 n_89 n_I345 VSS nfet_05v0 L=0.6U W=2U AS=1.46P AD=1.46P PS=5.46U
+ PD=5.46U
* device instance _5559 r90 *1 218.535,570.745 nfet_05v0
XM_5559 n_4 n_269 n_I344 VSS nfet_05v0 L=0.6U W=2U AS=1.46P AD=1.46P PS=5.46U
+ PD=5.46U
* device instance _5560 r90 *1 378.535,492.745 nfet_05v0
XM_5560 n_4 n_169 n_I343 VSS nfet_05v0 L=0.6U W=2U AS=1.46P AD=1.46P PS=5.46U
+ PD=5.46U
* device instance _5561 r90 *1 418.535,492.745 nfet_05v0
XM_5561 n_4 n_172 n_I342 VSS nfet_05v0 L=0.6U W=2U AS=1.46P AD=1.46P PS=5.46U
+ PD=5.46U
* device instance _5562 r90 *1 458.535,492.745 nfet_05v0
XM_5562 n_4 n_175 n_I341 VSS nfet_05v0 L=0.6U W=2U AS=1.46P AD=1.46P PS=5.46U
+ PD=5.46U
* device instance _5563 r90 *1 498.535,492.745 nfet_05v0
XM_5563 n_4 n_178 n_I340 VSS nfet_05v0 L=0.6U W=2U AS=1.46P AD=1.46P PS=5.46U
+ PD=5.46U
* device instance _5564 r90 *1 658.535,492.745 nfet_05v0
XM_5564 n_4 n_190 n_I339 VSS nfet_05v0 L=0.6U W=2U AS=1.46P AD=1.46P PS=5.46U
+ PD=5.46U
* device instance _5565 r90 *1 58.535,336.745 nfet_05v0
XM_5565 n_4 n_147 n_I338 VSS nfet_05v0 L=0.6U W=2U AS=1.46P AD=1.46P PS=5.46U
+ PD=5.46U
* device instance _5566 r90 *1 578.535,492.745 nfet_05v0
XM_5566 n_4 n_184 n_I337 VSS nfet_05v0 L=0.6U W=2U AS=1.46P AD=1.46P PS=5.46U
+ PD=5.46U
* device instance _5567 r90 *1 618.535,492.745 nfet_05v0
XM_5567 n_4 n_187 n_I336 VSS nfet_05v0 L=0.6U W=2U AS=1.46P AD=1.46P PS=5.46U
+ PD=5.46U
* device instance _5568 r90 *1 178.535,492.745 nfet_05v0
XM_5568 n_4 n_154 n_I335 VSS nfet_05v0 L=0.6U W=2U AS=1.46P AD=1.46P PS=5.46U
+ PD=5.46U
* device instance _5569 r90 *1 218.535,258.745 nfet_05v0
XM_5569 n_4 n_90 n_I334 VSS nfet_05v0 L=0.6U W=2U AS=1.46P AD=1.46P PS=5.46U
+ PD=5.46U
* device instance _5570 r90 *1 98.535,492.745 nfet_05v0
XM_5570 n_4 n_148 n_I333 VSS nfet_05v0 L=0.6U W=2U AS=1.46P AD=1.46P PS=5.46U
+ PD=5.46U
* device instance _5571 r90 *1 138.535,492.745 nfet_05v0
XM_5571 n_4 n_151 n_I332 VSS nfet_05v0 L=0.6U W=2U AS=1.46P AD=1.46P PS=5.46U
+ PD=5.46U
* device instance _5572 r90 *1 58.535,492.745 nfet_05v0
XM_5572 n_4 n_145 n_I331 VSS nfet_05v0 L=0.6U W=2U AS=1.46P AD=1.46P PS=5.46U
+ PD=5.46U
* device instance _5573 r90 *1 218.535,492.745 nfet_05v0
XM_5573 n_4 n_157 n_I330 VSS nfet_05v0 L=0.6U W=2U AS=1.46P AD=1.46P PS=5.46U
+ PD=5.46U
* device instance _5574 r90 *1 258.535,492.745 nfet_05v0
XM_5574 n_4 n_160 n_I329 VSS nfet_05v0 L=0.6U W=2U AS=1.46P AD=1.46P PS=5.46U
+ PD=5.46U
* device instance _5575 r90 *1 298.535,492.745 nfet_05v0
XM_5575 n_4 n_163 n_I328 VSS nfet_05v0 L=0.6U W=2U AS=1.46P AD=1.46P PS=5.46U
+ PD=5.46U
* device instance _5576 r90 *1 258.535,258.745 nfet_05v0
XM_5576 n_4 n_92 n_I327 VSS nfet_05v0 L=0.6U W=2U AS=1.46P AD=1.46P PS=5.46U
+ PD=5.46U
* device instance _5577 r90 *1 298.535,258.745 nfet_05v0
XM_5577 n_4 n_94 n_I326 VSS nfet_05v0 L=0.6U W=2U AS=1.46P AD=1.46P PS=5.46U
+ PD=5.46U
* device instance _5578 r90 *1 98.535,258.745 nfet_05v0
XM_5578 n_4 n_84 n_I325 VSS nfet_05v0 L=0.6U W=2U AS=1.46P AD=1.46P PS=5.46U
+ PD=5.46U
* device instance _5579 r90 *1 138.535,258.745 nfet_05v0
XM_5579 n_4 n_86 n_I324 VSS nfet_05v0 L=0.6U W=2U AS=1.46P AD=1.46P PS=5.46U
+ PD=5.46U
* device instance _5580 r90 *1 58.535,258.745 nfet_05v0
XM_5580 n_4 n_82 n_I323 VSS nfet_05v0 L=0.6U W=2U AS=1.46P AD=1.46P PS=5.46U
+ PD=5.46U
* device instance _5581 r90 *1 538.535,492.745 nfet_05v0
XM_5581 n_4 n_181 n_I322 VSS nfet_05v0 L=0.6U W=2U AS=1.46P AD=1.46P PS=5.46U
+ PD=5.46U
* device instance _5582 r90 *1 498.535,336.745 nfet_05v0
XM_5582 n_4 n_180 n_I321 VSS nfet_05v0 L=0.6U W=2U AS=1.46P AD=1.46P PS=5.46U
+ PD=5.46U
* device instance _5583 r90 *1 218.535,24.745 nfet_05v0
XM_5583 n_4 n_10 n_I320 VSS nfet_05v0 L=0.6U W=2U AS=1.46P AD=1.46P PS=5.46U
+ PD=5.46U
* device instance _5584 r90 *1 458.535,336.745 nfet_05v0
XM_5584 n_4 n_177 n_I319 VSS nfet_05v0 L=0.6U W=2U AS=1.46P AD=1.46P PS=5.46U
+ PD=5.46U
* device instance _5585 r90 *1 378.535,570.745 nfet_05v0
XM_5585 n_4 n_273 n_I318 VSS nfet_05v0 L=0.6U W=2U AS=1.46P AD=1.46P PS=5.46U
+ PD=5.46U
* device instance _5586 r90 *1 418.535,336.745 nfet_05v0
XM_5586 n_4 n_174 n_I317 VSS nfet_05v0 L=0.6U W=2U AS=1.46P AD=1.46P PS=5.46U
+ PD=5.46U
* device instance _5587 r90 *1 498.535,414.745 nfet_05v0
XM_5587 n_4 n_179 n_I316 VSS nfet_05v0 L=0.6U W=2U AS=1.46P AD=1.46P PS=5.46U
+ PD=5.46U
* device instance _5588 r90 *1 378.535,336.745 nfet_05v0
XM_5588 n_4 n_171 n_I315 VSS nfet_05v0 L=0.6U W=2U AS=1.46P AD=1.46P PS=5.46U
+ PD=5.46U
* device instance _5589 r90 *1 378.535,414.745 nfet_05v0
XM_5589 n_4 n_170 n_I314 VSS nfet_05v0 L=0.6U W=2U AS=1.46P AD=1.46P PS=5.46U
+ PD=5.46U
* device instance _5590 r90 *1 458.535,414.745 nfet_05v0
XM_5590 n_4 n_176 n_I313 VSS nfet_05v0 L=0.6U W=2U AS=1.46P AD=1.46P PS=5.46U
+ PD=5.46U
* device instance _5591 r90 *1 258.535,24.745 nfet_05v0
XM_5591 n_4 n_11 n_I312 VSS nfet_05v0 L=0.6U W=2U AS=1.46P AD=1.46P PS=5.46U
+ PD=5.46U
* device instance _5592 r90 *1 418.535,414.745 nfet_05v0
XM_5592 n_4 n_173 n_I311 VSS nfet_05v0 L=0.6U W=2U AS=1.46P AD=1.46P PS=5.46U
+ PD=5.46U
* device instance _5593 r90 *1 618.535,414.745 nfet_05v0
XM_5593 n_4 n_188 n_I310 VSS nfet_05v0 L=0.6U W=2U AS=1.46P AD=1.46P PS=5.46U
+ PD=5.46U
* device instance _5594 r90 *1 578.535,414.745 nfet_05v0
XM_5594 n_4 n_185 n_I309 VSS nfet_05v0 L=0.6U W=2U AS=1.46P AD=1.46P PS=5.46U
+ PD=5.46U
* device instance _5595 r90 *1 618.535,336.745 nfet_05v0
XM_5595 n_4 n_189 n_I308 VSS nfet_05v0 L=0.6U W=2U AS=1.46P AD=1.46P PS=5.46U
+ PD=5.46U
* device instance _5596 r90 *1 618.535,570.745 nfet_05v0
XM_5596 n_4 n_279 n_I307 VSS nfet_05v0 L=0.6U W=2U AS=1.46P AD=1.46P PS=5.46U
+ PD=5.46U
* device instance _5597 r90 *1 338.535,492.745 nfet_05v0
XM_5597 n_4 n_166 n_I306 VSS nfet_05v0 L=0.6U W=2U AS=1.46P AD=1.46P PS=5.46U
+ PD=5.46U
* device instance _5598 r90 *1 538.535,336.745 nfet_05v0
XM_5598 n_4 n_183 n_I305 VSS nfet_05v0 L=0.6U W=2U AS=1.46P AD=1.46P PS=5.46U
+ PD=5.46U
* device instance _5599 r90 *1 578.535,570.745 nfet_05v0
XM_5599 n_4 n_278 n_I304 VSS nfet_05v0 L=0.6U W=2U AS=1.46P AD=1.46P PS=5.46U
+ PD=5.46U
* device instance _5600 r90 *1 658.535,570.745 nfet_05v0
XM_5600 n_4 n_280 n_I303 VSS nfet_05v0 L=0.6U W=2U AS=1.46P AD=1.46P PS=5.46U
+ PD=5.46U
* device instance _5601 r90 *1 578.535,258.745 nfet_05v0
XM_5601 n_4 n_108 n_I302 VSS nfet_05v0 L=0.6U W=2U AS=1.46P AD=1.46P PS=5.46U
+ PD=5.46U
* device instance _5602 r90 *1 618.535,258.745 nfet_05v0
XM_5602 n_4 n_110 n_I301 VSS nfet_05v0 L=0.6U W=2U AS=1.46P AD=1.46P PS=5.46U
+ PD=5.46U
* device instance _5603 r90 *1 658.535,258.745 nfet_05v0
XM_5603 n_4 n_112 n_I300 VSS nfet_05v0 L=0.6U W=2U AS=1.46P AD=1.46P PS=5.46U
+ PD=5.46U
* device instance _5604 r90 *1 578.535,336.745 nfet_05v0
XM_5604 n_4 n_186 n_I299 VSS nfet_05v0 L=0.6U W=2U AS=1.46P AD=1.46P PS=5.46U
+ PD=5.46U
* device instance _5605 r90 *1 538.535,414.745 nfet_05v0
XM_5605 n_4 n_182 n_I298 VSS nfet_05v0 L=0.6U W=2U AS=1.46P AD=1.46P PS=5.46U
+ PD=5.46U
* device instance _5606 r90 *1 538.535,258.745 nfet_05v0
XM_5606 n_4 n_106 n_I297 VSS nfet_05v0 L=0.6U W=2U AS=1.46P AD=1.46P PS=5.46U
+ PD=5.46U
* device instance _5607 r90 *1 498.535,258.745 nfet_05v0
XM_5607 n_4 n_104 n_I296 VSS nfet_05v0 L=0.6U W=2U AS=1.46P AD=1.46P PS=5.46U
+ PD=5.46U
* device instance _5608 r90 *1 458.535,258.745 nfet_05v0
XM_5608 n_4 n_102 n_I295 VSS nfet_05v0 L=0.6U W=2U AS=1.46P AD=1.46P PS=5.46U
+ PD=5.46U
* device instance _5609 r90 *1 378.535,258.745 nfet_05v0
XM_5609 n_4 n_98 n_I294 VSS nfet_05v0 L=0.6U W=2U AS=1.46P AD=1.46P PS=5.46U
+ PD=5.46U
* device instance _5610 r90 *1 418.535,258.745 nfet_05v0
XM_5610 n_4 n_100 n_I293 VSS nfet_05v0 L=0.6U W=2U AS=1.46P AD=1.46P PS=5.46U
+ PD=5.46U
* device instance _5611 r90 *1 658.535,414.745 nfet_05v0
XM_5611 n_4 n_191 n_I292 VSS nfet_05v0 L=0.6U W=2U AS=1.46P AD=1.46P PS=5.46U
+ PD=5.46U
* device instance _5612 r90 *1 658.535,336.745 nfet_05v0
XM_5612 n_4 n_192 n_I291 VSS nfet_05v0 L=0.6U W=2U AS=1.46P AD=1.46P PS=5.46U
+ PD=5.46U
* device instance _5613 r90 *1 538.535,570.745 nfet_05v0
XM_5613 n_4 n_277 n_I290 VSS nfet_05v0 L=0.6U W=2U AS=1.46P AD=1.46P PS=5.46U
+ PD=5.46U
* device instance _5614 r90 *1 98.535,414.745 nfet_05v0
XM_5614 n_4 n_149 n_I289 VSS nfet_05v0 L=0.6U W=2U AS=1.46P AD=1.46P PS=5.46U
+ PD=5.46U
* device instance _5615 r90 *1 378.535,24.745 nfet_05v0
XM_5615 n_4 n_14 n_I288 VSS nfet_05v0 L=0.6U W=2U AS=1.46P AD=1.46P PS=5.46U
+ PD=5.46U
* device instance _5616 r90 *1 138.535,570.745 nfet_05v0
XM_5616 n_4 n_267 n_I287 VSS nfet_05v0 L=0.6U W=2U AS=1.46P AD=1.46P PS=5.46U
+ PD=5.46U
* device instance _5617 r90 *1 58.535,570.745 nfet_05v0
XM_5617 n_4 n_265 n_I286 VSS nfet_05v0 L=0.6U W=2U AS=1.46P AD=1.46P PS=5.46U
+ PD=5.46U
* device instance _5618 r90 *1 138.535,336.745 nfet_05v0
XM_5618 n_4 n_153 n_I285 VSS nfet_05v0 L=0.6U W=2U AS=1.46P AD=1.46P PS=5.46U
+ PD=5.46U
* device instance _5619 r90 *1 138.535,414.745 nfet_05v0
XM_5619 n_4 n_152 n_I284 VSS nfet_05v0 L=0.6U W=2U AS=1.46P AD=1.46P PS=5.46U
+ PD=5.46U
* device instance _5620 r90 *1 58.535,102.745 nfet_05v0
XM_5620 n_4 n_25 n_I283 VSS nfet_05v0 L=0.6U W=2U AS=1.46P AD=1.46P PS=5.46U
+ PD=5.46U
* device instance _5621 r90 *1 98.535,102.745 nfet_05v0
XM_5621 n_4 n_26 n_I282 VSS nfet_05v0 L=0.6U W=2U AS=1.46P AD=1.46P PS=5.46U
+ PD=5.46U
* device instance _5622 r90 *1 138.535,102.745 nfet_05v0
XM_5622 n_4 n_27 n_I281 VSS nfet_05v0 L=0.6U W=2U AS=1.46P AD=1.46P PS=5.46U
+ PD=5.46U
* device instance _5623 r90 *1 98.535,24.745 nfet_05v0
XM_5623 n_4 n_7 n_I280 VSS nfet_05v0 L=0.6U W=2U AS=1.46P AD=1.46P PS=5.46U
+ PD=5.46U
* device instance _5624 r90 *1 458.535,24.745 nfet_05v0
XM_5624 n_4 n_16 n_I279 VSS nfet_05v0 L=0.6U W=2U AS=1.46P AD=1.46P PS=5.46U
+ PD=5.46U
* device instance _5625 r90 *1 138.535,24.745 nfet_05v0
XM_5625 n_4 n_8 n_I278 VSS nfet_05v0 L=0.6U W=2U AS=1.46P AD=1.46P PS=5.46U
+ PD=5.46U
* device instance _5626 r90 *1 138.535,180.745 nfet_05v0
XM_5626 n_4 n_87 n_I277 VSS nfet_05v0 L=0.6U W=2U AS=1.46P AD=1.46P PS=5.46U
+ PD=5.46U
* device instance _5627 r90 *1 58.535,180.745 nfet_05v0
XM_5627 n_4 n_83 n_I276 VSS nfet_05v0 L=0.6U W=2U AS=1.46P AD=1.46P PS=5.46U
+ PD=5.46U
* device instance _5628 r90 *1 258.535,180.745 nfet_05v0
XM_5628 n_4 n_93 n_I275 VSS nfet_05v0 L=0.6U W=2U AS=1.46P AD=1.46P PS=5.46U
+ PD=5.46U
* device instance _5629 r90 *1 218.535,102.745 nfet_05v0
XM_5629 n_4 n_29 n_I274 VSS nfet_05v0 L=0.6U W=2U AS=1.46P AD=1.46P PS=5.46U
+ PD=5.46U
* device instance _5630 r90 *1 258.535,102.745 nfet_05v0
XM_5630 n_4 n_30 n_I273 VSS nfet_05v0 L=0.6U W=2U AS=1.46P AD=1.46P PS=5.46U
+ PD=5.46U
* device instance _5631 r90 *1 178.535,570.745 nfet_05v0
XM_5631 n_4 n_268 n_I272 VSS nfet_05v0 L=0.6U W=2U AS=1.46P AD=1.46P PS=5.46U
+ PD=5.46U
* device instance _5632 r90 *1 298.535,180.745 nfet_05v0
XM_5632 n_4 n_95 n_I271 VSS nfet_05v0 L=0.6U W=2U AS=1.46P AD=1.46P PS=5.46U
+ PD=5.46U
* device instance _5633 r90 *1 298.535,102.745 nfet_05v0
XM_5633 n_4 n_31 n_I270 VSS nfet_05v0 L=0.6U W=2U AS=1.46P AD=1.46P PS=5.46U
+ PD=5.46U
* device instance _5634 r90 *1 378.535,180.745 nfet_05v0
XM_5634 n_4 n_99 n_I269 VSS nfet_05v0 L=0.6U W=2U AS=1.46P AD=1.46P PS=5.46U
+ PD=5.46U
* device instance _5635 r90 *1 418.535,180.745 nfet_05v0
XM_5635 n_4 n_101 n_I268 VSS nfet_05v0 L=0.6U W=2U AS=1.46P AD=1.46P PS=5.46U
+ PD=5.46U
* device instance _5636 r90 *1 98.535,180.745 nfet_05v0
XM_5636 n_4 n_85 n_I267 VSS nfet_05v0 L=0.6U W=2U AS=1.46P AD=1.46P PS=5.46U
+ PD=5.46U
* device instance _5637 r90 *1 498.535,180.745 nfet_05v0
XM_5637 n_4 n_105 n_I266 VSS nfet_05v0 L=0.6U W=2U AS=1.46P AD=1.46P PS=5.46U
+ PD=5.46U
* device instance _5638 r90 *1 498.535,570.745 nfet_05v0
XM_5638 n_4 n_276 n_I265 VSS nfet_05v0 L=0.6U W=2U AS=1.46P AD=1.46P PS=5.46U
+ PD=5.46U
* device instance _5639 r90 *1 458.535,570.745 nfet_05v0
XM_5639 n_4 n_275 n_I264 VSS nfet_05v0 L=0.6U W=2U AS=1.46P AD=1.46P PS=5.46U
+ PD=5.46U
* device instance _5640 r90 *1 418.535,24.745 nfet_05v0
XM_5640 n_4 n_15 n_I263 VSS nfet_05v0 L=0.6U W=2U AS=1.46P AD=1.46P PS=5.46U
+ PD=5.46U
* device instance _5641 r90 *1 418.535,570.745 nfet_05v0
XM_5641 n_4 n_274 n_I262 VSS nfet_05v0 L=0.6U W=2U AS=1.46P AD=1.46P PS=5.46U
+ PD=5.46U
* device instance _5642 r90 *1 298.535,24.745 nfet_05v0
XM_5642 n_4 n_12 n_I261 VSS nfet_05v0 L=0.6U W=2U AS=1.46P AD=1.46P PS=5.46U
+ PD=5.46U
* device instance _5643 r90 *1 218.535,180.745 nfet_05v0
XM_5643 n_4 n_91 n_I260 VSS nfet_05v0 L=0.6U W=2U AS=1.46P AD=1.46P PS=5.46U
+ PD=5.46U
* device instance _5644 r90 *1 498.535,24.745 nfet_05v0
XM_5644 n_4 n_17 n_I259 VSS nfet_05v0 L=0.6U W=2U AS=1.46P AD=1.46P PS=5.46U
+ PD=5.46U
* device instance _5645 r90 *1 458.535,180.745 nfet_05v0
XM_5645 n_4 n_103 n_I258 VSS nfet_05v0 L=0.6U W=2U AS=1.46P AD=1.46P PS=5.46U
+ PD=5.46U
* device instance _5646 r180 *1 51.51,27.82 pfet_05v0
XM_5646 VDD_DEC n_6 n_I4653 VDD_DEC pfet_05v0 L=0.5U W=2U AS=1.54P AD=1.54P
+ PS=5.54U PD=5.54U
* device instance _5647 r180 *1 251.51,573.82 pfet_05v0
XM_5647 VDD_DEC n_270 n_I4654 VDD_DEC pfet_05v0 L=0.5U W=2U AS=1.54P AD=1.54P
+ PS=5.54U PD=5.54U
* device instance _5648 r180 *1 531.51,27.82 pfet_05v0
XM_5648 VDD_DEC n_18 n_I4655 VDD_DEC pfet_05v0 L=0.5U W=2U AS=1.54P AD=1.54P
+ PS=5.54U PD=5.54U
* device instance _5649 r180 *1 171.51,105.82 pfet_05v0
XM_5649 VDD_DEC n_28 n_I4656 VDD_DEC pfet_05v0 L=0.5U W=2U AS=1.54P AD=1.54P
+ PS=5.54U PD=5.54U
* device instance _5650 r180 *1 211.51,417.82 pfet_05v0
XM_5650 VDD_DEC n_158 n_I4657 VDD_DEC pfet_05v0 L=0.5U W=2U AS=1.54P AD=1.54P
+ PS=5.54U PD=5.54U
* device instance _5651 r180 *1 171.51,27.82 pfet_05v0
XM_5651 VDD_DEC n_9 n_I4658 VDD_DEC pfet_05v0 L=0.5U W=2U AS=1.54P AD=1.54P
+ PS=5.54U PD=5.54U
* device instance _5652 r180 *1 291.51,573.82 pfet_05v0
XM_5652 VDD_DEC n_271 n_I4659 VDD_DEC pfet_05v0 L=0.5U W=2U AS=1.54P AD=1.54P
+ PS=5.54U PD=5.54U
* device instance _5653 r180 *1 91.51,573.82 pfet_05v0
XM_5653 VDD_DEC n_266 n_I4660 VDD_DEC pfet_05v0 L=0.5U W=2U AS=1.54P AD=1.54P
+ PS=5.54U PD=5.54U
* device instance _5654 r180 *1 251.51,339.82 pfet_05v0
XM_5654 VDD_DEC n_162 n_I4661 VDD_DEC pfet_05v0 L=0.5U W=2U AS=1.54P AD=1.54P
+ PS=5.54U PD=5.54U
* device instance _5655 r180 *1 611.51,27.82 pfet_05v0
XM_5655 VDD_DEC n_20 n_I4662 VDD_DEC pfet_05v0 L=0.5U W=2U AS=1.54P AD=1.54P
+ PS=5.54U PD=5.54U
* device instance _5656 r180 *1 171.51,417.82 pfet_05v0
XM_5656 VDD_DEC n_155 n_I4663 VDD_DEC pfet_05v0 L=0.5U W=2U AS=1.54P AD=1.54P
+ PS=5.54U PD=5.54U
* device instance _5657 r180 *1 451.51,105.82 pfet_05v0
XM_5657 VDD_DEC n_35 n_I4664 VDD_DEC pfet_05v0 L=0.5U W=2U AS=1.54P AD=1.54P
+ PS=5.54U PD=5.54U
* device instance _5658 r180 *1 491.51,105.82 pfet_05v0
XM_5658 VDD_DEC n_36 n_I4665 VDD_DEC pfet_05v0 L=0.5U W=2U AS=1.54P AD=1.54P
+ PS=5.54U PD=5.54U
* device instance _5659 r180 *1 611.51,183.82 pfet_05v0
XM_5659 VDD_DEC n_111 n_I4666 VDD_DEC pfet_05v0 L=0.5U W=2U AS=1.54P AD=1.54P
+ PS=5.54U PD=5.54U
* device instance _5660 r180 *1 651.51,183.82 pfet_05v0
XM_5660 VDD_DEC n_113 n_I4667 VDD_DEC pfet_05v0 L=0.5U W=2U AS=1.54P AD=1.54P
+ PS=5.54U PD=5.54U
* device instance _5661 r180 *1 531.51,183.82 pfet_05v0
XM_5661 VDD_DEC n_107 n_I4668 VDD_DEC pfet_05v0 L=0.5U W=2U AS=1.54P AD=1.54P
+ PS=5.54U PD=5.54U
* device instance _5662 r180 *1 571.51,183.82 pfet_05v0
XM_5662 VDD_DEC n_109 n_I4669 VDD_DEC pfet_05v0 L=0.5U W=2U AS=1.54P AD=1.54P
+ PS=5.54U PD=5.54U
* device instance _5663 r180 *1 531.51,105.82 pfet_05v0
XM_5663 VDD_DEC n_37 n_I4670 VDD_DEC pfet_05v0 L=0.5U W=2U AS=1.54P AD=1.54P
+ PS=5.54U PD=5.54U
* device instance _5664 r180 *1 571.51,105.82 pfet_05v0
XM_5664 VDD_DEC n_38 n_I4671 VDD_DEC pfet_05v0 L=0.5U W=2U AS=1.54P AD=1.54P
+ PS=5.54U PD=5.54U
* device instance _5665 r180 *1 91.51,339.82 pfet_05v0
XM_5665 VDD_DEC n_150 n_I4672 VDD_DEC pfet_05v0 L=0.5U W=2U AS=1.54P AD=1.54P
+ PS=5.54U PD=5.54U
* device instance _5666 r180 *1 571.51,27.82 pfet_05v0
XM_5666 VDD_DEC n_19 n_I4673 VDD_DEC pfet_05v0 L=0.5U W=2U AS=1.54P AD=1.54P
+ PS=5.54U PD=5.54U
* device instance _5667 r180 *1 411.51,105.82 pfet_05v0
XM_5667 VDD_DEC n_34 n_I4674 VDD_DEC pfet_05v0 L=0.5U W=2U AS=1.54P AD=1.54P
+ PS=5.54U PD=5.54U
* device instance _5668 r180 *1 651.51,105.82 pfet_05v0
XM_5668 VDD_DEC n_40 n_I4675 VDD_DEC pfet_05v0 L=0.5U W=2U AS=1.54P AD=1.54P
+ PS=5.54U PD=5.54U
* device instance _5669 r180 *1 651.51,27.82 pfet_05v0
XM_5669 VDD_DEC n_21 n_I4676 VDD_DEC pfet_05v0 L=0.5U W=2U AS=1.54P AD=1.54P
+ PS=5.54U PD=5.54U
* device instance _5670 r180 *1 51.51,417.82 pfet_05v0
XM_5670 VDD_DEC n_146 n_I4677 VDD_DEC pfet_05v0 L=0.5U W=2U AS=1.54P AD=1.54P
+ PS=5.54U PD=5.54U
* device instance _5671 r180 *1 371.51,105.82 pfet_05v0
XM_5671 VDD_DEC n_33 n_I4678 VDD_DEC pfet_05v0 L=0.5U W=2U AS=1.54P AD=1.54P
+ PS=5.54U PD=5.54U
* device instance _5672 r180 *1 211.51,339.82 pfet_05v0
XM_5672 VDD_DEC n_159 n_I4679 VDD_DEC pfet_05v0 L=0.5U W=2U AS=1.54P AD=1.54P
+ PS=5.54U PD=5.54U
* device instance _5673 r180 *1 291.51,417.82 pfet_05v0
XM_5673 VDD_DEC n_164 n_I4680 VDD_DEC pfet_05v0 L=0.5U W=2U AS=1.54P AD=1.54P
+ PS=5.54U PD=5.54U
* device instance _5674 r180 *1 331.51,573.82 pfet_05v0
XM_5674 VDD_DEC n_272 n_I4681 VDD_DEC pfet_05v0 L=0.5U W=2U AS=1.54P AD=1.54P
+ PS=5.54U PD=5.54U
* device instance _5675 r180 *1 251.51,417.82 pfet_05v0
XM_5675 VDD_DEC n_161 n_I4682 VDD_DEC pfet_05v0 L=0.5U W=2U AS=1.54P AD=1.54P
+ PS=5.54U PD=5.54U
* device instance _5676 r180 *1 291.51,339.82 pfet_05v0
XM_5676 VDD_DEC n_165 n_I4683 VDD_DEC pfet_05v0 L=0.5U W=2U AS=1.54P AD=1.54P
+ PS=5.54U PD=5.54U
* device instance _5677 r180 *1 611.51,105.82 pfet_05v0
XM_5677 VDD_DEC n_39 n_I4684 VDD_DEC pfet_05v0 L=0.5U W=2U AS=1.54P AD=1.54P
+ PS=5.54U PD=5.54U
* device instance _5678 r180 *1 331.51,417.82 pfet_05v0
XM_5678 VDD_DEC n_167 n_I4685 VDD_DEC pfet_05v0 L=0.5U W=2U AS=1.54P AD=1.54P
+ PS=5.54U PD=5.54U
* device instance _5679 r180 *1 171.51,339.82 pfet_05v0
XM_5679 VDD_DEC n_156 n_I4686 VDD_DEC pfet_05v0 L=0.5U W=2U AS=1.54P AD=1.54P
+ PS=5.54U PD=5.54U
* device instance _5680 r180 *1 331.51,339.82 pfet_05v0
XM_5680 VDD_DEC n_168 n_I4687 VDD_DEC pfet_05v0 L=0.5U W=2U AS=1.54P AD=1.54P
+ PS=5.54U PD=5.54U
* device instance _5681 r180 *1 331.51,261.82 pfet_05v0
XM_5681 VDD_DEC n_96 n_I4688 VDD_DEC pfet_05v0 L=0.5U W=2U AS=1.54P AD=1.54P
+ PS=5.54U PD=5.54U
* device instance _5682 r180 *1 331.51,183.82 pfet_05v0
XM_5682 VDD_DEC n_97 n_I4689 VDD_DEC pfet_05v0 L=0.5U W=2U AS=1.54P AD=1.54P
+ PS=5.54U PD=5.54U
* device instance _5683 r180 *1 331.51,105.82 pfet_05v0
XM_5683 VDD_DEC n_32 n_I4690 VDD_DEC pfet_05v0 L=0.5U W=2U AS=1.54P AD=1.54P
+ PS=5.54U PD=5.54U
* device instance _5684 r180 *1 331.51,27.82 pfet_05v0
XM_5684 VDD_DEC n_13 n_I4691 VDD_DEC pfet_05v0 L=0.5U W=2U AS=1.54P AD=1.54P
+ PS=5.54U PD=5.54U
* device instance _5685 r180 *1 171.51,261.82 pfet_05v0
XM_5685 VDD_DEC n_88 n_I4692 VDD_DEC pfet_05v0 L=0.5U W=2U AS=1.54P AD=1.54P
+ PS=5.54U PD=5.54U
* device instance _5686 r180 *1 171.51,183.82 pfet_05v0
XM_5686 VDD_DEC n_89 n_I4693 VDD_DEC pfet_05v0 L=0.5U W=2U AS=1.54P AD=1.54P
+ PS=5.54U PD=5.54U
* device instance _5687 r180 *1 211.51,573.82 pfet_05v0
XM_5687 VDD_DEC n_269 n_I4694 VDD_DEC pfet_05v0 L=0.5U W=2U AS=1.54P AD=1.54P
+ PS=5.54U PD=5.54U
* device instance _5688 r180 *1 371.51,495.82 pfet_05v0
XM_5688 VDD_DEC n_169 n_I4695 VDD_DEC pfet_05v0 L=0.5U W=2U AS=1.54P AD=1.54P
+ PS=5.54U PD=5.54U
* device instance _5689 r180 *1 411.51,495.82 pfet_05v0
XM_5689 VDD_DEC n_172 n_I4696 VDD_DEC pfet_05v0 L=0.5U W=2U AS=1.54P AD=1.54P
+ PS=5.54U PD=5.54U
* device instance _5690 r180 *1 451.51,495.82 pfet_05v0
XM_5690 VDD_DEC n_175 n_I4697 VDD_DEC pfet_05v0 L=0.5U W=2U AS=1.54P AD=1.54P
+ PS=5.54U PD=5.54U
* device instance _5691 r180 *1 491.51,495.82 pfet_05v0
XM_5691 VDD_DEC n_178 n_I4698 VDD_DEC pfet_05v0 L=0.5U W=2U AS=1.54P AD=1.54P
+ PS=5.54U PD=5.54U
* device instance _5692 r180 *1 651.51,495.82 pfet_05v0
XM_5692 VDD_DEC n_190 n_I4699 VDD_DEC pfet_05v0 L=0.5U W=2U AS=1.54P AD=1.54P
+ PS=5.54U PD=5.54U
* device instance _5693 r180 *1 51.51,339.82 pfet_05v0
XM_5693 VDD_DEC n_147 n_I4700 VDD_DEC pfet_05v0 L=0.5U W=2U AS=1.54P AD=1.54P
+ PS=5.54U PD=5.54U
* device instance _5694 r180 *1 571.51,495.82 pfet_05v0
XM_5694 VDD_DEC n_184 n_I4701 VDD_DEC pfet_05v0 L=0.5U W=2U AS=1.54P AD=1.54P
+ PS=5.54U PD=5.54U
* device instance _5695 r180 *1 611.51,495.82 pfet_05v0
XM_5695 VDD_DEC n_187 n_I4702 VDD_DEC pfet_05v0 L=0.5U W=2U AS=1.54P AD=1.54P
+ PS=5.54U PD=5.54U
* device instance _5696 r180 *1 171.51,495.82 pfet_05v0
XM_5696 VDD_DEC n_154 n_I4703 VDD_DEC pfet_05v0 L=0.5U W=2U AS=1.54P AD=1.54P
+ PS=5.54U PD=5.54U
* device instance _5697 r180 *1 211.51,261.82 pfet_05v0
XM_5697 VDD_DEC n_90 n_I4704 VDD_DEC pfet_05v0 L=0.5U W=2U AS=1.54P AD=1.54P
+ PS=5.54U PD=5.54U
* device instance _5698 r180 *1 91.51,495.82 pfet_05v0
XM_5698 VDD_DEC n_148 n_I4705 VDD_DEC pfet_05v0 L=0.5U W=2U AS=1.54P AD=1.54P
+ PS=5.54U PD=5.54U
* device instance _5699 r180 *1 131.51,495.82 pfet_05v0
XM_5699 VDD_DEC n_151 n_I4706 VDD_DEC pfet_05v0 L=0.5U W=2U AS=1.54P AD=1.54P
+ PS=5.54U PD=5.54U
* device instance _5700 r180 *1 51.51,495.82 pfet_05v0
XM_5700 VDD_DEC n_145 n_I4707 VDD_DEC pfet_05v0 L=0.5U W=2U AS=1.54P AD=1.54P
+ PS=5.54U PD=5.54U
* device instance _5701 r180 *1 211.51,495.82 pfet_05v0
XM_5701 VDD_DEC n_157 n_I4708 VDD_DEC pfet_05v0 L=0.5U W=2U AS=1.54P AD=1.54P
+ PS=5.54U PD=5.54U
* device instance _5702 r180 *1 251.51,495.82 pfet_05v0
XM_5702 VDD_DEC n_160 n_I4709 VDD_DEC pfet_05v0 L=0.5U W=2U AS=1.54P AD=1.54P
+ PS=5.54U PD=5.54U
* device instance _5703 r180 *1 291.51,495.82 pfet_05v0
XM_5703 VDD_DEC n_163 n_I4710 VDD_DEC pfet_05v0 L=0.5U W=2U AS=1.54P AD=1.54P
+ PS=5.54U PD=5.54U
* device instance _5704 r180 *1 251.51,261.82 pfet_05v0
XM_5704 VDD_DEC n_92 n_I4711 VDD_DEC pfet_05v0 L=0.5U W=2U AS=1.54P AD=1.54P
+ PS=5.54U PD=5.54U
* device instance _5705 r180 *1 291.51,261.82 pfet_05v0
XM_5705 VDD_DEC n_94 n_I4712 VDD_DEC pfet_05v0 L=0.5U W=2U AS=1.54P AD=1.54P
+ PS=5.54U PD=5.54U
* device instance _5706 r180 *1 91.51,261.82 pfet_05v0
XM_5706 VDD_DEC n_84 n_I4713 VDD_DEC pfet_05v0 L=0.5U W=2U AS=1.54P AD=1.54P
+ PS=5.54U PD=5.54U
* device instance _5707 r180 *1 131.51,261.82 pfet_05v0
XM_5707 VDD_DEC n_86 n_I4714 VDD_DEC pfet_05v0 L=0.5U W=2U AS=1.54P AD=1.54P
+ PS=5.54U PD=5.54U
* device instance _5708 r180 *1 51.51,261.82 pfet_05v0
XM_5708 VDD_DEC n_82 n_I4715 VDD_DEC pfet_05v0 L=0.5U W=2U AS=1.54P AD=1.54P
+ PS=5.54U PD=5.54U
* device instance _5709 r180 *1 531.51,495.82 pfet_05v0
XM_5709 VDD_DEC n_181 n_I4716 VDD_DEC pfet_05v0 L=0.5U W=2U AS=1.54P AD=1.54P
+ PS=5.54U PD=5.54U
* device instance _5710 r180 *1 491.51,339.82 pfet_05v0
XM_5710 VDD_DEC n_180 n_I4717 VDD_DEC pfet_05v0 L=0.5U W=2U AS=1.54P AD=1.54P
+ PS=5.54U PD=5.54U
* device instance _5711 r180 *1 211.51,27.82 pfet_05v0
XM_5711 VDD_DEC n_10 n_I4718 VDD_DEC pfet_05v0 L=0.5U W=2U AS=1.54P AD=1.54P
+ PS=5.54U PD=5.54U
* device instance _5712 r180 *1 451.51,339.82 pfet_05v0
XM_5712 VDD_DEC n_177 n_I4719 VDD_DEC pfet_05v0 L=0.5U W=2U AS=1.54P AD=1.54P
+ PS=5.54U PD=5.54U
* device instance _5713 r180 *1 371.51,573.82 pfet_05v0
XM_5713 VDD_DEC n_273 n_I4720 VDD_DEC pfet_05v0 L=0.5U W=2U AS=1.54P AD=1.54P
+ PS=5.54U PD=5.54U
* device instance _5714 r180 *1 411.51,339.82 pfet_05v0
XM_5714 VDD_DEC n_174 n_I4721 VDD_DEC pfet_05v0 L=0.5U W=2U AS=1.54P AD=1.54P
+ PS=5.54U PD=5.54U
* device instance _5715 r180 *1 491.51,417.82 pfet_05v0
XM_5715 VDD_DEC n_179 n_I4722 VDD_DEC pfet_05v0 L=0.5U W=2U AS=1.54P AD=1.54P
+ PS=5.54U PD=5.54U
* device instance _5716 r180 *1 371.51,339.82 pfet_05v0
XM_5716 VDD_DEC n_171 n_I4723 VDD_DEC pfet_05v0 L=0.5U W=2U AS=1.54P AD=1.54P
+ PS=5.54U PD=5.54U
* device instance _5717 r180 *1 371.51,417.82 pfet_05v0
XM_5717 VDD_DEC n_170 n_I4724 VDD_DEC pfet_05v0 L=0.5U W=2U AS=1.54P AD=1.54P
+ PS=5.54U PD=5.54U
* device instance _5718 r180 *1 451.51,417.82 pfet_05v0
XM_5718 VDD_DEC n_176 n_I4725 VDD_DEC pfet_05v0 L=0.5U W=2U AS=1.54P AD=1.54P
+ PS=5.54U PD=5.54U
* device instance _5719 r180 *1 251.51,27.82 pfet_05v0
XM_5719 VDD_DEC n_11 n_I4726 VDD_DEC pfet_05v0 L=0.5U W=2U AS=1.54P AD=1.54P
+ PS=5.54U PD=5.54U
* device instance _5720 r180 *1 411.51,417.82 pfet_05v0
XM_5720 VDD_DEC n_173 n_I4727 VDD_DEC pfet_05v0 L=0.5U W=2U AS=1.54P AD=1.54P
+ PS=5.54U PD=5.54U
* device instance _5721 r180 *1 611.51,417.82 pfet_05v0
XM_5721 VDD_DEC n_188 n_I4728 VDD_DEC pfet_05v0 L=0.5U W=2U AS=1.54P AD=1.54P
+ PS=5.54U PD=5.54U
* device instance _5722 r180 *1 571.51,417.82 pfet_05v0
XM_5722 VDD_DEC n_185 n_I4729 VDD_DEC pfet_05v0 L=0.5U W=2U AS=1.54P AD=1.54P
+ PS=5.54U PD=5.54U
* device instance _5723 r180 *1 611.51,339.82 pfet_05v0
XM_5723 VDD_DEC n_189 n_I4730 VDD_DEC pfet_05v0 L=0.5U W=2U AS=1.54P AD=1.54P
+ PS=5.54U PD=5.54U
* device instance _5724 r180 *1 611.51,573.82 pfet_05v0
XM_5724 VDD_DEC n_279 n_I4731 VDD_DEC pfet_05v0 L=0.5U W=2U AS=1.54P AD=1.54P
+ PS=5.54U PD=5.54U
* device instance _5725 r180 *1 331.51,495.82 pfet_05v0
XM_5725 VDD_DEC n_166 n_I4732 VDD_DEC pfet_05v0 L=0.5U W=2U AS=1.54P AD=1.54P
+ PS=5.54U PD=5.54U
* device instance _5726 r180 *1 531.51,339.82 pfet_05v0
XM_5726 VDD_DEC n_183 n_I4733 VDD_DEC pfet_05v0 L=0.5U W=2U AS=1.54P AD=1.54P
+ PS=5.54U PD=5.54U
* device instance _5727 r180 *1 571.51,573.82 pfet_05v0
XM_5727 VDD_DEC n_278 n_I4734 VDD_DEC pfet_05v0 L=0.5U W=2U AS=1.54P AD=1.54P
+ PS=5.54U PD=5.54U
* device instance _5728 r180 *1 651.51,573.82 pfet_05v0
XM_5728 VDD_DEC n_280 n_I4735 VDD_DEC pfet_05v0 L=0.5U W=2U AS=1.54P AD=1.54P
+ PS=5.54U PD=5.54U
* device instance _5729 r180 *1 571.51,261.82 pfet_05v0
XM_5729 VDD_DEC n_108 n_I4736 VDD_DEC pfet_05v0 L=0.5U W=2U AS=1.54P AD=1.54P
+ PS=5.54U PD=5.54U
* device instance _5730 r180 *1 611.51,261.82 pfet_05v0
XM_5730 VDD_DEC n_110 n_I4737 VDD_DEC pfet_05v0 L=0.5U W=2U AS=1.54P AD=1.54P
+ PS=5.54U PD=5.54U
* device instance _5731 r180 *1 651.51,261.82 pfet_05v0
XM_5731 VDD_DEC n_112 n_I4738 VDD_DEC pfet_05v0 L=0.5U W=2U AS=1.54P AD=1.54P
+ PS=5.54U PD=5.54U
* device instance _5732 r180 *1 571.51,339.82 pfet_05v0
XM_5732 VDD_DEC n_186 n_I4739 VDD_DEC pfet_05v0 L=0.5U W=2U AS=1.54P AD=1.54P
+ PS=5.54U PD=5.54U
* device instance _5733 r180 *1 531.51,417.82 pfet_05v0
XM_5733 VDD_DEC n_182 n_I4740 VDD_DEC pfet_05v0 L=0.5U W=2U AS=1.54P AD=1.54P
+ PS=5.54U PD=5.54U
* device instance _5734 r180 *1 531.51,261.82 pfet_05v0
XM_5734 VDD_DEC n_106 n_I4741 VDD_DEC pfet_05v0 L=0.5U W=2U AS=1.54P AD=1.54P
+ PS=5.54U PD=5.54U
* device instance _5735 r180 *1 491.51,261.82 pfet_05v0
XM_5735 VDD_DEC n_104 n_I4742 VDD_DEC pfet_05v0 L=0.5U W=2U AS=1.54P AD=1.54P
+ PS=5.54U PD=5.54U
* device instance _5736 r180 *1 451.51,261.82 pfet_05v0
XM_5736 VDD_DEC n_102 n_I4743 VDD_DEC pfet_05v0 L=0.5U W=2U AS=1.54P AD=1.54P
+ PS=5.54U PD=5.54U
* device instance _5737 r180 *1 371.51,261.82 pfet_05v0
XM_5737 VDD_DEC n_98 n_I4744 VDD_DEC pfet_05v0 L=0.5U W=2U AS=1.54P AD=1.54P
+ PS=5.54U PD=5.54U
* device instance _5738 r180 *1 411.51,261.82 pfet_05v0
XM_5738 VDD_DEC n_100 n_I4745 VDD_DEC pfet_05v0 L=0.5U W=2U AS=1.54P AD=1.54P
+ PS=5.54U PD=5.54U
* device instance _5739 r180 *1 651.51,417.82 pfet_05v0
XM_5739 VDD_DEC n_191 n_I4746 VDD_DEC pfet_05v0 L=0.5U W=2U AS=1.54P AD=1.54P
+ PS=5.54U PD=5.54U
* device instance _5740 r180 *1 651.51,339.82 pfet_05v0
XM_5740 VDD_DEC n_192 n_I4747 VDD_DEC pfet_05v0 L=0.5U W=2U AS=1.54P AD=1.54P
+ PS=5.54U PD=5.54U
* device instance _5741 r180 *1 531.51,573.82 pfet_05v0
XM_5741 VDD_DEC n_277 n_I4748 VDD_DEC pfet_05v0 L=0.5U W=2U AS=1.54P AD=1.54P
+ PS=5.54U PD=5.54U
* device instance _5742 r180 *1 91.51,417.82 pfet_05v0
XM_5742 VDD_DEC n_149 n_I4749 VDD_DEC pfet_05v0 L=0.5U W=2U AS=1.54P AD=1.54P
+ PS=5.54U PD=5.54U
* device instance _5743 r180 *1 371.51,27.82 pfet_05v0
XM_5743 VDD_DEC n_14 n_I4750 VDD_DEC pfet_05v0 L=0.5U W=2U AS=1.54P AD=1.54P
+ PS=5.54U PD=5.54U
* device instance _5744 r180 *1 131.51,573.82 pfet_05v0
XM_5744 VDD_DEC n_267 n_I4751 VDD_DEC pfet_05v0 L=0.5U W=2U AS=1.54P AD=1.54P
+ PS=5.54U PD=5.54U
* device instance _5745 r180 *1 51.51,573.82 pfet_05v0
XM_5745 VDD_DEC n_265 n_I4752 VDD_DEC pfet_05v0 L=0.5U W=2U AS=1.54P AD=1.54P
+ PS=5.54U PD=5.54U
* device instance _5746 r180 *1 131.51,339.82 pfet_05v0
XM_5746 VDD_DEC n_153 n_I4753 VDD_DEC pfet_05v0 L=0.5U W=2U AS=1.54P AD=1.54P
+ PS=5.54U PD=5.54U
* device instance _5747 r180 *1 131.51,417.82 pfet_05v0
XM_5747 VDD_DEC n_152 n_I4754 VDD_DEC pfet_05v0 L=0.5U W=2U AS=1.54P AD=1.54P
+ PS=5.54U PD=5.54U
* device instance _5748 r180 *1 51.51,105.82 pfet_05v0
XM_5748 VDD_DEC n_25 n_I4755 VDD_DEC pfet_05v0 L=0.5U W=2U AS=1.54P AD=1.54P
+ PS=5.54U PD=5.54U
* device instance _5749 r180 *1 91.51,105.82 pfet_05v0
XM_5749 VDD_DEC n_26 n_I4756 VDD_DEC pfet_05v0 L=0.5U W=2U AS=1.54P AD=1.54P
+ PS=5.54U PD=5.54U
* device instance _5750 r180 *1 131.51,105.82 pfet_05v0
XM_5750 VDD_DEC n_27 n_I4757 VDD_DEC pfet_05v0 L=0.5U W=2U AS=1.54P AD=1.54P
+ PS=5.54U PD=5.54U
* device instance _5751 r180 *1 91.51,27.82 pfet_05v0
XM_5751 VDD_DEC n_7 n_I4758 VDD_DEC pfet_05v0 L=0.5U W=2U AS=1.54P AD=1.54P
+ PS=5.54U PD=5.54U
* device instance _5752 r180 *1 451.51,27.82 pfet_05v0
XM_5752 VDD_DEC n_16 n_I4759 VDD_DEC pfet_05v0 L=0.5U W=2U AS=1.54P AD=1.54P
+ PS=5.54U PD=5.54U
* device instance _5753 r180 *1 131.51,27.82 pfet_05v0
XM_5753 VDD_DEC n_8 n_I4760 VDD_DEC pfet_05v0 L=0.5U W=2U AS=1.54P AD=1.54P
+ PS=5.54U PD=5.54U
* device instance _5754 r180 *1 131.51,183.82 pfet_05v0
XM_5754 VDD_DEC n_87 n_I4761 VDD_DEC pfet_05v0 L=0.5U W=2U AS=1.54P AD=1.54P
+ PS=5.54U PD=5.54U
* device instance _5755 r180 *1 51.51,183.82 pfet_05v0
XM_5755 VDD_DEC n_83 n_I4762 VDD_DEC pfet_05v0 L=0.5U W=2U AS=1.54P AD=1.54P
+ PS=5.54U PD=5.54U
* device instance _5756 r180 *1 251.51,183.82 pfet_05v0
XM_5756 VDD_DEC n_93 n_I4763 VDD_DEC pfet_05v0 L=0.5U W=2U AS=1.54P AD=1.54P
+ PS=5.54U PD=5.54U
* device instance _5757 r180 *1 211.51,105.82 pfet_05v0
XM_5757 VDD_DEC n_29 n_I4764 VDD_DEC pfet_05v0 L=0.5U W=2U AS=1.54P AD=1.54P
+ PS=5.54U PD=5.54U
* device instance _5758 r180 *1 251.51,105.82 pfet_05v0
XM_5758 VDD_DEC n_30 n_I4765 VDD_DEC pfet_05v0 L=0.5U W=2U AS=1.54P AD=1.54P
+ PS=5.54U PD=5.54U
* device instance _5759 r180 *1 171.51,573.82 pfet_05v0
XM_5759 VDD_DEC n_268 n_I4766 VDD_DEC pfet_05v0 L=0.5U W=2U AS=1.54P AD=1.54P
+ PS=5.54U PD=5.54U
* device instance _5760 r180 *1 291.51,183.82 pfet_05v0
XM_5760 VDD_DEC n_95 n_I4767 VDD_DEC pfet_05v0 L=0.5U W=2U AS=1.54P AD=1.54P
+ PS=5.54U PD=5.54U
* device instance _5761 r180 *1 291.51,105.82 pfet_05v0
XM_5761 VDD_DEC n_31 n_I4768 VDD_DEC pfet_05v0 L=0.5U W=2U AS=1.54P AD=1.54P
+ PS=5.54U PD=5.54U
* device instance _5762 r180 *1 371.51,183.82 pfet_05v0
XM_5762 VDD_DEC n_99 n_I4769 VDD_DEC pfet_05v0 L=0.5U W=2U AS=1.54P AD=1.54P
+ PS=5.54U PD=5.54U
* device instance _5763 r180 *1 411.51,183.82 pfet_05v0
XM_5763 VDD_DEC n_101 n_I4770 VDD_DEC pfet_05v0 L=0.5U W=2U AS=1.54P AD=1.54P
+ PS=5.54U PD=5.54U
* device instance _5764 r180 *1 91.51,183.82 pfet_05v0
XM_5764 VDD_DEC n_85 n_I4771 VDD_DEC pfet_05v0 L=0.5U W=2U AS=1.54P AD=1.54P
+ PS=5.54U PD=5.54U
* device instance _5765 r180 *1 491.51,183.82 pfet_05v0
XM_5765 VDD_DEC n_105 n_I4772 VDD_DEC pfet_05v0 L=0.5U W=2U AS=1.54P AD=1.54P
+ PS=5.54U PD=5.54U
* device instance _5766 r180 *1 491.51,573.82 pfet_05v0
XM_5766 VDD_DEC n_276 n_I4773 VDD_DEC pfet_05v0 L=0.5U W=2U AS=1.54P AD=1.54P
+ PS=5.54U PD=5.54U
* device instance _5767 r180 *1 451.51,573.82 pfet_05v0
XM_5767 VDD_DEC n_275 n_I4774 VDD_DEC pfet_05v0 L=0.5U W=2U AS=1.54P AD=1.54P
+ PS=5.54U PD=5.54U
* device instance _5768 r180 *1 411.51,27.82 pfet_05v0
XM_5768 VDD_DEC n_15 n_I4775 VDD_DEC pfet_05v0 L=0.5U W=2U AS=1.54P AD=1.54P
+ PS=5.54U PD=5.54U
* device instance _5769 r180 *1 411.51,573.82 pfet_05v0
XM_5769 VDD_DEC n_274 n_I4776 VDD_DEC pfet_05v0 L=0.5U W=2U AS=1.54P AD=1.54P
+ PS=5.54U PD=5.54U
* device instance _5770 r180 *1 291.51,27.82 pfet_05v0
XM_5770 VDD_DEC n_12 n_I4777 VDD_DEC pfet_05v0 L=0.5U W=2U AS=1.54P AD=1.54P
+ PS=5.54U PD=5.54U
* device instance _5771 r180 *1 211.51,183.82 pfet_05v0
XM_5771 VDD_DEC n_91 n_I4778 VDD_DEC pfet_05v0 L=0.5U W=2U AS=1.54P AD=1.54P
+ PS=5.54U PD=5.54U
* device instance _5772 r180 *1 491.51,27.82 pfet_05v0
XM_5772 VDD_DEC n_17 n_I4779 VDD_DEC pfet_05v0 L=0.5U W=2U AS=1.54P AD=1.54P
+ PS=5.54U PD=5.54U
* device instance _5773 r180 *1 451.51,183.82 pfet_05v0
XM_5773 VDD_DEC n_103 n_I4780 VDD_DEC pfet_05v0 L=0.5U W=2U AS=1.54P AD=1.54P
+ PS=5.54U PD=5.54U
.ENDS workshop_inverter

* cell inv_dut_125
* pin Q
* pin A
* pin VDD
* pin VSS
.SUBCKT inv_dut_125 Q A VDD VSS
* device instance _1 r0 *1 -0.855,9.4 pfet_03v3
XM_1 Q A VDD VDD pfet_03v3 L=0.6U W=5.4U AS=3.51P AD=3.51P PS=12.1U PD=12.1U
* device instance _2 r0 *1 -0.855,-11.2 nfet_03v3
XM_2 Q A VSS VSS nfet_03v3 L=0.6U W=1.8U AS=1.098P AD=1.098P PS=4.82U PD=4.82U
.ENDS inv_dut_125

* cell inv_dut_124
* pin Q
* pin A
* pin VDD
* pin VSS
.SUBCKT inv_dut_124 Q A VDD VSS
* device instance _1 r0 *1 -0.855,10.75 pfet_03v3
XM_1 Q A VDD VDD pfet_03v3 L=0.6U W=2.7U AS=1.755P AD=1.755P PS=6.7U PD=6.7U
* device instance _2 r0 *1 -0.855,-11.65 nfet_03v3
XM_2 Q A VSS VSS nfet_03v3 L=0.6U W=0.9U AS=0.549P AD=0.549P PS=3.02U PD=3.02U
.ENDS inv_dut_124

* cell inv_dut_095
* pin Q
* pin A
* pin VDD
* pin VSS
.SUBCKT inv_dut_095 Q A VDD VSS
* device instance _1 r0 *1 -0.705,8.05 pfet_03v3
XM_1 Q A VDD VDD pfet_03v3 L=0.9U W=8.1U AS=5.265P AD=5.265P PS=17.5U PD=17.5U
* device instance _2 r0 *1 -0.705,-10.75 nfet_03v3
XM_2 Q A VSS VSS nfet_03v3 L=0.9U W=2.7U AS=1.647P AD=1.647P PS=6.62U PD=6.62U
.ENDS inv_dut_095

* cell inv_dut_094
* pin Q
* pin A
* pin VDD
* pin VSS
.SUBCKT inv_dut_094 Q A VDD VSS
* device instance _1 r0 *1 -0.855,8.05 pfet_03v3
XM_1 Q A VDD VDD pfet_03v3 L=0.6U W=8.1U AS=5.265P AD=5.265P PS=17.5U PD=17.5U
* device instance _2 r0 *1 -0.855,-10.75 nfet_03v3
XM_2 Q A VSS VSS nfet_03v3 L=0.6U W=2.7U AS=1.647P AD=1.647P PS=6.62U PD=6.62U
.ENDS inv_dut_094

* cell inv_dut_093
* pin Q
* pin A
* pin VDD
* pin VSS
.SUBCKT inv_dut_093 Q A VDD VSS
* device instance _1 r0 *1 -0.855,9.4 pfet_03v3
XM_1 Q A VDD VDD pfet_03v3 L=0.6U W=5.4U AS=3.51P AD=3.51P PS=12.1U PD=12.1U
* device instance _2 r0 *1 -0.855,-11.2 nfet_03v3
XM_2 Q A VSS VSS nfet_03v3 L=0.6U W=1.8U AS=1.098P AD=1.098P PS=4.82U PD=4.82U
.ENDS inv_dut_093

* cell inv_dut_111
* pin Q
* pin A
* pin VDD
* pin VSS
.SUBCKT inv_dut_111 Q A VDD VSS
* device instance _1 r0 *1 0.365,4 pfet_05v0
XM_1 Q A VDD VDD pfet_05v0 L=1.8U W=16.2U AS=12.474P AD=12.474P PS=33.94U
+ PD=33.94U
* device instance _2 r0 *1 0.365,-9.4 nfet_05v0
XM_2 Q A VSS VSS nfet_05v0 L=1.8U W=5.4U AS=3.942P AD=3.942P PS=12.26U PD=12.26U
.ENDS inv_dut_111

* cell inv_dut_110
* pin Q
* pin A
* pin VDD
* pin VSS
.SUBCKT inv_dut_110 Q A VDD VSS
* device instance _1 r0 *1 0.065,4 pfet_05v0
XM_1 Q A VDD VDD pfet_05v0 L=1.2U W=16.2U AS=12.474P AD=12.474P PS=33.94U
+ PD=33.94U
* device instance _2 r0 *1 0.065,-9.4 nfet_05v0
XM_2 Q A VSS VSS nfet_05v0 L=1.2U W=5.4U AS=3.942P AD=3.942P PS=12.26U PD=12.26U
.ENDS inv_dut_110

* cell inv_dut_092
* pin Q
* pin A
* pin VDD
* pin VSS
.SUBCKT inv_dut_092 Q A VDD VSS
* device instance _1 r0 *1 -0.855,10.75 pfet_03v3
XM_1 Q A VDD VDD pfet_03v3 L=0.6U W=2.7U AS=1.755P AD=1.755P PS=6.7U PD=6.7U
* device instance _2 r0 *1 -0.855,-11.65 nfet_03v3
XM_2 Q A VSS VSS nfet_03v3 L=0.6U W=0.9U AS=0.549P AD=0.549P PS=3.02U PD=3.02U
.ENDS inv_dut_092

* cell inv_dut_109
* pin Q
* pin A
* pin VDD
* pin VSS
.SUBCKT inv_dut_109 Q A VDD VSS
* device instance _1 r0 *1 0.065,6.7 pfet_05v0
XM_1 Q A VDD VDD pfet_05v0 L=1.2U W=10.8U AS=8.316P AD=8.316P PS=23.14U PD=23.14U
* device instance _2 r0 *1 0.065,-10.3 nfet_05v0
XM_2 Q A VSS VSS nfet_05v0 L=1.2U W=3.6U AS=2.628P AD=2.628P PS=8.66U PD=8.66U
.ENDS inv_dut_109

* cell inv_dut_108
* pin Q
* pin A
* pin VDD
* pin VSS
.SUBCKT inv_dut_108 Q A VDD VSS
* device instance _1 r0 *1 0.065,9.4 pfet_05v0
XM_1 Q A VDD VDD pfet_05v0 L=1.2U W=5.4U AS=4.158P AD=4.158P PS=12.34U PD=12.34U
* device instance _2 r0 *1 0.065,-11.2 nfet_05v0
XM_2 Q A VSS VSS nfet_05v0 L=1.2U W=1.8U AS=1.314P AD=1.314P PS=5.06U PD=5.06U
.ENDS inv_dut_108

* cell inv_dut_127
* pin Q
* pin A
* pin VDD
* pin VSS
.SUBCKT inv_dut_127 Q A VDD VSS
* device instance _1 r0 *1 -0.705,8.05 pfet_03v3
XM_1 Q A VDD VDD pfet_03v3 L=0.9U W=8.1U AS=5.265P AD=5.265P PS=17.5U PD=17.5U
* device instance _2 r0 *1 -0.705,-10.75 nfet_03v3
XM_2 Q A VSS VSS nfet_03v3 L=0.9U W=2.7U AS=1.647P AD=1.647P PS=6.62U PD=6.62U
.ENDS inv_dut_127

* cell inv_dut_126
* pin Q
* pin A
* pin VDD
* pin VSS
.SUBCKT inv_dut_126 Q A VDD VSS
* device instance _1 r0 *1 -0.855,8.05 pfet_03v3
XM_1 Q A VDD VDD pfet_03v3 L=0.6U W=8.1U AS=5.265P AD=5.265P PS=17.5U PD=17.5U
* device instance _2 r0 *1 -0.855,-10.75 nfet_03v3
XM_2 Q A VSS VSS nfet_03v3 L=0.6U W=2.7U AS=1.647P AD=1.647P PS=6.62U PD=6.62U
.ENDS inv_dut_126

* cell inv_dut_091
* pin Q
* pin A
* pin VDD
* pin VSS
.SUBCKT inv_dut_091 Q A VDD VSS
* device instance _1 r0 *1 -0.855,9.4 pfet_03v3
XM_1 Q A VDD VDD pfet_03v3 L=0.6U W=5.4U AS=3.51P AD=3.51P PS=12.1U PD=12.1U
* device instance _2 r0 *1 -0.855,-10.75 nfet_03v3
XM_2 Q A VSS VSS nfet_03v3 L=0.6U W=2.7U AS=1.647P AD=1.647P PS=6.62U PD=6.62U
.ENDS inv_dut_091

* cell inv_dut_090
* pin Q
* pin A
* pin VDD
* pin VSS
.SUBCKT inv_dut_090 Q A VDD VSS
* device instance _1 r0 *1 -0.855,10.3 pfet_03v3
XM_1 Q A VDD VDD pfet_03v3 L=0.6U W=3.6U AS=2.34P AD=2.34P PS=8.5U PD=8.5U
* device instance _2 r0 *1 -0.855,-11.2 nfet_03v3
XM_2 Q A VSS VSS nfet_03v3 L=0.6U W=1.8U AS=1.098P AD=1.098P PS=4.82U PD=4.82U
.ENDS inv_dut_090

* cell inv_dut_089
* pin Q
* pin A
* pin VDD
* pin VSS
.SUBCKT inv_dut_089 Q A VDD VSS
* device instance _1 r0 *1 -0.855,11.2 pfet_03v3
XM_1 Q A VDD VDD pfet_03v3 L=0.6U W=1.8U AS=1.17P AD=1.17P PS=4.9U PD=4.9U
* device instance _2 r0 *1 -0.855,-11.65 nfet_03v3
XM_2 Q A VSS VSS nfet_03v3 L=0.6U W=0.9U AS=0.549P AD=0.549P PS=3.02U PD=3.02U
.ENDS inv_dut_089

* cell inv_dut_121
* pin Q
* pin A
* pin VDD
* pin VSS
.SUBCKT inv_dut_121 Q A VDD VSS
* device instance _1 r0 *1 -0.855,11.2 pfet_03v3
XM_1 Q A VDD VDD pfet_03v3 L=0.6U W=1.8U AS=1.17P AD=1.17P PS=4.9U PD=4.9U
* device instance _2 r0 *1 -0.855,-11.65 nfet_03v3
XM_2 Q A VSS VSS nfet_03v3 L=0.6U W=0.9U AS=0.549P AD=0.549P PS=3.02U PD=3.02U
.ENDS inv_dut_121

* cell inv_dut_088
* pin Q
* pin A
* pin VDD
* pin VSS
.SUBCKT inv_dut_088 Q A VDD VSS
* device instance _1 r0 *1 -1.005,8.05 pfet_03v3
XM_1 Q A VDD VDD pfet_03v3 L=0.3U W=8.1U AS=5.265P AD=5.265P PS=17.5U PD=17.5U
* device instance _2 r0 *1 -1.005,-10.75 nfet_03v3
XM_2 Q A VSS VSS nfet_03v3 L=0.3U W=2.7U AS=1.647P AD=1.647P PS=6.62U PD=6.62U
.ENDS inv_dut_088

* cell inv_dut_107
* pin Q
* pin A
* pin VDD
* pin VSS
.SUBCKT inv_dut_107 Q A VDD VSS
* device instance _1 r0 *1 0.065,6.7 pfet_05v0
XM_1 Q A VDD VDD pfet_05v0 L=1.2U W=10.8U AS=8.316P AD=8.316P PS=23.14U PD=23.14U
* device instance _2 r0 *1 0.065,-9.4 nfet_05v0
XM_2 Q A VSS VSS nfet_05v0 L=1.2U W=5.4U AS=3.942P AD=3.942P PS=12.26U PD=12.26U
.ENDS inv_dut_107

* cell inv_dut_106
* pin Q
* pin A
* pin VDD
* pin VSS
.SUBCKT inv_dut_106 Q A VDD VSS
* device instance _1 r0 *1 0.065,8.5 pfet_05v0
XM_1 Q A VDD VDD pfet_05v0 L=1.2U W=7.2U AS=5.544P AD=5.544P PS=15.94U PD=15.94U
* device instance _2 r0 *1 0.065,-10.3 nfet_05v0
XM_2 Q A VSS VSS nfet_05v0 L=1.2U W=3.6U AS=2.628P AD=2.628P PS=8.66U PD=8.66U
.ENDS inv_dut_106

* cell inv_dut_105
* pin Q
* pin A
* pin VDD
* pin VSS
.SUBCKT inv_dut_105 Q A VDD VSS
* device instance _1 r0 *1 0.065,10.3 pfet_05v0
XM_1 Q A VDD VDD pfet_05v0 L=1.2U W=3.6U AS=2.772P AD=2.772P PS=8.74U PD=8.74U
* device instance _2 r0 *1 0.065,-11.2 nfet_05v0
XM_2 Q A VSS VSS nfet_05v0 L=1.2U W=1.8U AS=1.314P AD=1.314P PS=5.06U PD=5.06U
.ENDS inv_dut_105

* cell inv_dut_104
* pin Q
* pin A
* pin VDD
* pin VSS
.SUBCKT inv_dut_104 Q A VDD VSS
* device instance _1 r0 *1 -0.235,4 pfet_05v0
XM_1 Q A VDD VDD pfet_05v0 L=0.6U W=16.2U AS=12.474P AD=12.474P PS=33.94U
+ PD=33.94U
* device instance _2 r0 *1 -0.235,-9.4 nfet_05v0
XM_2 Q A VSS VSS nfet_05v0 L=0.6U W=5.4U AS=3.942P AD=3.942P PS=12.26U PD=12.26U
.ENDS inv_dut_104

* cell inv_dut_120
* pin Q
* pin A
* pin VDD
* pin VSS
.SUBCKT inv_dut_120 Q A VDD VSS
* device instance _1 r0 *1 -1.005,8.05 pfet_03v3
XM_1 Q A VDD VDD pfet_03v3 L=0.3U W=8.1U AS=5.265P AD=5.265P PS=17.5U PD=17.5U
* device instance _2 r0 *1 -1.005,-10.75 nfet_03v3
XM_2 Q A VSS VSS nfet_03v3 L=0.3U W=2.7U AS=1.647P AD=1.647P PS=6.62U PD=6.62U
.ENDS inv_dut_120

* cell inv_dut_123
* pin Q
* pin A
* pin VDD
* pin VSS
.SUBCKT inv_dut_123 Q A VDD VSS
* device instance _1 r0 *1 -0.855,9.4 pfet_03v3
XM_1 Q A VDD VDD pfet_03v3 L=0.6U W=5.4U AS=3.51P AD=3.51P PS=12.1U PD=12.1U
* device instance _2 r0 *1 -0.855,-10.75 nfet_03v3
XM_2 Q A VSS VSS nfet_03v3 L=0.6U W=2.7U AS=1.647P AD=1.647P PS=6.62U PD=6.62U
.ENDS inv_dut_123

* cell inv_dut_122
* pin Q
* pin A
* pin VDD
* pin VSS
.SUBCKT inv_dut_122 Q A VDD VSS
* device instance _1 r0 *1 -0.855,10.3 pfet_03v3
XM_1 Q A VDD VDD pfet_03v3 L=0.6U W=3.6U AS=2.34P AD=2.34P PS=8.5U PD=8.5U
* device instance _2 r0 *1 -0.855,-11.2 nfet_03v3
XM_2 Q A VSS VSS nfet_03v3 L=0.6U W=1.8U AS=1.098P AD=1.098P PS=4.82U PD=4.82U
.ENDS inv_dut_122

* cell inv_dut_040
* pin Q
* pin A
* pin VDD
* pin VSS
.SUBCKT inv_dut_040 Q A VDD VSS
* device instance _1 r0 *1 -0.235,4 pfet_05v0
XM_1 Q A VDD VDD pfet_05v0 L=0.6U W=16.2U AS=12.474P AD=12.474P PS=33.94U
+ PD=33.94U
* device instance _2 r0 *1 -0.235,-9.4 nfet_05v0
XM_2 Q A VSS VSS nfet_05v0 L=0.6U W=5.4U AS=3.942P AD=3.942P PS=12.26U PD=12.26U
.ENDS inv_dut_040

* cell inv_dut_056
* pin Q
* pin A
* pin VDD
* pin VSS
.SUBCKT inv_dut_056 Q A VDD VSS
* device instance _1 r0 *1 -1.005,8.05 pfet_03v3
XM_1 Q A VDD VDD pfet_03v3 L=0.3U W=8.1U AS=5.265P AD=5.265P PS=17.5U PD=17.5U
* device instance _2 r0 *1 -1.005,-10.75 nfet_03v3
XM_2 Q A VSS VSS nfet_03v3 L=0.3U W=2.7U AS=1.647P AD=1.647P PS=6.62U PD=6.62U
.ENDS inv_dut_056

* cell inv_dut_075
* pin Q
* pin A
* pin VDD
* pin VSS
.SUBCKT inv_dut_075 Q A VDD VSS
* device instance _1 r0 *1 0.065,6.7 pfet_05v0
XM_1 Q A VDD VDD pfet_05v0 L=1.2U W=10.8U AS=8.316P AD=8.316P PS=23.14U PD=23.14U
* device instance _2 r0 *1 0.065,-9.4 nfet_05v0
XM_2 Q A VSS VSS nfet_05v0 L=1.2U W=5.4U AS=3.942P AD=3.942P PS=12.26U PD=12.26U
.ENDS inv_dut_075

* cell inv_dut_074
* pin Q
* pin A
* pin VDD
* pin VSS
.SUBCKT inv_dut_074 Q A VDD VSS
* device instance _1 r0 *1 0.065,8.5 pfet_05v0
XM_1 Q A VDD VDD pfet_05v0 L=1.2U W=7.2U AS=5.544P AD=5.544P PS=15.94U PD=15.94U
* device instance _2 r0 *1 0.065,-10.3 nfet_05v0
XM_2 Q A VSS VSS nfet_05v0 L=1.2U W=3.6U AS=2.628P AD=2.628P PS=8.66U PD=8.66U
.ENDS inv_dut_074

* cell inv_dut_073
* pin Q
* pin A
* pin VDD
* pin VSS
.SUBCKT inv_dut_073 Q A VDD VSS
* device instance _1 r0 *1 0.065,10.3 pfet_05v0
XM_1 Q A VDD VDD pfet_05v0 L=1.2U W=3.6U AS=2.772P AD=2.772P PS=8.74U PD=8.74U
* device instance _2 r0 *1 0.065,-11.2 nfet_05v0
XM_2 Q A VSS VSS nfet_05v0 L=1.2U W=1.8U AS=1.314P AD=1.314P PS=5.06U PD=5.06U
.ENDS inv_dut_073

* cell inv_dut_072
* pin Q
* pin A
* pin VDD
* pin VSS
.SUBCKT inv_dut_072 Q A VDD VSS
* device instance _1 r0 *1 -0.235,4 pfet_05v0
XM_1 Q A VDD VDD pfet_05v0 L=0.6U W=16.2U AS=12.474P AD=12.474P PS=33.94U
+ PD=33.94U
* device instance _2 r0 *1 -0.235,-9.4 nfet_05v0
XM_2 Q A VSS VSS nfet_05v0 L=0.6U W=5.4U AS=3.942P AD=3.942P PS=12.26U PD=12.26U
.ENDS inv_dut_072

* cell inv_dut_059
* pin Q
* pin A
* pin VDD
* pin VSS
.SUBCKT inv_dut_059 Q A VDD VSS
* device instance _1 r0 *1 -0.855,9.4 pfet_03v3
XM_1 Q A VDD VDD pfet_03v3 L=0.6U W=5.4U AS=3.51P AD=3.51P PS=12.1U PD=12.1U
* device instance _2 r0 *1 -0.855,-10.75 nfet_03v3
XM_2 Q A VSS VSS nfet_03v3 L=0.6U W=2.7U AS=1.647P AD=1.647P PS=6.62U PD=6.62U
.ENDS inv_dut_059

* cell inv_dut_058
* pin Q
* pin A
* pin VDD
* pin VSS
.SUBCKT inv_dut_058 Q A VDD VSS
* device instance _1 r0 *1 -0.855,10.3 pfet_03v3
XM_1 Q A VDD VDD pfet_03v3 L=0.6U W=3.6U AS=2.34P AD=2.34P PS=8.5U PD=8.5U
* device instance _2 r0 *1 -0.855,-11.2 nfet_03v3
XM_2 Q A VSS VSS nfet_03v3 L=0.6U W=1.8U AS=1.098P AD=1.098P PS=4.82U PD=4.82U
.ENDS inv_dut_058

* cell inv_dut_057
* pin Q
* pin A
* pin VDD
* pin VSS
.SUBCKT inv_dut_057 Q A VDD VSS
* device instance _1 r0 *1 -0.855,11.2 pfet_03v3
XM_1 Q A VDD VDD pfet_03v3 L=0.6U W=1.8U AS=1.17P AD=1.17P PS=4.9U PD=4.9U
* device instance _2 r0 *1 -0.855,-11.65 nfet_03v3
XM_2 Q A VSS VSS nfet_03v3 L=0.6U W=0.9U AS=0.549P AD=0.549P PS=3.02U PD=3.02U
.ENDS inv_dut_057

* cell inv_dut_043
* pin Q
* pin A
* pin VDD
* pin VSS
.SUBCKT inv_dut_043 Q A VDD VSS
* device instance _1 r0 *1 0.065,6.7 pfet_05v0
XM_1 Q A VDD VDD pfet_05v0 L=1.2U W=10.8U AS=8.316P AD=8.316P PS=23.14U PD=23.14U
* device instance _2 r0 *1 0.065,-9.4 nfet_05v0
XM_2 Q A VSS VSS nfet_05v0 L=1.2U W=5.4U AS=3.942P AD=3.942P PS=12.26U PD=12.26U
.ENDS inv_dut_043

* cell inv_dut_042
* pin Q
* pin A
* pin VDD
* pin VSS
.SUBCKT inv_dut_042 Q A VDD VSS
* device instance _1 r0 *1 0.065,8.5 pfet_05v0
XM_1 Q A VDD VDD pfet_05v0 L=1.2U W=7.2U AS=5.544P AD=5.544P PS=15.94U PD=15.94U
* device instance _2 r0 *1 0.065,-10.3 nfet_05v0
XM_2 Q A VSS VSS nfet_05v0 L=1.2U W=3.6U AS=2.628P AD=2.628P PS=8.66U PD=8.66U
.ENDS inv_dut_042

* cell inv_dut_041
* pin Q
* pin A
* pin VDD
* pin VSS
.SUBCKT inv_dut_041 Q A VDD VSS
* device instance _1 r0 *1 0.065,10.3 pfet_05v0
XM_1 Q A VDD VDD pfet_05v0 L=1.2U W=3.6U AS=2.772P AD=2.772P PS=8.74U PD=8.74U
* device instance _2 r0 *1 0.065,-11.2 nfet_05v0
XM_2 Q A VSS VSS nfet_05v0 L=1.2U W=1.8U AS=1.314P AD=1.314P PS=5.06U PD=5.06U
.ENDS inv_dut_041

* cell inv_dut_060
* pin Q
* pin A
* pin VDD
* pin VSS
.SUBCKT inv_dut_060 Q A VDD VSS
* device instance _1 r0 *1 -0.855,10.75 pfet_03v3
XM_1 Q A VDD VDD pfet_03v3 L=0.6U W=2.7U AS=1.755P AD=1.755P PS=6.7U PD=6.7U
* device instance _2 r0 *1 -0.855,-11.65 nfet_03v3
XM_2 Q A VSS VSS nfet_03v3 L=0.6U W=0.9U AS=0.549P AD=0.549P PS=3.02U PD=3.02U
.ENDS inv_dut_060

* cell inv_dut_079
* pin Q
* pin A
* pin VDD
* pin VSS
.SUBCKT inv_dut_079 Q A VDD VSS
* device instance _1 r0 *1 0.365,4 pfet_05v0
XM_1 Q A VDD VDD pfet_05v0 L=1.8U W=16.2U AS=12.474P AD=12.474P PS=33.94U
+ PD=33.94U
* device instance _2 r0 *1 0.365,-9.4 nfet_05v0
XM_2 Q A VSS VSS nfet_05v0 L=1.8U W=5.4U AS=3.942P AD=3.942P PS=12.26U PD=12.26U
.ENDS inv_dut_079

* cell inv_dut_077
* pin Q
* pin A
* pin VDD
* pin VSS
.SUBCKT inv_dut_077 Q A VDD VSS
* device instance _1 r0 *1 0.065,6.7 pfet_05v0
XM_1 Q A VDD VDD pfet_05v0 L=1.2U W=10.8U AS=8.316P AD=8.316P PS=23.14U PD=23.14U
* device instance _2 r0 *1 0.065,-10.3 nfet_05v0
XM_2 Q A VSS VSS nfet_05v0 L=1.2U W=3.6U AS=2.628P AD=2.628P PS=8.66U PD=8.66U
.ENDS inv_dut_077

* cell inv_dut_078
* pin Q
* pin A
* pin VDD
* pin VSS
.SUBCKT inv_dut_078 Q A VDD VSS
* device instance _1 r0 *1 0.065,4 pfet_05v0
XM_1 Q A VDD VDD pfet_05v0 L=1.2U W=16.2U AS=12.474P AD=12.474P PS=33.94U
+ PD=33.94U
* device instance _2 r0 *1 0.065,-9.4 nfet_05v0
XM_2 Q A VSS VSS nfet_05v0 L=1.2U W=5.4U AS=3.942P AD=3.942P PS=12.26U PD=12.26U
.ENDS inv_dut_078

* cell inv_dut_047
* pin Q
* pin A
* pin VDD
* pin VSS
.SUBCKT inv_dut_047 Q A VDD VSS
* device instance _1 r0 *1 0.365,4 pfet_05v0
XM_1 Q A VDD VDD pfet_05v0 L=1.8U W=16.2U AS=12.474P AD=12.474P PS=33.94U
+ PD=33.94U
* device instance _2 r0 *1 0.365,-9.4 nfet_05v0
XM_2 Q A VSS VSS nfet_05v0 L=1.8U W=5.4U AS=3.942P AD=3.942P PS=12.26U PD=12.26U
.ENDS inv_dut_047

* cell inv_dut_046
* pin Q
* pin A
* pin VDD
* pin VSS
.SUBCKT inv_dut_046 Q A VDD VSS
* device instance _1 r0 *1 0.065,4 pfet_05v0
XM_1 Q A VDD VDD pfet_05v0 L=1.2U W=16.2U AS=12.474P AD=12.474P PS=33.94U
+ PD=33.94U
* device instance _2 r0 *1 0.065,-9.4 nfet_05v0
XM_2 Q A VSS VSS nfet_05v0 L=1.2U W=5.4U AS=3.942P AD=3.942P PS=12.26U PD=12.26U
.ENDS inv_dut_046

* cell inv_dut_045
* pin Q
* pin A
* pin VDD
* pin VSS
.SUBCKT inv_dut_045 Q A VDD VSS
* device instance _1 r0 *1 0.065,6.7 pfet_05v0
XM_1 Q A VDD VDD pfet_05v0 L=1.2U W=10.8U AS=8.316P AD=8.316P PS=23.14U PD=23.14U
* device instance _2 r0 *1 0.065,-10.3 nfet_05v0
XM_2 Q A VSS VSS nfet_05v0 L=1.2U W=3.6U AS=2.628P AD=2.628P PS=8.66U PD=8.66U
.ENDS inv_dut_045

* cell inv_dut_076
* pin Q
* pin A
* pin VDD
* pin VSS
.SUBCKT inv_dut_076 Q A VDD VSS
* device instance _1 r0 *1 0.065,9.4 pfet_05v0
XM_1 Q A VDD VDD pfet_05v0 L=1.2U W=5.4U AS=4.158P AD=4.158P PS=12.34U PD=12.34U
* device instance _2 r0 *1 0.065,-11.2 nfet_05v0
XM_2 Q A VSS VSS nfet_05v0 L=1.2U W=1.8U AS=1.314P AD=1.314P PS=5.06U PD=5.06U
.ENDS inv_dut_076

* cell inv_dut_044
* pin Q
* pin A
* pin VDD
* pin VSS
.SUBCKT inv_dut_044 Q A VDD VSS
* device instance _1 r0 *1 0.065,9.4 pfet_05v0
XM_1 Q A VDD VDD pfet_05v0 L=1.2U W=5.4U AS=4.158P AD=4.158P PS=12.34U PD=12.34U
* device instance _2 r0 *1 0.065,-11.2 nfet_05v0
XM_2 Q A VSS VSS nfet_05v0 L=1.2U W=1.8U AS=1.314P AD=1.314P PS=5.06U PD=5.06U
.ENDS inv_dut_044

* cell inv_dut_063
* pin Q
* pin A
* pin VDD
* pin VSS
.SUBCKT inv_dut_063 Q A VDD VSS
* device instance _1 r0 *1 -0.705,8.05 pfet_03v3
XM_1 Q A VDD VDD pfet_03v3 L=0.9U W=8.1U AS=5.265P AD=5.265P PS=17.5U PD=17.5U
* device instance _2 r0 *1 -0.705,-10.75 nfet_03v3
XM_2 Q A VSS VSS nfet_03v3 L=0.9U W=2.7U AS=1.647P AD=1.647P PS=6.62U PD=6.62U
.ENDS inv_dut_063

* cell inv_dut_062
* pin Q
* pin A
* pin VDD
* pin VSS
.SUBCKT inv_dut_062 Q A VDD VSS
* device instance _1 r0 *1 -0.855,8.05 pfet_03v3
XM_1 Q A VDD VDD pfet_03v3 L=0.6U W=8.1U AS=5.265P AD=5.265P PS=17.5U PD=17.5U
* device instance _2 r0 *1 -0.855,-10.75 nfet_03v3
XM_2 Q A VSS VSS nfet_03v3 L=0.6U W=2.7U AS=1.647P AD=1.647P PS=6.62U PD=6.62U
.ENDS inv_dut_062

* cell inv_dut_061
* pin Q
* pin A
* pin VDD
* pin VSS
.SUBCKT inv_dut_061 Q A VDD VSS
* device instance _1 r0 *1 -0.855,9.4 pfet_03v3
XM_1 Q A VDD VDD pfet_03v3 L=0.6U W=5.4U AS=3.51P AD=3.51P PS=12.1U PD=12.1U
* device instance _2 r0 *1 -0.855,-11.2 nfet_03v3
XM_2 Q A VSS VSS nfet_03v3 L=0.6U W=1.8U AS=1.098P AD=1.098P PS=4.82U PD=4.82U
.ENDS inv_dut_061

* cell inv_dut_118
* pin Q
* pin A
* pin VDD
* pin VSS
.SUBCKT inv_dut_118 Q A VDD VSS
* device instance _1 r0 *1 -1.005,10.75 pfet_03v3
XM_1 Q A VDD VDD pfet_03v3 L=0.3U W=2.7U AS=1.755P AD=1.755P PS=6.7U PD=6.7U
* device instance _2 r0 *1 -1.005,-11.65 nfet_03v3
XM_2 Q A VSS VSS nfet_03v3 L=0.3U W=0.9U AS=0.549P AD=0.549P PS=3.02U PD=3.02U
.ENDS inv_dut_118

* cell inv_dut_117
* pin Q
* pin A
* pin VDD
* pin VSS
.SUBCKT inv_dut_117 Q A VDD VSS
* device instance _1 r0 *1 -1.005,9.4 pfet_03v3
XM_1 Q A VDD VDD pfet_03v3 L=0.3U W=5.4U AS=3.51P AD=3.51P PS=12.1U PD=12.1U
* device instance _2 r0 *1 -1.005,-10.8 nfet_03v3
XM_2 Q A VSS VSS nfet_03v3 L=0.3U W=2.6U AS=1.586P AD=1.586P PS=6.42U PD=6.42U
.ENDS inv_dut_117

* cell inv_dut_116
* pin Q
* pin A
* pin VDD
* pin VSS
.SUBCKT inv_dut_116 Q A VDD VSS
* device instance _1 r0 *1 -1.005,10.3 pfet_03v3
XM_1 Q A VDD VDD pfet_03v3 L=0.3U W=3.6U AS=2.34P AD=2.34P PS=8.5U PD=8.5U
* device instance _2 r0 *1 -1.005,-11.2 nfet_03v3
XM_2 Q A VSS VSS nfet_03v3 L=0.3U W=1.8U AS=1.098P AD=1.098P PS=4.82U PD=4.82U
.ENDS inv_dut_116

* cell inv_dut_086
* pin Q
* pin A
* pin VDD
* pin VSS
.SUBCKT inv_dut_086 Q A VDD VSS
* device instance _1 r0 *1 -1.005,10.75 pfet_03v3
XM_1 Q A VDD VDD pfet_03v3 L=0.3U W=2.7U AS=1.755P AD=1.755P PS=6.7U PD=6.7U
* device instance _2 r0 *1 -1.005,-11.65 nfet_03v3
XM_2 Q A VSS VSS nfet_03v3 L=0.3U W=0.9U AS=0.549P AD=0.549P PS=3.02U PD=3.02U
.ENDS inv_dut_086

* cell inv_dut_085
* pin Q
* pin A
* pin VDD
* pin VSS
.SUBCKT inv_dut_085 Q A VDD VSS
* device instance _1 r0 *1 -1.005,9.4 pfet_03v3
XM_1 Q A VDD VDD pfet_03v3 L=0.3U W=5.4U AS=3.51P AD=3.51P PS=12.1U PD=12.1U
* device instance _2 r0 *1 -1.005,-10.8 nfet_03v3
XM_2 Q A VSS VSS nfet_03v3 L=0.3U W=2.6U AS=1.586P AD=1.586P PS=6.42U PD=6.42U
.ENDS inv_dut_085

* cell inv_dut_084
* pin Q
* pin A
* pin VDD
* pin VSS
.SUBCKT inv_dut_084 Q A VDD VSS
* device instance _1 r0 *1 -1.005,10.3 pfet_03v3
XM_1 Q A VDD VDD pfet_03v3 L=0.3U W=3.6U AS=2.34P AD=2.34P PS=8.5U PD=8.5U
* device instance _2 r0 *1 -1.005,-11.2 nfet_03v3
XM_2 Q A VSS VSS nfet_03v3 L=0.3U W=1.8U AS=1.098P AD=1.098P PS=4.82U PD=4.82U
.ENDS inv_dut_084

* cell inv_dut_102
* pin Q
* pin A
* pin VDD
* pin VSS
.SUBCKT inv_dut_102 Q A VDD VSS
* device instance _1 r0 *1 -0.235,9.4 pfet_05v0
XM_1 Q A VDD VDD pfet_05v0 L=0.6U W=5.4U AS=4.158P AD=4.158P PS=12.34U PD=12.34U
* device instance _2 r0 *1 -0.235,-11.2 nfet_05v0
XM_2 Q A VSS VSS nfet_05v0 L=0.6U W=1.8U AS=1.314P AD=1.314P PS=5.06U PD=5.06U
.ENDS inv_dut_102

* cell inv_dut_100
* pin Q
* pin A
* pin VDD
* pin VSS
.SUBCKT inv_dut_100 Q A VDD VSS
* device instance _1 r0 *1 -0.235,8.5 pfet_05v0
XM_1 Q A VDD VDD pfet_05v0 L=0.6U W=7.2U AS=5.544P AD=5.544P PS=15.94U PD=15.94U
* device instance _2 r0 *1 -0.235,-10.3 nfet_05v0
XM_2 Q A VSS VSS nfet_05v0 L=0.6U W=3.6U AS=2.628P AD=2.628P PS=8.66U PD=8.66U
.ENDS inv_dut_100

* cell inv_dut_101
* pin Q
* pin A
* pin VDD
* pin VSS
.SUBCKT inv_dut_101 Q A VDD VSS
* device instance _1 r0 *1 -0.235,6.7 pfet_05v0
XM_1 Q A VDD VDD pfet_05v0 L=0.6U W=10.8U AS=8.316P AD=8.316P PS=23.14U PD=23.14U
* device instance _2 r0 *1 -0.235,-9.4 nfet_05v0
XM_2 Q A VSS VSS nfet_05v0 L=0.6U W=5.4U AS=3.942P AD=3.942P PS=12.26U PD=12.26U
.ENDS inv_dut_101

* cell inv_dut_098
* pin Q
* pin A
* pin VDD
* pin VSS
.SUBCKT inv_dut_098 Q A VDD VSS
* device instance _1 r0 *1 -0.235,9.4 pfet_05v0
XM_1 Q A VDD VDD pfet_05v0 L=0.6U W=5.4U AS=4.158P AD=4.158P PS=12.34U PD=12.34U
* device instance _2 r0 *1 -0.235,-9.4 nfet_05v0
XM_2 Q A VSS VSS nfet_05v0 L=0.6U W=5.4U AS=3.942P AD=3.942P PS=12.26U PD=12.26U
.ENDS inv_dut_098

* cell inv_dut_097
* pin Q
* pin A
* pin VDD
* pin VSS
.SUBCKT inv_dut_097 Q A VDD VSS
* device instance _1 r0 *1 -0.235,10.3 pfet_05v0
XM_1 Q A VDD VDD pfet_05v0 L=0.6U W=3.6U AS=2.772P AD=2.772P PS=8.74U PD=8.74U
* device instance _2 r0 *1 -0.235,-10.3 nfet_05v0
XM_2 Q A VSS VSS nfet_05v0 L=0.6U W=3.6U AS=2.628P AD=2.628P PS=8.66U PD=8.66U
.ENDS inv_dut_097

* cell inv_dut_096
* pin Q
* pin A
* pin VDD
* pin VSS
.SUBCKT inv_dut_096 Q A VDD VSS
* device instance _1 r0 *1 -0.235,11.2 pfet_05v0
XM_1 Q A VDD VDD pfet_05v0 L=0.6U W=1.8U AS=1.386P AD=1.386P PS=5.14U PD=5.14U
* device instance _2 r0 *1 -0.235,-11.2 nfet_05v0
XM_2 Q A VSS VSS nfet_05v0 L=0.6U W=1.8U AS=1.314P AD=1.314P PS=5.06U PD=5.06U
.ENDS inv_dut_096

* cell inv_dut_114
* pin Q
* pin A
* pin VDD
* pin VSS
.SUBCKT inv_dut_114 Q A VDD VSS
* device instance _1 r0 *1 -1.005,10.3 pfet_03v3
XM_1 Q A VDD VDD pfet_03v3 L=0.3U W=3.6U AS=2.34P AD=2.34P PS=8.5U PD=8.5U
* device instance _2 r0 *1 -1.005,-10.3 nfet_03v3
XM_2 Q A VSS VSS nfet_03v3 L=0.3U W=3.6U AS=2.196P AD=2.196P PS=8.42U PD=8.42U
.ENDS inv_dut_114

* cell inv_dut_113
* pin Q
* pin A
* pin VDD
* pin VSS
.SUBCKT inv_dut_113 Q A VDD VSS
* device instance _1 r0 *1 -1.005,11.2 pfet_03v3
XM_1 Q A VDD VDD pfet_03v3 L=0.3U W=1.8U AS=1.17P AD=1.17P PS=4.9U PD=4.9U
* device instance _2 r0 *1 -1.005,-11.2 nfet_03v3
XM_2 Q A VSS VSS nfet_03v3 L=0.3U W=1.8U AS=1.098P AD=1.098P PS=4.82U PD=4.82U
.ENDS inv_dut_113

* cell inv_dut_082
* pin Q
* pin A
* pin VDD
* pin VSS
.SUBCKT inv_dut_082 Q A VDD VSS
* device instance _1 r0 *1 -1.005,10.3 pfet_03v3
XM_1 Q A VDD VDD pfet_03v3 L=0.3U W=3.6U AS=2.34P AD=2.34P PS=8.5U PD=8.5U
* device instance _2 r0 *1 -1.005,-10.3 nfet_03v3
XM_2 Q A VSS VSS nfet_03v3 L=0.3U W=3.6U AS=2.196P AD=2.196P PS=8.42U PD=8.42U
.ENDS inv_dut_082

* cell inv_dut_081
* pin Q
* pin A
* pin VDD
* pin VSS
.SUBCKT inv_dut_081 Q A VDD VSS
* device instance _1 r0 *1 -1.005,11.2 pfet_03v3
XM_1 Q A VDD VDD pfet_03v3 L=0.3U W=1.8U AS=1.17P AD=1.17P PS=4.9U PD=4.9U
* device instance _2 r0 *1 -1.005,-11.2 nfet_03v3
XM_2 Q A VSS VSS nfet_03v3 L=0.3U W=1.8U AS=1.098P AD=1.098P PS=4.82U PD=4.82U
.ENDS inv_dut_081

* cell inv_dut_112
* pin Q
* pin A
* pin VDD
* pin VSS
.SUBCKT inv_dut_112 Q A VDD VSS
* device instance _1 r0 *1 -1.005,11.65 pfet_03v3
XM_1 Q A VDD VDD pfet_03v3 L=0.3U W=0.9U AS=0.585P AD=0.585P PS=3.1U PD=3.1U
* device instance _2 r0 *1 -1.005,-11.65 nfet_03v3
XM_2 Q A VSS VSS nfet_03v3 L=0.3U W=0.9U AS=0.549P AD=0.549P PS=3.02U PD=3.02U
.ENDS inv_dut_112

* cell inv_dut_080
* pin Q
* pin A
* pin VDD
* pin VSS
.SUBCKT inv_dut_080 Q A VDD VSS
* device instance _1 r0 *1 -1.005,11.65 pfet_03v3
XM_1 Q A VDD VDD pfet_03v3 L=0.3U W=0.9U AS=0.585P AD=0.585P PS=3.1U PD=3.1U
* device instance _2 r0 *1 -1.005,-11.65 nfet_03v3
XM_2 Q A VSS VSS nfet_03v3 L=0.3U W=0.9U AS=0.549P AD=0.549P PS=3.02U PD=3.02U
.ENDS inv_dut_080

* cell inv_dut_050
* pin Q
* pin A
* pin VDD
* pin VSS
.SUBCKT inv_dut_050 Q A VDD VSS
* device instance _1 r0 *1 -1.005,10.3 pfet_03v3
XM_1 Q A VDD VDD pfet_03v3 L=0.3U W=3.6U AS=2.34P AD=2.34P PS=8.5U PD=8.5U
* device instance _2 r0 *1 -1.005,-10.3 nfet_03v3
XM_2 Q A VSS VSS nfet_03v3 L=0.3U W=3.6U AS=2.196P AD=2.196P PS=8.42U PD=8.42U
.ENDS inv_dut_050

* cell inv_dut_049
* pin Q
* pin A
* pin VDD
* pin VSS
.SUBCKT inv_dut_049 Q A VDD VSS
* device instance _1 r0 *1 -1.005,11.2 pfet_03v3
XM_1 Q A VDD VDD pfet_03v3 L=0.3U W=1.8U AS=1.17P AD=1.17P PS=4.9U PD=4.9U
* device instance _2 r0 *1 -1.005,-11.2 nfet_03v3
XM_2 Q A VSS VSS nfet_03v3 L=0.3U W=1.8U AS=1.098P AD=1.098P PS=4.82U PD=4.82U
.ENDS inv_dut_049

* cell inv_dut_034
* pin Q
* pin A
* pin VDD
* pin VSS
.SUBCKT inv_dut_034 Q A VDD VSS
* device instance _1 r0 *1 -0.235,9.4 pfet_05v0
XM_1 Q A VDD VDD pfet_05v0 L=0.6U W=5.4U AS=4.158P AD=4.158P PS=12.34U PD=12.34U
* device instance _2 r0 *1 -0.235,-9.4 nfet_05v0
XM_2 Q A VSS VSS nfet_05v0 L=0.6U W=5.4U AS=3.942P AD=3.942P PS=12.26U PD=12.26U
.ENDS inv_dut_034

* cell inv_dut_066
* pin Q
* pin A
* pin VDD
* pin VSS
.SUBCKT inv_dut_066 Q A VDD VSS
* device instance _1 r0 *1 -0.235,9.4 pfet_05v0
XM_1 Q A VDD VDD pfet_05v0 L=0.6U W=5.4U AS=4.158P AD=4.158P PS=12.34U PD=12.34U
* device instance _2 r0 *1 -0.235,-9.4 nfet_05v0
XM_2 Q A VSS VSS nfet_05v0 L=0.6U W=5.4U AS=3.942P AD=3.942P PS=12.26U PD=12.26U
.ENDS inv_dut_066

* cell inv_dut_065
* pin Q
* pin A
* pin VDD
* pin VSS
.SUBCKT inv_dut_065 Q A VDD VSS
* device instance _1 r0 *1 -0.235,10.3 pfet_05v0
XM_1 Q A VDD VDD pfet_05v0 L=0.6U W=3.6U AS=2.772P AD=2.772P PS=8.74U PD=8.74U
* device instance _2 r0 *1 -0.235,-10.3 nfet_05v0
XM_2 Q A VSS VSS nfet_05v0 L=0.6U W=3.6U AS=2.628P AD=2.628P PS=8.66U PD=8.66U
.ENDS inv_dut_065

* cell inv_dut_064
* pin Q
* pin A
* pin VDD
* pin VSS
.SUBCKT inv_dut_064 Q A VDD VSS
* device instance _1 r0 *1 -0.235,11.2 pfet_05v0
XM_1 Q A VDD VDD pfet_05v0 L=0.6U W=1.8U AS=1.386P AD=1.386P PS=5.14U PD=5.14U
* device instance _2 r0 *1 -0.235,-11.2 nfet_05v0
XM_2 Q A VSS VSS nfet_05v0 L=0.6U W=1.8U AS=1.314P AD=1.314P PS=5.06U PD=5.06U
.ENDS inv_dut_064

* cell inv_dut_033
* pin Q
* pin A
* pin VDD
* pin VSS
.SUBCKT inv_dut_033 Q A VDD VSS
* device instance _1 r0 *1 -0.235,10.3 pfet_05v0
XM_1 Q A VDD VDD pfet_05v0 L=0.6U W=3.6U AS=2.772P AD=2.772P PS=8.74U PD=8.74U
* device instance _2 r0 *1 -0.235,-10.3 nfet_05v0
XM_2 Q A VSS VSS nfet_05v0 L=0.6U W=3.6U AS=2.628P AD=2.628P PS=8.66U PD=8.66U
.ENDS inv_dut_033

* cell inv_dut_048
* pin Q
* pin A
* pin VDD
* pin VSS
.SUBCKT inv_dut_048 Q A VDD VSS
* device instance _1 r0 *1 -1.005,11.65 pfet_03v3
XM_1 Q A VDD VDD pfet_03v3 L=0.3U W=0.9U AS=0.585P AD=0.585P PS=3.1U PD=3.1U
* device instance _2 r0 *1 -1.005,-11.65 nfet_03v3
XM_2 Q A VSS VSS nfet_03v3 L=0.3U W=0.9U AS=0.549P AD=0.549P PS=3.02U PD=3.02U
.ENDS inv_dut_048

* cell inv_dut_032
* pin Q
* pin A
* pin VDD
* pin VSS
.SUBCKT inv_dut_032 Q A VDD VSS
* device instance _1 r0 *1 -0.235,11.2 pfet_05v0
XM_1 Q A VDD VDD pfet_05v0 L=0.6U W=1.8U AS=1.386P AD=1.386P PS=5.14U PD=5.14U
* device instance _2 r0 *1 -0.235,-11.2 nfet_05v0
XM_2 Q A VSS VSS nfet_05v0 L=0.6U W=1.8U AS=1.314P AD=1.314P PS=5.06U PD=5.06U
.ENDS inv_dut_032

* cell inv_dut_036
* pin Q
* pin A
* pin VDD
* pin VSS
.SUBCKT inv_dut_036 Q A VDD VSS
* device instance _1 r0 *1 -0.235,8.5 pfet_05v0
XM_1 Q A VDD VDD pfet_05v0 L=0.6U W=7.2U AS=5.544P AD=5.544P PS=15.94U PD=15.94U
* device instance _2 r0 *1 -0.235,-10.3 nfet_05v0
XM_2 Q A VSS VSS nfet_05v0 L=0.6U W=3.6U AS=2.628P AD=2.628P PS=8.66U PD=8.66U
.ENDS inv_dut_036

* cell inv_dut_070
* pin Q
* pin A
* pin VDD
* pin VSS
.SUBCKT inv_dut_070 Q A VDD VSS
* device instance _1 r0 *1 -0.235,9.4 pfet_05v0
XM_1 Q A VDD VDD pfet_05v0 L=0.6U W=5.4U AS=4.158P AD=4.158P PS=12.34U PD=12.34U
* device instance _2 r0 *1 -0.235,-11.2 nfet_05v0
XM_2 Q A VSS VSS nfet_05v0 L=0.6U W=1.8U AS=1.314P AD=1.314P PS=5.06U PD=5.06U
.ENDS inv_dut_070

* cell inv_dut_038
* pin Q
* pin A
* pin VDD
* pin VSS
.SUBCKT inv_dut_038 Q A VDD VSS
* device instance _1 r0 *1 -0.235,9.4 pfet_05v0
XM_1 Q A VDD VDD pfet_05v0 L=0.6U W=5.4U AS=4.158P AD=4.158P PS=12.34U PD=12.34U
* device instance _2 r0 *1 -0.235,-11.2 nfet_05v0
XM_2 Q A VSS VSS nfet_05v0 L=0.6U W=1.8U AS=1.314P AD=1.314P PS=5.06U PD=5.06U
.ENDS inv_dut_038

* cell inv_dut_069
* pin Q
* pin A
* pin VDD
* pin VSS
.SUBCKT inv_dut_069 Q A VDD VSS
* device instance _1 r0 *1 -0.235,6.7 pfet_05v0
XM_1 Q A VDD VDD pfet_05v0 L=0.6U W=10.8U AS=8.316P AD=8.316P PS=23.14U PD=23.14U
* device instance _2 r0 *1 -0.235,-9.4 nfet_05v0
XM_2 Q A VSS VSS nfet_05v0 L=0.6U W=5.4U AS=3.942P AD=3.942P PS=12.26U PD=12.26U
.ENDS inv_dut_069

* cell inv_dut_068
* pin Q
* pin A
* pin VDD
* pin VSS
.SUBCKT inv_dut_068 Q A VDD VSS
* device instance _1 r0 *1 -0.235,8.5 pfet_05v0
XM_1 Q A VDD VDD pfet_05v0 L=0.6U W=7.2U AS=5.544P AD=5.544P PS=15.94U PD=15.94U
* device instance _2 r0 *1 -0.235,-10.3 nfet_05v0
XM_2 Q A VSS VSS nfet_05v0 L=0.6U W=3.6U AS=2.628P AD=2.628P PS=8.66U PD=8.66U
.ENDS inv_dut_068

* cell inv_dut_037
* pin Q
* pin A
* pin VDD
* pin VSS
.SUBCKT inv_dut_037 Q A VDD VSS
* device instance _1 r0 *1 -0.235,6.7 pfet_05v0
XM_1 Q A VDD VDD pfet_05v0 L=0.6U W=10.8U AS=8.316P AD=8.316P PS=23.14U PD=23.14U
* device instance _2 r0 *1 -0.235,-9.4 nfet_05v0
XM_2 Q A VSS VSS nfet_05v0 L=0.6U W=5.4U AS=3.942P AD=3.942P PS=12.26U PD=12.26U
.ENDS inv_dut_037

* cell inv_dut_054
* pin Q
* pin A
* pin VDD
* pin VSS
.SUBCKT inv_dut_054 Q A VDD VSS
* device instance _1 r0 *1 -1.005,10.75 pfet_03v3
XM_1 Q A VDD VDD pfet_03v3 L=0.3U W=2.7U AS=1.755P AD=1.755P PS=6.7U PD=6.7U
* device instance _2 r0 *1 -1.005,-11.65 nfet_03v3
XM_2 Q A VSS VSS nfet_03v3 L=0.3U W=0.9U AS=0.549P AD=0.549P PS=3.02U PD=3.02U
.ENDS inv_dut_054

* cell inv_dut_053
* pin Q
* pin A
* pin VDD
* pin VSS
.SUBCKT inv_dut_053 Q A VDD VSS
* device instance _1 r0 *1 -1.005,9.4 pfet_03v3
XM_1 Q A VDD VDD pfet_03v3 L=0.3U W=5.4U AS=3.51P AD=3.51P PS=12.1U PD=12.1U
* device instance _2 r0 *1 -1.005,-10.8 nfet_03v3
XM_2 Q A VSS VSS nfet_03v3 L=0.3U W=2.6U AS=1.586P AD=1.586P PS=6.42U PD=6.42U
.ENDS inv_dut_053

* cell inv_dut_052
* pin Q
* pin A
* pin VDD
* pin VSS
.SUBCKT inv_dut_052 Q A VDD VSS
* device instance _1 r0 *1 -1.005,10.3 pfet_03v3
XM_1 Q A VDD VDD pfet_03v3 L=0.3U W=3.6U AS=2.34P AD=2.34P PS=8.5U PD=8.5U
* device instance _2 r0 *1 -1.005,-11.2 nfet_03v3
XM_2 Q A VSS VSS nfet_03v3 L=0.3U W=1.8U AS=1.098P AD=1.098P PS=4.82U PD=4.82U
.ENDS inv_dut_052

* cell inv_dut_035
* pin Q
* pin A
* pin VDD
* pin VSS
.SUBCKT inv_dut_035 Q A VDD VSS
* device instance _1 r0 *1 -0.235,10.3 pfet_05v0
XM_1 Q A VDD VDD pfet_05v0 L=0.6U W=3.6U AS=2.772P AD=2.772P PS=8.74U PD=8.74U
* device instance _2 r0 *1 -0.235,-11.2 nfet_05v0
XM_2 Q A VSS VSS nfet_05v0 L=0.6U W=1.8U AS=1.314P AD=1.314P PS=5.06U PD=5.06U
.ENDS inv_dut_035

* cell inv_dut_083
* pin Q
* pin A
* pin VDD
* pin VSS
.SUBCKT inv_dut_083 Q A VDD VSS
* device instance _1 r0 *1 -1.005,11.2 pfet_03v3
XM_1 Q A VDD VDD pfet_03v3 L=0.3U W=1.8U AS=1.17P AD=1.17P PS=4.9U PD=4.9U
* device instance _2 r0 *1 -1.005,-11.65 nfet_03v3
XM_2 Q A VSS VSS nfet_03v3 L=0.3U W=0.9U AS=0.549P AD=0.549P PS=3.02U PD=3.02U
.ENDS inv_dut_083

* cell inv_dut_067
* pin Q
* pin A
* pin VDD
* pin VSS
.SUBCKT inv_dut_067 Q A VDD VSS
* device instance _1 r0 *1 -0.235,10.3 pfet_05v0
XM_1 Q A VDD VDD pfet_05v0 L=0.6U W=3.6U AS=2.772P AD=2.772P PS=8.74U PD=8.74U
* device instance _2 r0 *1 -0.235,-11.2 nfet_05v0
XM_2 Q A VSS VSS nfet_05v0 L=0.6U W=1.8U AS=1.314P AD=1.314P PS=5.06U PD=5.06U
.ENDS inv_dut_067

* cell inv_dut_051
* pin Q
* pin A
* pin VDD
* pin VSS
.SUBCKT inv_dut_051 Q A VDD VSS
* device instance _1 r0 *1 -1.005,11.2 pfet_03v3
XM_1 Q A VDD VDD pfet_03v3 L=0.3U W=1.8U AS=1.17P AD=1.17P PS=4.9U PD=4.9U
* device instance _2 r0 *1 -1.005,-11.65 nfet_03v3
XM_2 Q A VSS VSS nfet_03v3 L=0.3U W=0.9U AS=0.549P AD=0.549P PS=3.02U PD=3.02U
.ENDS inv_dut_051

* cell inv_dut_115
* pin Q
* pin A
* pin VDD
* pin VSS
.SUBCKT inv_dut_115 Q A VDD VSS
* device instance _1 r0 *1 -1.005,11.2 pfet_03v3
XM_1 Q A VDD VDD pfet_03v3 L=0.3U W=1.8U AS=1.17P AD=1.17P PS=4.9U PD=4.9U
* device instance _2 r0 *1 -1.005,-11.65 nfet_03v3
XM_2 Q A VSS VSS nfet_03v3 L=0.3U W=0.9U AS=0.549P AD=0.549P PS=3.02U PD=3.02U
.ENDS inv_dut_115

* cell inv_dut_099
* pin Q
* pin A
* pin VDD
* pin VSS
.SUBCKT inv_dut_099 Q A VDD VSS
* device instance _1 r0 *1 -0.235,10.3 pfet_05v0
XM_1 Q A VDD VDD pfet_05v0 L=0.6U W=3.6U AS=2.772P AD=2.772P PS=8.74U PD=8.74U
* device instance _2 r0 *1 -0.235,-11.2 nfet_05v0
XM_2 Q A VSS VSS nfet_05v0 L=0.6U W=1.8U AS=1.314P AD=1.314P PS=5.06U PD=5.06U
.ENDS inv_dut_099

* cell inv_dut_004
* pin Q
* pin A
* pin VDD
* pin VSS
.SUBCKT inv_dut_004 Q A VDD VSS
* device instance _1 r0 *1 -0.235,8.5 pfet_05v0
XM_1 Q A VDD VDD pfet_05v0 L=0.6U W=7.2U AS=5.544P AD=5.544P PS=15.94U PD=15.94U
* device instance _2 r0 *1 -0.235,-10.3 nfet_05v0
XM_2 Q A VSS VSS nfet_05v0 L=0.6U W=3.6U AS=2.628P AD=2.628P PS=8.66U PD=8.66U
.ENDS inv_dut_004

* cell inv_dut_020
* pin Q
* pin A
* pin VDD
* pin VSS
.SUBCKT inv_dut_020 Q A VDD VSS
* device instance _1 r0 *1 -1.005,10.3 pfet_03v3
XM_1 Q A VDD VDD pfet_03v3 L=0.3U W=3.6U AS=2.34P AD=2.34P PS=8.5U PD=8.5U
* device instance _2 r0 *1 -1.005,-11.2 nfet_03v3
XM_2 Q A VSS VSS nfet_03v3 L=0.3U W=1.8U AS=1.098P AD=1.098P PS=4.82U PD=4.82U
.ENDS inv_dut_020

* cell inv_dut_006
* pin Q
* pin A
* pin VDD
* pin VSS
.SUBCKT inv_dut_006 Q A VDD VSS
* device instance _1 r0 *1 -0.235,9.4 pfet_05v0
XM_1 Q A VDD VDD pfet_05v0 L=0.6U W=5.4U AS=4.158P AD=4.158P PS=12.34U PD=12.34U
* device instance _2 r0 *1 -0.235,-11.2 nfet_05v0
XM_2 Q A VSS VSS nfet_05v0 L=0.6U W=1.8U AS=1.314P AD=1.314P PS=5.06U PD=5.06U
.ENDS inv_dut_006

* cell inv_dut_005
* pin Q
* pin A
* pin VDD
* pin VSS
.SUBCKT inv_dut_005 Q A VDD VSS
* device instance _1 r0 *1 -0.235,6.7 pfet_05v0
XM_1 Q A VDD VDD pfet_05v0 L=0.6U W=10.8U AS=8.316P AD=8.316P PS=23.14U PD=23.14U
* device instance _2 r0 *1 -0.235,-9.4 nfet_05v0
XM_2 Q A VSS VSS nfet_05v0 L=0.6U W=5.4U AS=3.942P AD=3.942P PS=12.26U PD=12.26U
.ENDS inv_dut_005

* cell inv_dut_022
* pin Q
* pin A
* pin VDD
* pin VSS
.SUBCKT inv_dut_022 Q A VDD VSS
* device instance _1 r0 *1 -1.005,10.75 pfet_03v3
XM_1 Q A VDD VDD pfet_03v3 L=0.3U W=2.7U AS=1.755P AD=1.755P PS=6.7U PD=6.7U
* device instance _2 r0 *1 -1.005,-11.65 nfet_03v3
XM_2 Q A VSS VSS nfet_03v3 L=0.3U W=0.9U AS=0.549P AD=0.549P PS=3.02U PD=3.02U
.ENDS inv_dut_022

* cell inv_dut_021
* pin Q
* pin A
* pin VDD
* pin VSS
.SUBCKT inv_dut_021 Q A VDD VSS
* device instance _1 r0 *1 -1.005,9.4 pfet_03v3
XM_1 Q A VDD VDD pfet_03v3 L=0.3U W=5.4U AS=3.51P AD=3.51P PS=12.1U PD=12.1U
* device instance _2 r0 *1 -1.005,-10.8 nfet_03v3
XM_2 Q A VSS VSS nfet_03v3 L=0.3U W=2.6U AS=1.586P AD=1.586P PS=6.42U PD=6.42U
.ENDS inv_dut_021

* cell inv_dut_018
* pin Q
* pin A
* pin VDD
* pin VSS
.SUBCKT inv_dut_018 Q A VDD VSS
* device instance _1 r0 *1 -1.005,10.3 pfet_03v3
XM_1 Q A VDD VDD pfet_03v3 L=0.3U W=3.6U AS=2.34P AD=2.34P PS=8.5U PD=8.5U
* device instance _2 r0 *1 -1.005,-10.3 nfet_03v3
XM_2 Q A VSS VSS nfet_03v3 L=0.3U W=3.6U AS=2.196P AD=2.196P PS=8.42U PD=8.42U
.ENDS inv_dut_018

* cell inv_dut_017
* pin Q
* pin A
* pin VDD
* pin VSS
.SUBCKT inv_dut_017 Q A VDD VSS
* device instance _1 r0 *1 -1.005,11.2 pfet_03v3
XM_1 Q A VDD VDD pfet_03v3 L=0.3U W=1.8U AS=1.17P AD=1.17P PS=4.9U PD=4.9U
* device instance _2 r0 *1 -1.005,-11.2 nfet_03v3
XM_2 Q A VSS VSS nfet_03v3 L=0.3U W=1.8U AS=1.098P AD=1.098P PS=4.82U PD=4.82U
.ENDS inv_dut_017

* cell inv_dut_002
* pin Q
* pin A
* pin VDD
* pin VSS
.SUBCKT inv_dut_002 Q A VDD VSS
* device instance _1 r0 *1 -0.235,9.4 pfet_05v0
XM_1 Q A VDD VDD pfet_05v0 L=0.6U W=5.4U AS=4.158P AD=4.158P PS=12.34U PD=12.34U
* device instance _2 r0 *1 -0.235,-9.4 nfet_05v0
XM_2 Q A VSS VSS nfet_05v0 L=0.6U W=5.4U AS=3.942P AD=3.942P PS=12.26U PD=12.26U
.ENDS inv_dut_002

* cell inv_dut_016
* pin Q
* pin A
* pin VDD
* pin VSS
.SUBCKT inv_dut_016 Q A VDD VSS
* device instance _1 r0 *1 -1.005,11.65 pfet_03v3
XM_1 Q A VDD VDD pfet_03v3 L=0.3U W=0.9U AS=0.585P AD=0.585P PS=3.1U PD=3.1U
* device instance _2 r0 *1 -1.005,-11.65 nfet_03v3
XM_2 Q A VSS VSS nfet_03v3 L=0.3U W=0.9U AS=0.549P AD=0.549P PS=3.02U PD=3.02U
.ENDS inv_dut_016

* cell inv_dut_001
* pin Q
* pin A
* pin VDD
* pin VSS
.SUBCKT inv_dut_001 Q A VDD VSS
* device instance _1 r0 *1 -0.235,10.3 pfet_05v0
XM_1 Q A VDD VDD pfet_05v0 L=0.6U W=3.6U AS=2.772P AD=2.772P PS=8.74U PD=8.74U
* device instance _2 r0 *1 -0.235,-10.3 nfet_05v0
XM_2 Q A VSS VSS nfet_05v0 L=0.6U W=3.6U AS=2.628P AD=2.628P PS=8.66U PD=8.66U
.ENDS inv_dut_001

* cell inv_dut_000
* pin Q
* pin A
* pin VDD
* pin VSS
.SUBCKT inv_dut_000 Q A VDD VSS
* device instance _1 r0 *1 -0.235,11.2 pfet_05v0
XM_1 Q A VDD VDD pfet_05v0 L=0.6U W=1.8U AS=1.386P AD=1.386P PS=5.14U PD=5.14U
* device instance _2 r0 *1 -0.235,-11.2 nfet_05v0
XM_2 Q A VSS VSS nfet_05v0 L=0.6U W=1.8U AS=1.314P AD=1.314P PS=5.06U PD=5.06U
.ENDS inv_dut_000

* cell cs_inv_5v0
* pin
* pin
* pin
* pin
* pin
* pin SUB
.SUBCKT cs_inv_5v0 n_1 n_4 n_14 n_15 n_17 SUB
* device instance _1 r0 *1 2.97,7.835 pfet_05v0
XM_1 n_1 n_15 n_2 n_1 pfet_05v0 L=1U W=16U AS=6.2P AD=5.28P PS=23.1U PD=18.64U
* device instance _5 r0 *1 9.36,7.835 pfet_05v0
XM_5 n_4 n_17 n_2 n_1 pfet_05v0 L=0.5U W=4U AS=2.16P AD=3.08P PS=5.08U PD=9.54U
* device instance _6 r0 *1 6,1.775 nfet_05v0
XM_6 SUB n_14 n_5 SUB nfet_05v0 L=1U W=4U AS=1.98P AD=1.56P PS=7.98U PD=5.56U
* device instance _8 r0 *1 9.36,1.775 nfet_05v0
XM_8 n_4 n_17 n_5 SUB nfet_05v0 L=0.6U W=2U AS=1.04P AD=1.46P PS=3.04U PD=5.46U
.ENDS cs_inv_5v0

* cell cs_inv_x4_5v0
* pin
* pin
* pin
* pin
* pin
* pin SUB
.SUBCKT cs_inv_x4_5v0 n_1 n_2 n_38 n_39 n_41 SUB
* device instance _1 r0 *1 2.97,7.835 pfet_05v0
XM_1 n_1 n_39 n_4 n_1 pfet_05v0 L=1U W=64U AS=18.68P AD=17.76P PS=77.34U
+ PD=72.88U
* device instance _17 r0 *1 27.6,7.835 pfet_05v0
XM_17 n_2 n_41 n_4 n_1 pfet_05v0 L=0.5U W=12U AS=5.36P AD=6.28P PS=14.68U
+ PD=19.14U
* device instance _20 r0 *1 15.07,1.775 nfet_05v0
XM_20 SUB n_38 n_3 SUB nfet_05v0 L=1U W=16U AS=5.1P AD=4.68P PS=23.1U PD=20.68U
* device instance _28 r0 *1 27.55,1.775 nfet_05v0
XM_28 n_2 n_41 n_3 SUB nfet_05v0 L=0.6U W=6U AS=2.64P AD=3.06P PS=8.64U PD=11.06U
.ENDS cs_inv_x4_5v0

* cell vco_bias_5v0
* pin
* pin
* pin
* pin
* pin SUB
.SUBCKT vco_bias_5v0 n_1 n_2 n_7 n_19 SUB
* device instance _1 r0 *1 2.97,7.835 pfet_05v0
XM_1 n_7 n_7 n_1 n_1 pfet_05v0 L=1U W=16U AS=6.2P AD=5.28P PS=23.1U PD=18.64U
* device instance _5 r0 *1 9.61,7.835 pfet_05v0
XM_5 n_2 n_7 n_1 n_1 pfet_05v0 L=1U W=16U AS=5.28P AD=6.2P PS=18.64U PD=23.1U
* device instance _9 r0 *1 8.29,1.775 nfet_05v0
XM_9 SUB n_19 n_7 SUB nfet_05v0 L=2U W=2U AS=1.46P AD=1.04P PS=5.46U PD=3.04U
* device instance _10 r0 *1 10.83,1.775 nfet_05v0
XM_10 n_2 n_2 SUB SUB nfet_05v0 L=1U W=4U AS=1.56P AD=1.98P PS=5.56U PD=7.98U
.ENDS vco_bias_5v0

* cell inv_dut_019
* pin Q
* pin A
* pin VDD
* pin VSS
.SUBCKT inv_dut_019 Q A VDD VSS
* device instance _1 r0 *1 -1.005,11.2 pfet_03v3
XM_1 Q A VDD VDD pfet_03v3 L=0.3U W=1.8U AS=1.17P AD=1.17P PS=4.9U PD=4.9U
* device instance _2 r0 *1 -1.005,-11.65 nfet_03v3
XM_2 Q A VSS VSS nfet_03v3 L=0.3U W=0.9U AS=0.549P AD=0.549P PS=3.02U PD=3.02U
.ENDS inv_dut_019

* cell inv_dut_003
* pin Q
* pin A
* pin VDD
* pin VSS
.SUBCKT inv_dut_003 Q A VDD VSS
* device instance _1 r0 *1 -0.235,10.3 pfet_05v0
XM_1 Q A VDD VDD pfet_05v0 L=0.6U W=3.6U AS=2.772P AD=2.772P PS=8.74U PD=8.74U
* device instance _2 r0 *1 -0.235,-11.2 nfet_05v0
XM_2 Q A VSS VSS nfet_05v0 L=0.6U W=1.8U AS=1.314P AD=1.314P PS=5.06U PD=5.06U
.ENDS inv_dut_003

* cell inv_dut_031
* pin Q
* pin A
* pin VDD
* pin VSS
.SUBCKT inv_dut_031 Q A VDD VSS
* device instance _1 r0 *1 -0.705,8.05 pfet_03v3
XM_1 Q A VDD VDD pfet_03v3 L=0.9U W=8.1U AS=5.265P AD=5.265P PS=17.5U PD=17.5U
* device instance _2 r0 *1 -0.705,-10.75 nfet_03v3
XM_2 Q A VSS VSS nfet_03v3 L=0.9U W=2.7U AS=1.647P AD=1.647P PS=6.62U PD=6.62U
.ENDS inv_dut_031

* cell inv_dut_030
* pin Q
* pin A
* pin VDD
* pin VSS
.SUBCKT inv_dut_030 Q A VDD VSS
* device instance _1 r0 *1 -0.855,8.05 pfet_03v3
XM_1 Q A VDD VDD pfet_03v3 L=0.6U W=8.1U AS=5.265P AD=5.265P PS=17.5U PD=17.5U
* device instance _2 r0 *1 -0.855,-10.75 nfet_03v3
XM_2 Q A VSS VSS nfet_03v3 L=0.6U W=2.7U AS=1.647P AD=1.647P PS=6.62U PD=6.62U
.ENDS inv_dut_030

* cell inv_dut_029
* pin Q
* pin A
* pin VDD
* pin VSS
.SUBCKT inv_dut_029 Q A VDD VSS
* device instance _1 r0 *1 -0.855,9.4 pfet_03v3
XM_1 Q A VDD VDD pfet_03v3 L=0.6U W=5.4U AS=3.51P AD=3.51P PS=12.1U PD=12.1U
* device instance _2 r0 *1 -0.855,-11.2 nfet_03v3
XM_2 Q A VSS VSS nfet_03v3 L=0.6U W=1.8U AS=1.098P AD=1.098P PS=4.82U PD=4.82U
.ENDS inv_dut_029

* cell inv_dut_028
* pin Q
* pin A
* pin VDD
* pin VSS
.SUBCKT inv_dut_028 Q A VDD VSS
* device instance _1 r0 *1 -0.855,10.75 pfet_03v3
XM_1 Q A VDD VDD pfet_03v3 L=0.6U W=2.7U AS=1.755P AD=1.755P PS=6.7U PD=6.7U
* device instance _2 r0 *1 -0.855,-11.65 nfet_03v3
XM_2 Q A VSS VSS nfet_03v3 L=0.6U W=0.9U AS=0.549P AD=0.549P PS=3.02U PD=3.02U
.ENDS inv_dut_028

* cell inv_dut_013
* pin Q
* pin A
* pin VDD
* pin VSS
.SUBCKT inv_dut_013 Q A VDD VSS
* device instance _1 r0 *1 0.065,6.7 pfet_05v0
XM_1 Q A VDD VDD pfet_05v0 L=1.2U W=10.8U AS=8.316P AD=8.316P PS=23.14U PD=23.14U
* device instance _2 r0 *1 0.065,-10.3 nfet_05v0
XM_2 Q A VSS VSS nfet_05v0 L=1.2U W=3.6U AS=2.628P AD=2.628P PS=8.66U PD=8.66U
.ENDS inv_dut_013

* cell inv_dut_015
* pin Q
* pin A
* pin VDD
* pin VSS
.SUBCKT inv_dut_015 Q A VDD VSS
* device instance _1 r0 *1 0.365,4 pfet_05v0
XM_1 Q A VDD VDD pfet_05v0 L=1.8U W=16.2U AS=12.474P AD=12.474P PS=33.94U
+ PD=33.94U
* device instance _2 r0 *1 0.365,-9.4 nfet_05v0
XM_2 Q A VSS VSS nfet_05v0 L=1.8U W=5.4U AS=3.942P AD=3.942P PS=12.26U PD=12.26U
.ENDS inv_dut_015

* cell inv_dut_014
* pin Q
* pin A
* pin VDD
* pin VSS
.SUBCKT inv_dut_014 Q A VDD VSS
* device instance _1 r0 *1 0.065,4 pfet_05v0
XM_1 Q A VDD VDD pfet_05v0 L=1.2U W=16.2U AS=12.474P AD=12.474P PS=33.94U
+ PD=33.94U
* device instance _2 r0 *1 0.065,-9.4 nfet_05v0
XM_2 Q A VSS VSS nfet_05v0 L=1.2U W=5.4U AS=3.942P AD=3.942P PS=12.26U PD=12.26U
.ENDS inv_dut_014

* cell inv_dut_012
* pin Q
* pin A
* pin VDD
* pin VSS
.SUBCKT inv_dut_012 Q A VDD VSS
* device instance _1 r0 *1 0.065,9.4 pfet_05v0
XM_1 Q A VDD VDD pfet_05v0 L=1.2U W=5.4U AS=4.158P AD=4.158P PS=12.34U PD=12.34U
* device instance _2 r0 *1 0.065,-11.2 nfet_05v0
XM_2 Q A VSS VSS nfet_05v0 L=1.2U W=1.8U AS=1.314P AD=1.314P PS=5.06U PD=5.06U
.ENDS inv_dut_012

* cell inv_dut_011
* pin Q
* pin A
* pin VDD
* pin VSS
.SUBCKT inv_dut_011 Q A VDD VSS
* device instance _1 r0 *1 0.065,6.7 pfet_05v0
XM_1 Q A VDD VDD pfet_05v0 L=1.2U W=10.8U AS=8.316P AD=8.316P PS=23.14U PD=23.14U
* device instance _2 r0 *1 0.065,-9.4 nfet_05v0
XM_2 Q A VSS VSS nfet_05v0 L=1.2U W=5.4U AS=3.942P AD=3.942P PS=12.26U PD=12.26U
.ENDS inv_dut_011

* cell inv_dut_010
* pin Q
* pin A
* pin VDD
* pin VSS
.SUBCKT inv_dut_010 Q A VDD VSS
* device instance _1 r0 *1 0.065,8.5 pfet_05v0
XM_1 Q A VDD VDD pfet_05v0 L=1.2U W=7.2U AS=5.544P AD=5.544P PS=15.94U PD=15.94U
* device instance _2 r0 *1 0.065,-10.3 nfet_05v0
XM_2 Q A VSS VSS nfet_05v0 L=1.2U W=3.6U AS=2.628P AD=2.628P PS=8.66U PD=8.66U
.ENDS inv_dut_010

* cell inv_dut_009
* pin Q
* pin A
* pin VDD
* pin VSS
.SUBCKT inv_dut_009 Q A VDD VSS
* device instance _1 r0 *1 0.065,10.3 pfet_05v0
XM_1 Q A VDD VDD pfet_05v0 L=1.2U W=3.6U AS=2.772P AD=2.772P PS=8.74U PD=8.74U
* device instance _2 r0 *1 0.065,-11.2 nfet_05v0
XM_2 Q A VSS VSS nfet_05v0 L=1.2U W=1.8U AS=1.314P AD=1.314P PS=5.06U PD=5.06U
.ENDS inv_dut_009

* cell inv_dut_008
* pin Q
* pin A
* pin VDD
* pin VSS
.SUBCKT inv_dut_008 Q A VDD VSS
* device instance _1 r0 *1 -0.235,4 pfet_05v0
XM_1 Q A VDD VDD pfet_05v0 L=0.6U W=16.2U AS=12.474P AD=12.474P PS=33.94U
+ PD=33.94U
* device instance _2 r0 *1 -0.235,-9.4 nfet_05v0
XM_2 Q A VSS VSS nfet_05v0 L=0.6U W=5.4U AS=3.942P AD=3.942P PS=12.26U PD=12.26U
.ENDS inv_dut_008

* cell inv_dut_027
* pin Q
* pin A
* pin VDD
* pin VSS
.SUBCKT inv_dut_027 Q A VDD VSS
* device instance _1 r0 *1 -0.855,9.4 pfet_03v3
XM_1 Q A VDD VDD pfet_03v3 L=0.6U W=5.4U AS=3.51P AD=3.51P PS=12.1U PD=12.1U
* device instance _2 r0 *1 -0.855,-10.75 nfet_03v3
XM_2 Q A VSS VSS nfet_03v3 L=0.6U W=2.7U AS=1.647P AD=1.647P PS=6.62U PD=6.62U
.ENDS inv_dut_027

* cell inv_dut_026
* pin Q
* pin A
* pin VDD
* pin VSS
.SUBCKT inv_dut_026 Q A VDD VSS
* device instance _1 r0 *1 -0.855,10.3 pfet_03v3
XM_1 Q A VDD VDD pfet_03v3 L=0.6U W=3.6U AS=2.34P AD=2.34P PS=8.5U PD=8.5U
* device instance _2 r0 *1 -0.855,-11.2 nfet_03v3
XM_2 Q A VSS VSS nfet_03v3 L=0.6U W=1.8U AS=1.098P AD=1.098P PS=4.82U PD=4.82U
.ENDS inv_dut_026

* cell inv_dut_025
* pin Q
* pin A
* pin VDD
* pin VSS
.SUBCKT inv_dut_025 Q A VDD VSS
* device instance _1 r0 *1 -0.855,11.2 pfet_03v3
XM_1 Q A VDD VDD pfet_03v3 L=0.6U W=1.8U AS=1.17P AD=1.17P PS=4.9U PD=4.9U
* device instance _2 r0 *1 -0.855,-11.65 nfet_03v3
XM_2 Q A VSS VSS nfet_03v3 L=0.6U W=0.9U AS=0.549P AD=0.549P PS=3.02U PD=3.02U
.ENDS inv_dut_025

* cell inv_dut_024
* pin Q
* pin A
* pin VDD
* pin VSS
.SUBCKT inv_dut_024 Q A VDD VSS
* device instance _1 r0 *1 -1.005,8.05 pfet_03v3
XM_1 Q A VDD VDD pfet_03v3 L=0.3U W=8.1U AS=5.265P AD=5.265P PS=17.5U PD=17.5U
* device instance _2 r0 *1 -1.005,-10.75 nfet_03v3
XM_2 Q A VSS VSS nfet_03v3 L=0.3U W=2.7U AS=1.647P AD=1.647P PS=6.62U PD=6.62U
.ENDS inv_dut_024

* cell inv_dut_119
* pin Q
* pin A
* pin VDD
* pin VSS
.SUBCKT inv_dut_119 Q A VDD VSS
* device instance _1 r0 *1 -1.005,9.4 pfet_03v3
XM_1 Q A VDD VDD pfet_03v3 L=0.3U W=5.4U AS=3.51P AD=3.51P PS=12.1U PD=12.1U
* device instance _2 r0 *1 -1.005,-11.2 nfet_03v3
XM_2 Q A VSS VSS nfet_03v3 L=0.3U W=1.8U AS=1.098P AD=1.098P PS=4.82U PD=4.82U
.ENDS inv_dut_119

* cell inv_dut_103
* pin Q
* pin A
* pin VDD
* pin VSS
.SUBCKT inv_dut_103 Q A VDD VSS
* device instance _1 r0 *1 -0.235,6.7 pfet_05v0
XM_1 Q A VDD VDD pfet_05v0 L=0.6U W=10.8U AS=8.316P AD=8.316P PS=23.14U PD=23.14U
* device instance _2 r0 *1 -0.235,-10.3 nfet_05v0
XM_2 Q A VSS VSS nfet_05v0 L=0.6U W=3.6U AS=2.628P AD=2.628P PS=8.66U PD=8.66U
.ENDS inv_dut_103

* cell inv_dut_087
* pin Q
* pin A
* pin VDD
* pin VSS
.SUBCKT inv_dut_087 Q A VDD VSS
* device instance _1 r0 *1 -1.005,9.4 pfet_03v3
XM_1 Q A VDD VDD pfet_03v3 L=0.3U W=5.4U AS=3.51P AD=3.51P PS=12.1U PD=12.1U
* device instance _2 r0 *1 -1.005,-11.2 nfet_03v3
XM_2 Q A VSS VSS nfet_03v3 L=0.3U W=1.8U AS=1.098P AD=1.098P PS=4.82U PD=4.82U
.ENDS inv_dut_087

* cell inv_dut_071
* pin Q
* pin A
* pin VDD
* pin VSS
.SUBCKT inv_dut_071 Q A VDD VSS
* device instance _1 r0 *1 -0.235,6.7 pfet_05v0
XM_1 Q A VDD VDD pfet_05v0 L=0.6U W=10.8U AS=8.316P AD=8.316P PS=23.14U PD=23.14U
* device instance _2 r0 *1 -0.235,-10.3 nfet_05v0
XM_2 Q A VSS VSS nfet_05v0 L=0.6U W=3.6U AS=2.628P AD=2.628P PS=8.66U PD=8.66U
.ENDS inv_dut_071

* cell inv_dut_055
* pin Q
* pin A
* pin VDD
* pin VSS
.SUBCKT inv_dut_055 Q A VDD VSS
* device instance _1 r0 *1 -1.005,9.4 pfet_03v3
XM_1 Q A VDD VDD pfet_03v3 L=0.3U W=5.4U AS=3.51P AD=3.51P PS=12.1U PD=12.1U
* device instance _2 r0 *1 -1.005,-11.2 nfet_03v3
XM_2 Q A VSS VSS nfet_03v3 L=0.3U W=1.8U AS=1.098P AD=1.098P PS=4.82U PD=4.82U
.ENDS inv_dut_055

* cell inv_dut_039
* pin Q
* pin A
* pin VDD
* pin VSS
.SUBCKT inv_dut_039 Q A VDD VSS
* device instance _1 r0 *1 -0.235,6.7 pfet_05v0
XM_1 Q A VDD VDD pfet_05v0 L=0.6U W=10.8U AS=8.316P AD=8.316P PS=23.14U PD=23.14U
* device instance _2 r0 *1 -0.235,-10.3 nfet_05v0
XM_2 Q A VSS VSS nfet_05v0 L=0.6U W=3.6U AS=2.628P AD=2.628P PS=8.66U PD=8.66U
.ENDS inv_dut_039

* cell inv_dut_023
* pin Q
* pin A
* pin VDD
* pin VSS
.SUBCKT inv_dut_023 Q A VDD VSS
* device instance _1 r0 *1 -1.005,9.4 pfet_03v3
XM_1 Q A VDD VDD pfet_03v3 L=0.3U W=5.4U AS=3.51P AD=3.51P PS=12.1U PD=12.1U
* device instance _2 r0 *1 -1.005,-11.2 nfet_03v3
XM_2 Q A VSS VSS nfet_03v3 L=0.3U W=1.8U AS=1.098P AD=1.098P PS=4.82U PD=4.82U
.ENDS inv_dut_023

* cell inv_dut_007
* pin Q
* pin A
* pin VDD
* pin VSS
.SUBCKT inv_dut_007 Q A VDD VSS
* device instance _1 r0 *1 -0.235,6.7 pfet_05v0
XM_1 Q A VDD VDD pfet_05v0 L=0.6U W=10.8U AS=8.316P AD=8.316P PS=23.14U PD=23.14U
* device instance _2 r0 *1 -0.235,-10.3 nfet_05v0
XM_2 Q A VSS VSS nfet_05v0 L=0.6U W=3.6U AS=2.628P AD=2.628P PS=8.66U PD=8.66U
.ENDS inv_dut_007
