* Extracted by KLayout with GF180MCU LVS runset on : 18/10/2026 00:11

* cell tgate_5v0_in
* pin DUT_IN
* pin IN
* pin SEL
* pin VDD_DEC
* pin VSS
.SUBCKT tgate_5v0_in DUT_IN IN SEL VDD_DEC VSS
* device instance $1 r0 *1 -3.255,-0.74 diode_nw2ps_06v0
D$1 VSS SEL diode_nw2ps_06v0 A=0.432P P=3.12U
* device instance $2 r180 *1 -0.57,3.82 pfet_05v0
M$2 VDD_DEC SEL \$8 VDD_DEC pfet_05v0 L=0.5U W=2U AS=1.54P AD=1.54P PS=5.54U
+ PD=5.54U
* device instance $3 r0 *1 6.485,2.825 nfet_05v0
M$3 VSS \$8 DUT_IN VSS nfet_05v0 L=0.6U W=0.42U AS=0.315P AD=0.315P PS=2.34U
+ PD=2.34U
* device instance $4 r0 *1 6.485,4.74 nfet_05v0
M$4 VSS SEL \$8 VSS nfet_05v0 L=0.6U W=1U AS=0.73P AD=0.73P PS=3.46U PD=3.46U
* device instance $5 r90 *1 6.455,0.745 nfet_05v0
M$5 IN SEL DUT_IN VSS nfet_05v0 L=0.6U W=2U AS=1.46P AD=1.46P PS=5.46U PD=5.46U
* device instance $6 r90 *1 2.945,0.715 pfet_05v0
M$6 IN \$8 DUT_IN VDD_DEC pfet_05v0 L=0.5U W=6U AS=3.14P AD=3.14P PS=11.14U
+ PD=11.14U
.ENDS tgate_5v0_in
