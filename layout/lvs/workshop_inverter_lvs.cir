* Extracted by KLayout with GF180MCU LVS runset on : 23/10/2026 05:28

.SUBCKT workshop_inverter
X$1 SEL$113 SEL$116 SEL$118 SEL$122 SEL$125 SEL$127 SEL$98 SEL$102 SEL$104
+ SEL$107 SEL$110 SEL$80 SEL$81 SEL$85 SEL$89 SEL$91 SEL$92 SEL$64 SEL$70
+ SEL$71 SEL$74 SEL$75 SEL$77 SEL$48 SEL$50 SEL$52 SEL$53 SEL$54 SEL$55 SEL$56
+ SEL$57 SEL$58 SEL$59 SEL$60 SEL$61 SEL$62 SEL$63 SEL$32 SEL$33 SEL$34 SEL$35
+ SEL$36 SEL$37 SEL$38 SEL$39 SEL$40 SEL$41 SEL$42 SEL$43 SEL$44 SEL$45 SEL$46
+ SEL$47 SEL$16 SEL$17 SEL$18 SEL$19 SEL$20 SEL$21 SEL$22 SEL$23 SEL$24 SEL$25
+ SEL$26 SEL$27 SEL$28 SEL$29 SEL$30 SEL$31 SEL SEL$1 SEL$2 SEL$4 SEL$5 SEL$6
+ SEL$7 SEL$8 SEL$9 SEL$10 SEL$13 SEL$14 SEL$15 SEL$123 SEL$112 SEL$115 SEL$117
+ VDD_DEC SEL$99 SEL$126 SEL$108 SEL$103 SEL$97 SEL$101 SEL$82 SEL$111 SEL$109
+ SEL$87 SEL$84 SEL$83 SEL$94 SEL$90 SEL$88 SEL$69 SEL$67 SEL$66 SEL$73 SEL$68
+ SEL$78 SEL$76 SEL$79 SEL$49 SEL$51 SEL$11 SEL$12 SEL$100 SEL$105 SEL$86
+ SEL$93 SEL$120 SEL$72 SEL$124 SEL$65 SEL$121 SEL$106 SEL$95 SEL$119 SEL$96
+ SEL$114 SEL$3 D[0] D[1] D[2] D[4] D[5] D[3] D[6] VSS decoder_7to128
X$2 DUT_OUT DUT_IN$10 VDD_INV VSS inv_dut_112
X$3 DUT_OUT$1 DUT_IN VDD_INV VSS inv_dut_113
X$4 DUT_OUT$2 DUT_IN$1 VDD_INV VSS inv_dut_114
X$5 DUT_OUT$3 DUT_IN$11 VDD_INV VSS inv_dut_115
X$6 DUT_OUT$4 DUT_IN$2 VDD_INV VSS inv_dut_116
X$7 DUT_OUT$5 DUT_IN$3 VDD_INV VSS inv_dut_117
X$8 DUT_OUT$6 DUT_IN$12 VDD_INV VSS inv_dut_118
X$9 DUT_OUT$7 DUT_IN$4 VDD_INV VSS inv_dut_119
X$10 DUT_OUT$8 DUT_IN$13 VDD_INV VSS inv_dut_120
X$11 DUT_OUT$9 DUT_IN$5 VDD_INV VSS inv_dut_121
X$12 DUT_OUT$10 DUT_IN$6 VDD_INV VSS inv_dut_122
X$13 DUT_OUT$11 DUT_IN$7 VDD_INV VSS inv_dut_123
X$14 DUT_OUT$12 DUT_IN$14 VDD_INV VSS inv_dut_124
X$15 DUT_OUT$13 DUT_IN$8 VDD_INV VSS inv_dut_125
X$16 DUT_OUT$14 DUT_IN$9 VDD_INV VSS inv_dut_126
X$17 DUT_OUT$15 DUT_IN$15 VDD_INV VSS inv_dut_127
X$18 DUT_OUT$16 DUT_IN$16 VDD_INV VSS inv_dut_096
X$19 DUT_OUT$17 DUT_IN$17 VDD_INV VSS inv_dut_097
X$20 DUT_OUT$18 DUT_IN$18 VDD_INV VSS inv_dut_098
X$21 DUT_OUT$19 DUT_IN$19 VDD_INV VSS inv_dut_099
X$22 DUT_OUT$20 DUT_IN$20 VDD_INV VSS inv_dut_100
X$23 DUT_OUT$21 DUT_IN$21 VDD_INV VSS inv_dut_101
X$24 DUT_OUT$22 DUT_IN$22 VDD_INV VSS inv_dut_102
X$25 DUT_OUT$23 DUT_IN$23 VDD_INV VSS inv_dut_103
X$26 DUT_OUT$24 DUT_IN$24 VDD_INV VSS inv_dut_104
X$27 DUT_OUT$25 DUT_IN$25 VDD_INV VSS inv_dut_105
X$28 DUT_OUT$26 DUT_IN$26 VDD_INV VSS inv_dut_106
X$29 DUT_OUT$27 DUT_IN$27 VDD_INV VSS inv_dut_107
X$30 DUT_OUT$28 DUT_IN$28 VDD_INV VSS inv_dut_108
X$31 DUT_OUT$29 DUT_IN$29 VDD_INV VSS inv_dut_109
X$32 DUT_OUT$30 DUT_IN$30 VDD_INV VSS inv_dut_110
X$33 DUT_OUT$31 DUT_IN$31 VDD_INV VSS inv_dut_111
X$34 DUT_OUT$32 DUT_IN$32 VDD_INV VSS inv_dut_080
X$35 DUT_OUT$33 DUT_IN$33 VDD_INV VSS inv_dut_081
X$36 DUT_OUT$34 DUT_IN$34 VDD_INV VSS inv_dut_082
X$37 DUT_OUT$35 DUT_IN$35 VDD_INV VSS inv_dut_083
X$38 DUT_OUT$36 DUT_IN$36 VDD_INV VSS inv_dut_084
X$39 DUT_OUT$37 DUT_IN$37 VDD_INV VSS inv_dut_085
X$40 DUT_OUT$38 DUT_IN$38 VDD_INV VSS inv_dut_086
X$41 DUT_OUT$39 DUT_IN$39 VDD_INV VSS inv_dut_087
X$42 DUT_OUT$40 DUT_IN$40 VDD_INV VSS inv_dut_088
X$43 DUT_OUT$41 DUT_IN$41 VDD_INV VSS inv_dut_089
X$44 DUT_OUT$42 DUT_IN$42 VDD_INV VSS inv_dut_090
X$45 DUT_OUT$43 DUT_IN$43 VDD_INV VSS inv_dut_091
X$46 DUT_OUT$44 DUT_IN$44 VDD_INV VSS inv_dut_092
X$47 DUT_OUT$45 DUT_IN$45 VDD_INV VSS inv_dut_093
X$48 DUT_OUT$46 DUT_IN$46 VDD_INV VSS inv_dut_094
X$49 DUT_OUT$47 DUT_IN$47 VDD_INV VSS inv_dut_095
X$50 DUT_OUT$48 DUT_IN$48 VDD_INV VSS inv_dut_064
X$51 DUT_OUT$49 DUT_IN$49 VDD_INV VSS inv_dut_065
X$52 DUT_OUT$50 DUT_IN$50 VDD_INV VSS inv_dut_066
X$53 DUT_OUT$51 DUT_IN$51 VDD_INV VSS inv_dut_067
X$54 DUT_OUT$52 DUT_IN$52 VDD_INV VSS inv_dut_068
X$55 DUT_OUT$53 DUT_IN$53 VDD_INV VSS inv_dut_069
X$56 DUT_OUT$54 DUT_IN$54 VDD_INV VSS inv_dut_070
X$57 DUT_OUT$55 DUT_IN$55 VDD_INV VSS inv_dut_071
X$58 DUT_OUT$56 DUT_IN$56 VDD_INV VSS inv_dut_072
X$59 DUT_OUT$57 DUT_IN$57 VDD_INV VSS inv_dut_073
X$60 DUT_OUT$58 DUT_IN$58 VDD_INV VSS inv_dut_074
X$61 DUT_OUT$59 DUT_IN$59 VDD_INV VSS inv_dut_075
X$62 DUT_OUT$60 DUT_IN$60 VDD_INV VSS inv_dut_076
X$63 DUT_OUT$61 DUT_IN$61 VDD_INV VSS inv_dut_077
X$64 DUT_OUT$62 DUT_IN$62 VDD_INV VSS inv_dut_078
X$65 DUT_OUT$63 DUT_IN$63 VDD_INV VSS inv_dut_079
X$66 DUT_OUT$64 DUT_IN$64 VDD_INV VSS inv_dut_048
X$67 DUT_OUT$65 DUT_IN$65 VDD_INV VSS inv_dut_049
X$68 DUT_OUT$66 DUT_IN$66 VDD_INV VSS inv_dut_050
X$69 DUT_OUT$67 DUT_IN$67 VDD_INV VSS inv_dut_051
X$70 DUT_OUT$68 DUT_IN$68 VDD_INV VSS inv_dut_052
X$71 DUT_OUT$69 DUT_IN$69 VDD_INV VSS inv_dut_053
X$72 DUT_OUT$70 DUT_IN$70 VDD_INV VSS inv_dut_054
X$73 DUT_OUT$71 DUT_IN$71 VDD_INV VSS inv_dut_055
X$74 DUT_OUT$72 DUT_IN$72 VDD_INV VSS inv_dut_056
X$75 DUT_OUT$73 DUT_IN$73 VDD_INV VSS inv_dut_057
X$76 DUT_OUT$74 DUT_IN$74 VDD_INV VSS inv_dut_058
X$77 DUT_OUT$75 DUT_IN$75 VDD_INV VSS inv_dut_059
X$78 DUT_OUT$76 DUT_IN$76 VDD_INV VSS inv_dut_060
X$79 DUT_OUT$77 DUT_IN$77 VDD_INV VSS inv_dut_061
X$80 DUT_OUT$78 DUT_IN$78 VDD_INV VSS inv_dut_062
X$81 DUT_OUT$79 DUT_IN$79 VDD_INV VSS inv_dut_063
X$82 DUT_OUT$80 DUT_IN$80 VDD_INV VSS inv_dut_032
X$83 DUT_OUT$81 DUT_IN$81 VDD_INV VSS inv_dut_033
X$84 DUT_OUT$82 DUT_IN$82 VDD_INV VSS inv_dut_034
X$85 DUT_OUT$83 DUT_IN$83 VDD_INV VSS inv_dut_035
X$86 DUT_OUT$84 DUT_IN$84 VDD_INV VSS inv_dut_036
X$87 DUT_OUT$85 DUT_IN$85 VDD_INV VSS inv_dut_037
X$88 DUT_OUT$86 DUT_IN$86 VDD_INV VSS inv_dut_038
X$89 DUT_OUT$87 DUT_IN$87 VDD_INV VSS inv_dut_039
X$90 DUT_OUT$88 DUT_IN$88 VDD_INV VSS inv_dut_040
X$91 DUT_OUT$89 DUT_IN$89 VDD_INV VSS inv_dut_041
X$92 DUT_OUT$90 DUT_IN$90 VDD_INV VSS inv_dut_042
X$93 DUT_OUT$91 DUT_IN$91 VDD_INV VSS inv_dut_043
X$94 DUT_OUT$92 DUT_IN$92 VDD_INV VSS inv_dut_044
X$95 DUT_OUT$93 DUT_IN$93 VDD_INV VSS inv_dut_045
X$96 DUT_OUT$94 DUT_IN$94 VDD_INV VSS inv_dut_046
X$97 DUT_OUT$95 DUT_IN$95 VDD_INV VSS inv_dut_047
X$98 DUT_OUT$96 DUT_IN$96 VDD_INV VSS inv_dut_016
X$99 DUT_OUT$97 DUT_IN$97 VDD_INV VSS inv_dut_017
X$100 DUT_OUT$98 DUT_IN$98 VDD_INV VSS inv_dut_018
X$101 DUT_OUT$99 DUT_IN$99 VDD_INV VSS inv_dut_019
X$102 DUT_OUT$100 DUT_IN$100 VDD_INV VSS inv_dut_020
X$103 DUT_OUT$101 DUT_IN$101 VDD_INV VSS inv_dut_021
X$104 DUT_OUT$102 DUT_IN$102 VDD_INV VSS inv_dut_022
X$105 DUT_OUT$103 DUT_IN$103 VDD_INV VSS inv_dut_023
X$106 DUT_OUT$104 DUT_IN$104 VDD_INV VSS inv_dut_024
X$107 DUT_OUT$105 DUT_IN$105 VDD_INV VSS inv_dut_025
X$108 DUT_OUT$106 DUT_IN$106 VDD_INV VSS inv_dut_026
X$109 DUT_OUT$107 DUT_IN$107 VDD_INV VSS inv_dut_027
X$110 DUT_OUT$108 DUT_IN$108 VDD_INV VSS inv_dut_028
X$111 DUT_OUT$109 DUT_IN$109 VDD_INV VSS inv_dut_029
X$112 DUT_OUT$110 DUT_IN$110 VDD_INV VSS inv_dut_030
X$113 DUT_OUT$111 DUT_IN$111 VDD_INV VSS inv_dut_031
X$114 DUT_OUT$112 DUT_IN$112 VDD_INV VSS inv_dut_000
X$115 DUT_OUT$113 DUT_IN$113 VDD_INV VSS inv_dut_001
X$116 DUT_OUT$114 DUT_IN$114 VDD_INV VSS inv_dut_002
X$117 DUT_OUT$115 DUT_IN$115 VDD_INV VSS inv_dut_003
X$118 DUT_OUT$116 DUT_IN$116 VDD_INV VSS inv_dut_004
X$119 DUT_OUT$117 DUT_IN$117 VDD_INV VSS inv_dut_005
X$120 DUT_OUT$118 DUT_IN$118 VDD_INV VSS inv_dut_006
X$121 DUT_OUT$119 DUT_IN$119 VDD_INV VSS inv_dut_007
X$122 DUT_OUT$120 DUT_IN$120 VDD_INV VSS inv_dut_008
X$123 DUT_OUT$121 DUT_IN$121 VDD_INV VSS inv_dut_009
X$124 DUT_OUT$122 DUT_IN$122 VDD_INV VSS inv_dut_010
X$125 DUT_OUT$123 DUT_IN$123 VDD_INV VSS inv_dut_011
X$126 DUT_OUT$124 DUT_IN$124 VDD_INV VSS inv_dut_012
X$127 DUT_OUT$125 DUT_IN$125 VDD_INV VSS inv_dut_013
X$128 DUT_OUT$126 DUT_IN$126 VDD_INV VSS inv_dut_014
X$129 DUT_OUT$127 DUT_IN$127 VDD_INV VSS inv_dut_015
M$1 DUT_OUT|IN|INV_IN|OUT \$53 DUT_IN$10 VDD_DEC pfet_05v0 L=0.5U W=6U AS=3.14P
+ AD=3.14P PS=11.14U PD=11.14U
M$4 DUT_OUT|IN|INV_IN|OUT \$54 DUT_IN VDD_DEC pfet_05v0 L=0.5U W=6U AS=3.14P
+ AD=3.14P PS=11.14U PD=11.14U
M$7 DUT_OUT|IN|INV_IN|OUT \$55 DUT_IN$1 VDD_DEC pfet_05v0 L=0.5U W=6U AS=3.14P
+ AD=3.14P PS=11.14U PD=11.14U
M$10 DUT_OUT|IN|INV_IN|OUT \$56 DUT_IN$11 VDD_DEC pfet_05v0 L=0.5U W=6U
+ AS=3.14P AD=3.14P PS=11.14U PD=11.14U
M$13 DUT_OUT|IN|INV_IN|OUT \$57 DUT_IN$2 VDD_DEC pfet_05v0 L=0.5U W=6U AS=3.14P
+ AD=3.14P PS=11.14U PD=11.14U
M$16 DUT_OUT|IN|INV_IN|OUT \$59 DUT_IN$12 VDD_DEC pfet_05v0 L=0.5U W=6U
+ AS=3.14P AD=3.14P PS=11.14U PD=11.14U
M$19 DUT_OUT|IN|INV_IN|OUT \$60 DUT_IN$4 VDD_DEC pfet_05v0 L=0.5U W=6U AS=3.14P
+ AD=3.14P PS=11.14U PD=11.14U
M$22 DUT_OUT|IN|INV_IN|OUT \$61 DUT_IN$13 VDD_DEC pfet_05v0 L=0.5U W=6U
+ AS=3.14P AD=3.14P PS=11.14U PD=11.14U
M$25 DUT_OUT|IN|INV_IN|OUT \$62 DUT_IN$5 VDD_DEC pfet_05v0 L=0.5U W=6U AS=3.14P
+ AD=3.14P PS=11.14U PD=11.14U
M$28 DUT_OUT|IN|INV_IN|OUT \$63 DUT_IN$6 VDD_DEC pfet_05v0 L=0.5U W=6U AS=3.14P
+ AD=3.14P PS=11.14U PD=11.14U
M$31 DUT_OUT|IN|INV_IN|OUT \$64 DUT_IN$7 VDD_DEC pfet_05v0 L=0.5U W=6U AS=3.14P
+ AD=3.14P PS=11.14U PD=11.14U
M$34 DUT_OUT|IN|INV_IN|OUT \$65 DUT_IN$14 VDD_DEC pfet_05v0 L=0.5U W=6U
+ AS=3.14P AD=3.14P PS=11.14U PD=11.14U
M$37 DUT_OUT|IN|INV_IN|OUT \$66 DUT_IN$8 VDD_DEC pfet_05v0 L=0.5U W=6U AS=3.14P
+ AD=3.14P PS=11.14U PD=11.14U
M$40 DUT_OUT|IN|INV_IN|OUT \$68 DUT_IN$15 VDD_DEC pfet_05v0 L=0.5U W=6U
+ AS=3.14P AD=3.14P PS=11.14U PD=11.14U
M$43 DUT_OUT|IN|INV_IN|OUT \$58 DUT_IN$3 VDD_DEC pfet_05v0 L=0.5U W=6U AS=3.14P
+ AD=3.14P PS=11.14U PD=11.14U
M$46 DUT_OUT|IN|INV_IN|OUT \$67 DUT_IN$9 VDD_DEC pfet_05v0 L=0.5U W=6U AS=3.14P
+ AD=3.14P PS=11.14U PD=11.14U
M$49 \$53 SEL VDD_DEC VDD_DEC pfet_05v0 L=0.5U W=2U AS=1.54P AD=1.54P PS=5.54U
+ PD=5.54U
M$50 \$54 SEL$1 VDD_DEC VDD_DEC pfet_05v0 L=0.5U W=2U AS=1.54P AD=1.54P
+ PS=5.54U PD=5.54U
M$51 \$55 SEL$2 VDD_DEC VDD_DEC pfet_05v0 L=0.5U W=2U AS=1.54P AD=1.54P
+ PS=5.54U PD=5.54U
M$52 \$56 SEL$3 VDD_DEC VDD_DEC pfet_05v0 L=0.5U W=2U AS=1.54P AD=1.54P
+ PS=5.54U PD=5.54U
M$53 \$57 SEL$4 VDD_DEC VDD_DEC pfet_05v0 L=0.5U W=2U AS=1.54P AD=1.54P
+ PS=5.54U PD=5.54U
M$54 \$58 SEL$5 VDD_DEC VDD_DEC pfet_05v0 L=0.5U W=2U AS=1.54P AD=1.54P
+ PS=5.54U PD=5.54U
M$55 \$59 SEL$6 VDD_DEC VDD_DEC pfet_05v0 L=0.5U W=2U AS=1.54P AD=1.54P
+ PS=5.54U PD=5.54U
M$56 \$60 SEL$7 VDD_DEC VDD_DEC pfet_05v0 L=0.5U W=2U AS=1.54P AD=1.54P
+ PS=5.54U PD=5.54U
M$57 \$61 SEL$8 VDD_DEC VDD_DEC pfet_05v0 L=0.5U W=2U AS=1.54P AD=1.54P
+ PS=5.54U PD=5.54U
M$58 \$62 SEL$9 VDD_DEC VDD_DEC pfet_05v0 L=0.5U W=2U AS=1.54P AD=1.54P
+ PS=5.54U PD=5.54U
M$59 \$63 SEL$10 VDD_DEC VDD_DEC pfet_05v0 L=0.5U W=2U AS=1.54P AD=1.54P
+ PS=5.54U PD=5.54U
M$60 \$64 SEL$11 VDD_DEC VDD_DEC pfet_05v0 L=0.5U W=2U AS=1.54P AD=1.54P
+ PS=5.54U PD=5.54U
M$61 \$65 SEL$12 VDD_DEC VDD_DEC pfet_05v0 L=0.5U W=2U AS=1.54P AD=1.54P
+ PS=5.54U PD=5.54U
M$62 \$66 SEL$13 VDD_DEC VDD_DEC pfet_05v0 L=0.5U W=2U AS=1.54P AD=1.54P
+ PS=5.54U PD=5.54U
M$63 \$67 SEL$14 VDD_DEC VDD_DEC pfet_05v0 L=0.5U W=2U AS=1.54P AD=1.54P
+ PS=5.54U PD=5.54U
M$64 \$68 SEL$15 VDD_DEC VDD_DEC pfet_05v0 L=0.5U W=2U AS=1.54P AD=1.54P
+ PS=5.54U PD=5.54U
M$65 DUT_OUT \$87 IN|INV_OUT|OUT VDD_DEC pfet_05v0 L=0.5U W=6U AS=3.14P
+ AD=3.14P PS=11.14U PD=11.14U
M$68 DUT_OUT$1 \$88 IN|INV_OUT|OUT VDD_DEC pfet_05v0 L=0.5U W=6U AS=3.14P
+ AD=3.14P PS=11.14U PD=11.14U
M$71 DUT_OUT$2 \$89 IN|INV_OUT|OUT VDD_DEC pfet_05v0 L=0.5U W=6U AS=3.14P
+ AD=3.14P PS=11.14U PD=11.14U
M$74 DUT_OUT$4 \$91 IN|INV_OUT|OUT VDD_DEC pfet_05v0 L=0.5U W=6U AS=3.14P
+ AD=3.14P PS=11.14U PD=11.14U
M$77 DUT_OUT$5 \$92 IN|INV_OUT|OUT VDD_DEC pfet_05v0 L=0.5U W=6U AS=3.14P
+ AD=3.14P PS=11.14U PD=11.14U
M$80 DUT_OUT$8 \$95 IN|INV_OUT|OUT VDD_DEC pfet_05v0 L=0.5U W=6U AS=3.14P
+ AD=3.14P PS=11.14U PD=11.14U
M$83 DUT_OUT$9 \$96 IN|INV_OUT|OUT VDD_DEC pfet_05v0 L=0.5U W=6U AS=3.14P
+ AD=3.14P PS=11.14U PD=11.14U
M$86 DUT_OUT$10 \$97 IN|INV_OUT|OUT VDD_DEC pfet_05v0 L=0.5U W=6U AS=3.14P
+ AD=3.14P PS=11.14U PD=11.14U
M$89 DUT_OUT$11 \$98 IN|INV_OUT|OUT VDD_DEC pfet_05v0 L=0.5U W=6U AS=3.14P
+ AD=3.14P PS=11.14U PD=11.14U
M$92 DUT_OUT$3 \$90 IN|INV_OUT|OUT VDD_DEC pfet_05v0 L=0.5U W=6U AS=3.14P
+ AD=3.14P PS=11.14U PD=11.14U
M$95 DUT_OUT$6 \$93 IN|INV_OUT|OUT VDD_DEC pfet_05v0 L=0.5U W=6U AS=3.14P
+ AD=3.14P PS=11.14U PD=11.14U
M$98 DUT_OUT$7 \$94 IN|INV_OUT|OUT VDD_DEC pfet_05v0 L=0.5U W=6U AS=3.14P
+ AD=3.14P PS=11.14U PD=11.14U
M$101 DUT_OUT$12 \$99 IN|INV_OUT|OUT VDD_DEC pfet_05v0 L=0.5U W=6U AS=3.14P
+ AD=3.14P PS=11.14U PD=11.14U
M$104 DUT_OUT$13 \$100 IN|INV_OUT|OUT VDD_DEC pfet_05v0 L=0.5U W=6U AS=3.14P
+ AD=3.14P PS=11.14U PD=11.14U
M$107 DUT_OUT$14 \$101 IN|INV_OUT|OUT VDD_DEC pfet_05v0 L=0.5U W=6U AS=3.14P
+ AD=3.14P PS=11.14U PD=11.14U
M$110 DUT_OUT$15 \$102 IN|INV_OUT|OUT VDD_DEC pfet_05v0 L=0.5U W=6U AS=3.14P
+ AD=3.14P PS=11.14U PD=11.14U
M$113 \$87 SEL VDD_DEC VDD_DEC pfet_05v0 L=0.5U W=2U AS=1.54P AD=1.54P PS=5.54U
+ PD=5.54U
M$114 \$88 SEL$1 VDD_DEC VDD_DEC pfet_05v0 L=0.5U W=2U AS=1.54P AD=1.54P
+ PS=5.54U PD=5.54U
M$115 \$89 SEL$2 VDD_DEC VDD_DEC pfet_05v0 L=0.5U W=2U AS=1.54P AD=1.54P
+ PS=5.54U PD=5.54U
M$116 \$90 SEL$3 VDD_DEC VDD_DEC pfet_05v0 L=0.5U W=2U AS=1.54P AD=1.54P
+ PS=5.54U PD=5.54U
M$117 \$91 SEL$4 VDD_DEC VDD_DEC pfet_05v0 L=0.5U W=2U AS=1.54P AD=1.54P
+ PS=5.54U PD=5.54U
M$118 \$92 SEL$5 VDD_DEC VDD_DEC pfet_05v0 L=0.5U W=2U AS=1.54P AD=1.54P
+ PS=5.54U PD=5.54U
M$119 \$93 SEL$6 VDD_DEC VDD_DEC pfet_05v0 L=0.5U W=2U AS=1.54P AD=1.54P
+ PS=5.54U PD=5.54U
M$120 \$94 SEL$7 VDD_DEC VDD_DEC pfet_05v0 L=0.5U W=2U AS=1.54P AD=1.54P
+ PS=5.54U PD=5.54U
M$121 \$95 SEL$8 VDD_DEC VDD_DEC pfet_05v0 L=0.5U W=2U AS=1.54P AD=1.54P
+ PS=5.54U PD=5.54U
M$122 \$96 SEL$9 VDD_DEC VDD_DEC pfet_05v0 L=0.5U W=2U AS=1.54P AD=1.54P
+ PS=5.54U PD=5.54U
M$123 \$97 SEL$10 VDD_DEC VDD_DEC pfet_05v0 L=0.5U W=2U AS=1.54P AD=1.54P
+ PS=5.54U PD=5.54U
M$124 \$98 SEL$11 VDD_DEC VDD_DEC pfet_05v0 L=0.5U W=2U AS=1.54P AD=1.54P
+ PS=5.54U PD=5.54U
M$125 \$99 SEL$12 VDD_DEC VDD_DEC pfet_05v0 L=0.5U W=2U AS=1.54P AD=1.54P
+ PS=5.54U PD=5.54U
M$126 \$100 SEL$13 VDD_DEC VDD_DEC pfet_05v0 L=0.5U W=2U AS=1.54P AD=1.54P
+ PS=5.54U PD=5.54U
M$127 \$101 SEL$14 VDD_DEC VDD_DEC pfet_05v0 L=0.5U W=2U AS=1.54P AD=1.54P
+ PS=5.54U PD=5.54U
M$128 \$102 SEL$15 VDD_DEC VDD_DEC pfet_05v0 L=0.5U W=2U AS=1.54P AD=1.54P
+ PS=5.54U PD=5.54U
M$129 DUT_OUT|IN|INV_IN|OUT \$169 DUT_IN$16 VDD_DEC pfet_05v0 L=0.5U W=6U
+ AS=3.14P AD=3.14P PS=11.14U PD=11.14U
M$132 DUT_OUT|IN|INV_IN|OUT \$170 DUT_IN$17 VDD_DEC pfet_05v0 L=0.5U W=6U
+ AS=3.14P AD=3.14P PS=11.14U PD=11.14U
M$135 DUT_OUT|IN|INV_IN|OUT \$171 DUT_IN$18 VDD_DEC pfet_05v0 L=0.5U W=6U
+ AS=3.14P AD=3.14P PS=11.14U PD=11.14U
M$138 DUT_OUT|IN|INV_IN|OUT \$173 DUT_IN$20 VDD_DEC pfet_05v0 L=0.5U W=6U
+ AS=3.14P AD=3.14P PS=11.14U PD=11.14U
M$141 DUT_OUT|IN|INV_IN|OUT \$174 DUT_IN$21 VDD_DEC pfet_05v0 L=0.5U W=6U
+ AS=3.14P AD=3.14P PS=11.14U PD=11.14U
M$144 DUT_OUT|IN|INV_IN|OUT \$177 DUT_IN$24 VDD_DEC pfet_05v0 L=0.5U W=6U
+ AS=3.14P AD=3.14P PS=11.14U PD=11.14U
M$147 DUT_OUT|IN|INV_IN|OUT \$178 DUT_IN$25 VDD_DEC pfet_05v0 L=0.5U W=6U
+ AS=3.14P AD=3.14P PS=11.14U PD=11.14U
M$150 DUT_OUT|IN|INV_IN|OUT \$179 DUT_IN$26 VDD_DEC pfet_05v0 L=0.5U W=6U
+ AS=3.14P AD=3.14P PS=11.14U PD=11.14U
M$153 DUT_OUT|IN|INV_IN|OUT \$180 DUT_IN$27 VDD_DEC pfet_05v0 L=0.5U W=6U
+ AS=3.14P AD=3.14P PS=11.14U PD=11.14U
M$156 DUT_OUT|IN|INV_IN|OUT \$181 DUT_IN$28 VDD_DEC pfet_05v0 L=0.5U W=6U
+ AS=3.14P AD=3.14P PS=11.14U PD=11.14U
M$159 DUT_OUT|IN|INV_IN|OUT \$182 DUT_IN$29 VDD_DEC pfet_05v0 L=0.5U W=6U
+ AS=3.14P AD=3.14P PS=11.14U PD=11.14U
M$162 DUT_OUT|IN|INV_IN|OUT \$183 DUT_IN$30 VDD_DEC pfet_05v0 L=0.5U W=6U
+ AS=3.14P AD=3.14P PS=11.14U PD=11.14U
M$165 DUT_OUT|IN|INV_IN|OUT \$184 DUT_IN$31 VDD_DEC pfet_05v0 L=0.5U W=6U
+ AS=3.14P AD=3.14P PS=11.14U PD=11.14U
M$168 DUT_OUT|IN|INV_IN|OUT \$172 DUT_IN$19 VDD_DEC pfet_05v0 L=0.5U W=6U
+ AS=3.14P AD=3.14P PS=11.14U PD=11.14U
M$171 DUT_OUT|IN|INV_IN|OUT \$175 DUT_IN$22 VDD_DEC pfet_05v0 L=0.5U W=6U
+ AS=3.14P AD=3.14P PS=11.14U PD=11.14U
M$174 DUT_OUT|IN|INV_IN|OUT \$176 DUT_IN$23 VDD_DEC pfet_05v0 L=0.5U W=6U
+ AS=3.14P AD=3.14P PS=11.14U PD=11.14U
M$177 \$169 SEL$16 VDD_DEC VDD_DEC pfet_05v0 L=0.5U W=2U AS=1.54P AD=1.54P
+ PS=5.54U PD=5.54U
M$178 \$170 SEL$17 VDD_DEC VDD_DEC pfet_05v0 L=0.5U W=2U AS=1.54P AD=1.54P
+ PS=5.54U PD=5.54U
M$179 \$171 SEL$18 VDD_DEC VDD_DEC pfet_05v0 L=0.5U W=2U AS=1.54P AD=1.54P
+ PS=5.54U PD=5.54U
M$180 \$172 SEL$19 VDD_DEC VDD_DEC pfet_05v0 L=0.5U W=2U AS=1.54P AD=1.54P
+ PS=5.54U PD=5.54U
M$181 \$173 SEL$20 VDD_DEC VDD_DEC pfet_05v0 L=0.5U W=2U AS=1.54P AD=1.54P
+ PS=5.54U PD=5.54U
M$182 \$174 SEL$21 VDD_DEC VDD_DEC pfet_05v0 L=0.5U W=2U AS=1.54P AD=1.54P
+ PS=5.54U PD=5.54U
M$183 \$175 SEL$22 VDD_DEC VDD_DEC pfet_05v0 L=0.5U W=2U AS=1.54P AD=1.54P
+ PS=5.54U PD=5.54U
M$184 \$176 SEL$23 VDD_DEC VDD_DEC pfet_05v0 L=0.5U W=2U AS=1.54P AD=1.54P
+ PS=5.54U PD=5.54U
M$185 \$177 SEL$24 VDD_DEC VDD_DEC pfet_05v0 L=0.5U W=2U AS=1.54P AD=1.54P
+ PS=5.54U PD=5.54U
M$186 \$178 SEL$25 VDD_DEC VDD_DEC pfet_05v0 L=0.5U W=2U AS=1.54P AD=1.54P
+ PS=5.54U PD=5.54U
M$187 \$179 SEL$26 VDD_DEC VDD_DEC pfet_05v0 L=0.5U W=2U AS=1.54P AD=1.54P
+ PS=5.54U PD=5.54U
M$188 \$180 SEL$27 VDD_DEC VDD_DEC pfet_05v0 L=0.5U W=2U AS=1.54P AD=1.54P
+ PS=5.54U PD=5.54U
M$189 \$181 SEL$28 VDD_DEC VDD_DEC pfet_05v0 L=0.5U W=2U AS=1.54P AD=1.54P
+ PS=5.54U PD=5.54U
M$190 \$182 SEL$29 VDD_DEC VDD_DEC pfet_05v0 L=0.5U W=2U AS=1.54P AD=1.54P
+ PS=5.54U PD=5.54U
M$191 \$183 SEL$30 VDD_DEC VDD_DEC pfet_05v0 L=0.5U W=2U AS=1.54P AD=1.54P
+ PS=5.54U PD=5.54U
M$192 \$184 SEL$31 VDD_DEC VDD_DEC pfet_05v0 L=0.5U W=2U AS=1.54P AD=1.54P
+ PS=5.54U PD=5.54U
M$193 DUT_OUT$16 \$202 IN|INV_OUT|OUT VDD_DEC pfet_05v0 L=0.5U W=6U AS=3.14P
+ AD=3.14P PS=11.14U PD=11.14U
M$196 DUT_OUT$17 \$203 IN|INV_OUT|OUT VDD_DEC pfet_05v0 L=0.5U W=6U AS=3.14P
+ AD=3.14P PS=11.14U PD=11.14U
M$199 DUT_OUT$18 \$204 IN|INV_OUT|OUT VDD_DEC pfet_05v0 L=0.5U W=6U AS=3.14P
+ AD=3.14P PS=11.14U PD=11.14U
M$202 DUT_OUT$19 \$205 IN|INV_OUT|OUT VDD_DEC pfet_05v0 L=0.5U W=6U AS=3.14P
+ AD=3.14P PS=11.14U PD=11.14U
M$205 DUT_OUT$20 \$206 IN|INV_OUT|OUT VDD_DEC pfet_05v0 L=0.5U W=6U AS=3.14P
+ AD=3.14P PS=11.14U PD=11.14U
M$208 DUT_OUT$21 \$207 IN|INV_OUT|OUT VDD_DEC pfet_05v0 L=0.5U W=6U AS=3.14P
+ AD=3.14P PS=11.14U PD=11.14U
M$211 DUT_OUT$22 \$208 IN|INV_OUT|OUT VDD_DEC pfet_05v0 L=0.5U W=6U AS=3.14P
+ AD=3.14P PS=11.14U PD=11.14U
M$214 DUT_OUT$23 \$209 IN|INV_OUT|OUT VDD_DEC pfet_05v0 L=0.5U W=6U AS=3.14P
+ AD=3.14P PS=11.14U PD=11.14U
M$217 DUT_OUT$25 \$211 IN|INV_OUT|OUT VDD_DEC pfet_05v0 L=0.5U W=6U AS=3.14P
+ AD=3.14P PS=11.14U PD=11.14U
M$220 DUT_OUT$26 \$212 IN|INV_OUT|OUT VDD_DEC pfet_05v0 L=0.5U W=6U AS=3.14P
+ AD=3.14P PS=11.14U PD=11.14U
M$223 DUT_OUT$28 \$214 IN|INV_OUT|OUT VDD_DEC pfet_05v0 L=0.5U W=6U AS=3.14P
+ AD=3.14P PS=11.14U PD=11.14U
M$226 DUT_OUT$30 \$216 IN|INV_OUT|OUT VDD_DEC pfet_05v0 L=0.5U W=6U AS=3.14P
+ AD=3.14P PS=11.14U PD=11.14U
M$229 DUT_OUT$24 \$210 IN|INV_OUT|OUT VDD_DEC pfet_05v0 L=0.5U W=6U AS=3.14P
+ AD=3.14P PS=11.14U PD=11.14U
M$232 DUT_OUT$27 \$213 IN|INV_OUT|OUT VDD_DEC pfet_05v0 L=0.5U W=6U AS=3.14P
+ AD=3.14P PS=11.14U PD=11.14U
M$235 DUT_OUT$29 \$215 IN|INV_OUT|OUT VDD_DEC pfet_05v0 L=0.5U W=6U AS=3.14P
+ AD=3.14P PS=11.14U PD=11.14U
M$238 DUT_OUT$31 \$217 IN|INV_OUT|OUT VDD_DEC pfet_05v0 L=0.5U W=6U AS=3.14P
+ AD=3.14P PS=11.14U PD=11.14U
M$241 \$202 SEL$16 VDD_DEC VDD_DEC pfet_05v0 L=0.5U W=2U AS=1.54P AD=1.54P
+ PS=5.54U PD=5.54U
M$242 \$203 SEL$17 VDD_DEC VDD_DEC pfet_05v0 L=0.5U W=2U AS=1.54P AD=1.54P
+ PS=5.54U PD=5.54U
M$243 \$204 SEL$18 VDD_DEC VDD_DEC pfet_05v0 L=0.5U W=2U AS=1.54P AD=1.54P
+ PS=5.54U PD=5.54U
M$244 \$205 SEL$19 VDD_DEC VDD_DEC pfet_05v0 L=0.5U W=2U AS=1.54P AD=1.54P
+ PS=5.54U PD=5.54U
M$245 \$206 SEL$20 VDD_DEC VDD_DEC pfet_05v0 L=0.5U W=2U AS=1.54P AD=1.54P
+ PS=5.54U PD=5.54U
M$246 \$207 SEL$21 VDD_DEC VDD_DEC pfet_05v0 L=0.5U W=2U AS=1.54P AD=1.54P
+ PS=5.54U PD=5.54U
M$247 \$208 SEL$22 VDD_DEC VDD_DEC pfet_05v0 L=0.5U W=2U AS=1.54P AD=1.54P
+ PS=5.54U PD=5.54U
M$248 \$209 SEL$23 VDD_DEC VDD_DEC pfet_05v0 L=0.5U W=2U AS=1.54P AD=1.54P
+ PS=5.54U PD=5.54U
M$249 \$210 SEL$24 VDD_DEC VDD_DEC pfet_05v0 L=0.5U W=2U AS=1.54P AD=1.54P
+ PS=5.54U PD=5.54U
M$250 \$211 SEL$25 VDD_DEC VDD_DEC pfet_05v0 L=0.5U W=2U AS=1.54P AD=1.54P
+ PS=5.54U PD=5.54U
M$251 \$212 SEL$26 VDD_DEC VDD_DEC pfet_05v0 L=0.5U W=2U AS=1.54P AD=1.54P
+ PS=5.54U PD=5.54U
M$252 \$213 SEL$27 VDD_DEC VDD_DEC pfet_05v0 L=0.5U W=2U AS=1.54P AD=1.54P
+ PS=5.54U PD=5.54U
M$253 \$214 SEL$28 VDD_DEC VDD_DEC pfet_05v0 L=0.5U W=2U AS=1.54P AD=1.54P
+ PS=5.54U PD=5.54U
M$254 \$215 SEL$29 VDD_DEC VDD_DEC pfet_05v0 L=0.5U W=2U AS=1.54P AD=1.54P
+ PS=5.54U PD=5.54U
M$255 \$216 SEL$30 VDD_DEC VDD_DEC pfet_05v0 L=0.5U W=2U AS=1.54P AD=1.54P
+ PS=5.54U PD=5.54U
M$256 \$217 SEL$31 VDD_DEC VDD_DEC pfet_05v0 L=0.5U W=2U AS=1.54P AD=1.54P
+ PS=5.54U PD=5.54U
M$257 DUT_OUT|IN|INV_IN|OUT \$284 DUT_IN$32 VDD_DEC pfet_05v0 L=0.5U W=6U
+ AS=3.14P AD=3.14P PS=11.14U PD=11.14U
M$260 DUT_OUT|IN|INV_IN|OUT \$285 DUT_IN$33 VDD_DEC pfet_05v0 L=0.5U W=6U
+ AS=3.14P AD=3.14P PS=11.14U PD=11.14U
M$263 DUT_OUT|IN|INV_IN|OUT \$286 DUT_IN$34 VDD_DEC pfet_05v0 L=0.5U W=6U
+ AS=3.14P AD=3.14P PS=11.14U PD=11.14U
M$266 DUT_OUT|IN|INV_IN|OUT \$287 DUT_IN$35 VDD_DEC pfet_05v0 L=0.5U W=6U
+ AS=3.14P AD=3.14P PS=11.14U PD=11.14U
M$269 DUT_OUT|IN|INV_IN|OUT \$288 DUT_IN$36 VDD_DEC pfet_05v0 L=0.5U W=6U
+ AS=3.14P AD=3.14P PS=11.14U PD=11.14U
M$272 DUT_OUT|IN|INV_IN|OUT \$289 DUT_IN$37 VDD_DEC pfet_05v0 L=0.5U W=6U
+ AS=3.14P AD=3.14P PS=11.14U PD=11.14U
M$275 DUT_OUT|IN|INV_IN|OUT \$290 DUT_IN$38 VDD_DEC pfet_05v0 L=0.5U W=6U
+ AS=3.14P AD=3.14P PS=11.14U PD=11.14U
M$278 DUT_OUT|IN|INV_IN|OUT \$291 DUT_IN$39 VDD_DEC pfet_05v0 L=0.5U W=6U
+ AS=3.14P AD=3.14P PS=11.14U PD=11.14U
M$281 DUT_OUT|IN|INV_IN|OUT \$292 DUT_IN$40 VDD_DEC pfet_05v0 L=0.5U W=6U
+ AS=3.14P AD=3.14P PS=11.14U PD=11.14U
M$284 DUT_OUT|IN|INV_IN|OUT \$293 DUT_IN$41 VDD_DEC pfet_05v0 L=0.5U W=6U
+ AS=3.14P AD=3.14P PS=11.14U PD=11.14U
M$287 DUT_OUT|IN|INV_IN|OUT \$294 DUT_IN$42 VDD_DEC pfet_05v0 L=0.5U W=6U
+ AS=3.14P AD=3.14P PS=11.14U PD=11.14U
M$290 DUT_OUT|IN|INV_IN|OUT \$295 DUT_IN$43 VDD_DEC pfet_05v0 L=0.5U W=6U
+ AS=3.14P AD=3.14P PS=11.14U PD=11.14U
M$293 DUT_OUT|IN|INV_IN|OUT \$296 DUT_IN$44 VDD_DEC pfet_05v0 L=0.5U W=6U
+ AS=3.14P AD=3.14P PS=11.14U PD=11.14U
M$296 DUT_OUT|IN|INV_IN|OUT \$297 DUT_IN$45 VDD_DEC pfet_05v0 L=0.5U W=6U
+ AS=3.14P AD=3.14P PS=11.14U PD=11.14U
M$299 DUT_OUT|IN|INV_IN|OUT \$299 DUT_IN$47 VDD_DEC pfet_05v0 L=0.5U W=6U
+ AS=3.14P AD=3.14P PS=11.14U PD=11.14U
M$302 DUT_OUT|IN|INV_IN|OUT \$298 DUT_IN$46 VDD_DEC pfet_05v0 L=0.5U W=6U
+ AS=3.14P AD=3.14P PS=11.14U PD=11.14U
M$305 \$284 SEL$32 VDD_DEC VDD_DEC pfet_05v0 L=0.5U W=2U AS=1.54P AD=1.54P
+ PS=5.54U PD=5.54U
M$306 \$285 SEL$33 VDD_DEC VDD_DEC pfet_05v0 L=0.5U W=2U AS=1.54P AD=1.54P
+ PS=5.54U PD=5.54U
M$307 \$286 SEL$34 VDD_DEC VDD_DEC pfet_05v0 L=0.5U W=2U AS=1.54P AD=1.54P
+ PS=5.54U PD=5.54U
M$308 \$287 SEL$35 VDD_DEC VDD_DEC pfet_05v0 L=0.5U W=2U AS=1.54P AD=1.54P
+ PS=5.54U PD=5.54U
M$309 \$288 SEL$36 VDD_DEC VDD_DEC pfet_05v0 L=0.5U W=2U AS=1.54P AD=1.54P
+ PS=5.54U PD=5.54U
M$310 \$289 SEL$37 VDD_DEC VDD_DEC pfet_05v0 L=0.5U W=2U AS=1.54P AD=1.54P
+ PS=5.54U PD=5.54U
M$311 \$290 SEL$38 VDD_DEC VDD_DEC pfet_05v0 L=0.5U W=2U AS=1.54P AD=1.54P
+ PS=5.54U PD=5.54U
M$312 \$291 SEL$39 VDD_DEC VDD_DEC pfet_05v0 L=0.5U W=2U AS=1.54P AD=1.54P
+ PS=5.54U PD=5.54U
M$313 \$292 SEL$40 VDD_DEC VDD_DEC pfet_05v0 L=0.5U W=2U AS=1.54P AD=1.54P
+ PS=5.54U PD=5.54U
M$314 \$293 SEL$41 VDD_DEC VDD_DEC pfet_05v0 L=0.5U W=2U AS=1.54P AD=1.54P
+ PS=5.54U PD=5.54U
M$315 \$294 SEL$42 VDD_DEC VDD_DEC pfet_05v0 L=0.5U W=2U AS=1.54P AD=1.54P
+ PS=5.54U PD=5.54U
M$316 \$295 SEL$43 VDD_DEC VDD_DEC pfet_05v0 L=0.5U W=2U AS=1.54P AD=1.54P
+ PS=5.54U PD=5.54U
M$317 \$296 SEL$44 VDD_DEC VDD_DEC pfet_05v0 L=0.5U W=2U AS=1.54P AD=1.54P
+ PS=5.54U PD=5.54U
M$318 \$297 SEL$45 VDD_DEC VDD_DEC pfet_05v0 L=0.5U W=2U AS=1.54P AD=1.54P
+ PS=5.54U PD=5.54U
M$319 \$298 SEL$46 VDD_DEC VDD_DEC pfet_05v0 L=0.5U W=2U AS=1.54P AD=1.54P
+ PS=5.54U PD=5.54U
M$320 \$299 SEL$47 VDD_DEC VDD_DEC pfet_05v0 L=0.5U W=2U AS=1.54P AD=1.54P
+ PS=5.54U PD=5.54U
M$321 DUT_OUT$32 \$317 IN|INV_OUT|OUT VDD_DEC pfet_05v0 L=0.5U W=6U AS=3.14P
+ AD=3.14P PS=11.14U PD=11.14U
M$324 DUT_OUT$33 \$318 IN|INV_OUT|OUT VDD_DEC pfet_05v0 L=0.5U W=6U AS=3.14P
+ AD=3.14P PS=11.14U PD=11.14U
M$327 DUT_OUT$34 \$319 IN|INV_OUT|OUT VDD_DEC pfet_05v0 L=0.5U W=6U AS=3.14P
+ AD=3.14P PS=11.14U PD=11.14U
M$330 DUT_OUT$35 \$320 IN|INV_OUT|OUT VDD_DEC pfet_05v0 L=0.5U W=6U AS=3.14P
+ AD=3.14P PS=11.14U PD=11.14U
M$333 DUT_OUT$36 \$321 IN|INV_OUT|OUT VDD_DEC pfet_05v0 L=0.5U W=6U AS=3.14P
+ AD=3.14P PS=11.14U PD=11.14U
M$336 DUT_OUT$37 \$322 IN|INV_OUT|OUT VDD_DEC pfet_05v0 L=0.5U W=6U AS=3.14P
+ AD=3.14P PS=11.14U PD=11.14U
M$339 DUT_OUT$38 \$323 IN|INV_OUT|OUT VDD_DEC pfet_05v0 L=0.5U W=6U AS=3.14P
+ AD=3.14P PS=11.14U PD=11.14U
M$342 DUT_OUT$39 \$324 IN|INV_OUT|OUT VDD_DEC pfet_05v0 L=0.5U W=6U AS=3.14P
+ AD=3.14P PS=11.14U PD=11.14U
M$345 DUT_OUT$40 \$325 IN|INV_OUT|OUT VDD_DEC pfet_05v0 L=0.5U W=6U AS=3.14P
+ AD=3.14P PS=11.14U PD=11.14U
M$348 DUT_OUT$41 \$326 IN|INV_OUT|OUT VDD_DEC pfet_05v0 L=0.5U W=6U AS=3.14P
+ AD=3.14P PS=11.14U PD=11.14U
M$351 DUT_OUT$42 \$327 IN|INV_OUT|OUT VDD_DEC pfet_05v0 L=0.5U W=6U AS=3.14P
+ AD=3.14P PS=11.14U PD=11.14U
M$354 DUT_OUT$43 \$328 IN|INV_OUT|OUT VDD_DEC pfet_05v0 L=0.5U W=6U AS=3.14P
+ AD=3.14P PS=11.14U PD=11.14U
M$357 DUT_OUT$44 \$329 IN|INV_OUT|OUT VDD_DEC pfet_05v0 L=0.5U W=6U AS=3.14P
+ AD=3.14P PS=11.14U PD=11.14U
M$360 DUT_OUT$46 \$331 IN|INV_OUT|OUT VDD_DEC pfet_05v0 L=0.5U W=6U AS=3.14P
+ AD=3.14P PS=11.14U PD=11.14U
M$363 DUT_OUT$47 \$332 IN|INV_OUT|OUT VDD_DEC pfet_05v0 L=0.5U W=6U AS=3.14P
+ AD=3.14P PS=11.14U PD=11.14U
M$366 DUT_OUT$45 \$330 IN|INV_OUT|OUT VDD_DEC pfet_05v0 L=0.5U W=6U AS=3.14P
+ AD=3.14P PS=11.14U PD=11.14U
M$369 \$317 SEL$32 VDD_DEC VDD_DEC pfet_05v0 L=0.5U W=2U AS=1.54P AD=1.54P
+ PS=5.54U PD=5.54U
M$370 \$318 SEL$33 VDD_DEC VDD_DEC pfet_05v0 L=0.5U W=2U AS=1.54P AD=1.54P
+ PS=5.54U PD=5.54U
M$371 \$319 SEL$34 VDD_DEC VDD_DEC pfet_05v0 L=0.5U W=2U AS=1.54P AD=1.54P
+ PS=5.54U PD=5.54U
M$372 \$320 SEL$35 VDD_DEC VDD_DEC pfet_05v0 L=0.5U W=2U AS=1.54P AD=1.54P
+ PS=5.54U PD=5.54U
M$373 \$321 SEL$36 VDD_DEC VDD_DEC pfet_05v0 L=0.5U W=2U AS=1.54P AD=1.54P
+ PS=5.54U PD=5.54U
M$374 \$322 SEL$37 VDD_DEC VDD_DEC pfet_05v0 L=0.5U W=2U AS=1.54P AD=1.54P
+ PS=5.54U PD=5.54U
M$375 \$323 SEL$38 VDD_DEC VDD_DEC pfet_05v0 L=0.5U W=2U AS=1.54P AD=1.54P
+ PS=5.54U PD=5.54U
M$376 \$324 SEL$39 VDD_DEC VDD_DEC pfet_05v0 L=0.5U W=2U AS=1.54P AD=1.54P
+ PS=5.54U PD=5.54U
M$377 \$325 SEL$40 VDD_DEC VDD_DEC pfet_05v0 L=0.5U W=2U AS=1.54P AD=1.54P
+ PS=5.54U PD=5.54U
M$378 \$326 SEL$41 VDD_DEC VDD_DEC pfet_05v0 L=0.5U W=2U AS=1.54P AD=1.54P
+ PS=5.54U PD=5.54U
M$379 \$327 SEL$42 VDD_DEC VDD_DEC pfet_05v0 L=0.5U W=2U AS=1.54P AD=1.54P
+ PS=5.54U PD=5.54U
M$380 \$328 SEL$43 VDD_DEC VDD_DEC pfet_05v0 L=0.5U W=2U AS=1.54P AD=1.54P
+ PS=5.54U PD=5.54U
M$381 \$329 SEL$44 VDD_DEC VDD_DEC pfet_05v0 L=0.5U W=2U AS=1.54P AD=1.54P
+ PS=5.54U PD=5.54U
M$382 \$330 SEL$45 VDD_DEC VDD_DEC pfet_05v0 L=0.5U W=2U AS=1.54P AD=1.54P
+ PS=5.54U PD=5.54U
M$383 \$331 SEL$46 VDD_DEC VDD_DEC pfet_05v0 L=0.5U W=2U AS=1.54P AD=1.54P
+ PS=5.54U PD=5.54U
M$384 \$332 SEL$47 VDD_DEC VDD_DEC pfet_05v0 L=0.5U W=2U AS=1.54P AD=1.54P
+ PS=5.54U PD=5.54U
M$385 DUT_OUT|IN|INV_IN|OUT \$399 DUT_IN$48 VDD_DEC pfet_05v0 L=0.5U W=6U
+ AS=3.14P AD=3.14P PS=11.14U PD=11.14U
M$388 DUT_OUT|IN|INV_IN|OUT \$400 DUT_IN$49 VDD_DEC pfet_05v0 L=0.5U W=6U
+ AS=3.14P AD=3.14P PS=11.14U PD=11.14U
M$391 DUT_OUT|IN|INV_IN|OUT \$401 DUT_IN$50 VDD_DEC pfet_05v0 L=0.5U W=6U
+ AS=3.14P AD=3.14P PS=11.14U PD=11.14U
M$394 DUT_OUT|IN|INV_IN|OUT \$402 DUT_IN$51 VDD_DEC pfet_05v0 L=0.5U W=6U
+ AS=3.14P AD=3.14P PS=11.14U PD=11.14U
M$397 DUT_OUT|IN|INV_IN|OUT \$403 DUT_IN$52 VDD_DEC pfet_05v0 L=0.5U W=6U
+ AS=3.14P AD=3.14P PS=11.14U PD=11.14U
M$400 DUT_OUT|IN|INV_IN|OUT \$405 DUT_IN$54 VDD_DEC pfet_05v0 L=0.5U W=6U
+ AS=3.14P AD=3.14P PS=11.14U PD=11.14U
M$403 DUT_OUT|IN|INV_IN|OUT \$406 DUT_IN$55 VDD_DEC pfet_05v0 L=0.5U W=6U
+ AS=3.14P AD=3.14P PS=11.14U PD=11.14U
M$406 DUT_OUT|IN|INV_IN|OUT \$408 DUT_IN$57 VDD_DEC pfet_05v0 L=0.5U W=6U
+ AS=3.14P AD=3.14P PS=11.14U PD=11.14U
M$409 DUT_OUT|IN|INV_IN|OUT \$409 DUT_IN$58 VDD_DEC pfet_05v0 L=0.5U W=6U
+ AS=3.14P AD=3.14P PS=11.14U PD=11.14U
M$412 DUT_OUT|IN|INV_IN|OUT \$410 DUT_IN$59 VDD_DEC pfet_05v0 L=0.5U W=6U
+ AS=3.14P AD=3.14P PS=11.14U PD=11.14U
M$415 DUT_OUT|IN|INV_IN|OUT \$411 DUT_IN$60 VDD_DEC pfet_05v0 L=0.5U W=6U
+ AS=3.14P AD=3.14P PS=11.14U PD=11.14U
M$418 DUT_OUT|IN|INV_IN|OUT \$412 DUT_IN$61 VDD_DEC pfet_05v0 L=0.5U W=6U
+ AS=3.14P AD=3.14P PS=11.14U PD=11.14U
M$421 DUT_OUT|IN|INV_IN|OUT \$404 DUT_IN$53 VDD_DEC pfet_05v0 L=0.5U W=6U
+ AS=3.14P AD=3.14P PS=11.14U PD=11.14U
M$424 DUT_OUT|IN|INV_IN|OUT \$407 DUT_IN$56 VDD_DEC pfet_05v0 L=0.5U W=6U
+ AS=3.14P AD=3.14P PS=11.14U PD=11.14U
M$427 DUT_OUT|IN|INV_IN|OUT \$413 DUT_IN$62 VDD_DEC pfet_05v0 L=0.5U W=6U
+ AS=3.14P AD=3.14P PS=11.14U PD=11.14U
M$430 DUT_OUT|IN|INV_IN|OUT \$414 DUT_IN$63 VDD_DEC pfet_05v0 L=0.5U W=6U
+ AS=3.14P AD=3.14P PS=11.14U PD=11.14U
M$433 \$399 SEL$48 VDD_DEC VDD_DEC pfet_05v0 L=0.5U W=2U AS=1.54P AD=1.54P
+ PS=5.54U PD=5.54U
M$434 \$400 SEL$49 VDD_DEC VDD_DEC pfet_05v0 L=0.5U W=2U AS=1.54P AD=1.54P
+ PS=5.54U PD=5.54U
M$435 \$401 SEL$50 VDD_DEC VDD_DEC pfet_05v0 L=0.5U W=2U AS=1.54P AD=1.54P
+ PS=5.54U PD=5.54U
M$436 \$402 SEL$51 VDD_DEC VDD_DEC pfet_05v0 L=0.5U W=2U AS=1.54P AD=1.54P
+ PS=5.54U PD=5.54U
M$437 \$403 SEL$52 VDD_DEC VDD_DEC pfet_05v0 L=0.5U W=2U AS=1.54P AD=1.54P
+ PS=5.54U PD=5.54U
M$438 \$404 SEL$53 VDD_DEC VDD_DEC pfet_05v0 L=0.5U W=2U AS=1.54P AD=1.54P
+ PS=5.54U PD=5.54U
M$439 \$405 SEL$54 VDD_DEC VDD_DEC pfet_05v0 L=0.5U W=2U AS=1.54P AD=1.54P
+ PS=5.54U PD=5.54U
M$440 \$406 SEL$55 VDD_DEC VDD_DEC pfet_05v0 L=0.5U W=2U AS=1.54P AD=1.54P
+ PS=5.54U PD=5.54U
M$441 \$407 SEL$56 VDD_DEC VDD_DEC pfet_05v0 L=0.5U W=2U AS=1.54P AD=1.54P
+ PS=5.54U PD=5.54U
M$442 \$408 SEL$57 VDD_DEC VDD_DEC pfet_05v0 L=0.5U W=2U AS=1.54P AD=1.54P
+ PS=5.54U PD=5.54U
M$443 \$409 SEL$58 VDD_DEC VDD_DEC pfet_05v0 L=0.5U W=2U AS=1.54P AD=1.54P
+ PS=5.54U PD=5.54U
M$444 \$410 SEL$59 VDD_DEC VDD_DEC pfet_05v0 L=0.5U W=2U AS=1.54P AD=1.54P
+ PS=5.54U PD=5.54U
M$445 \$411 SEL$60 VDD_DEC VDD_DEC pfet_05v0 L=0.5U W=2U AS=1.54P AD=1.54P
+ PS=5.54U PD=5.54U
M$446 \$412 SEL$61 VDD_DEC VDD_DEC pfet_05v0 L=0.5U W=2U AS=1.54P AD=1.54P
+ PS=5.54U PD=5.54U
M$447 \$413 SEL$62 VDD_DEC VDD_DEC pfet_05v0 L=0.5U W=2U AS=1.54P AD=1.54P
+ PS=5.54U PD=5.54U
M$448 \$414 SEL$63 VDD_DEC VDD_DEC pfet_05v0 L=0.5U W=2U AS=1.54P AD=1.54P
+ PS=5.54U PD=5.54U
M$449 DUT_OUT$48 \$416 IN|INV_OUT|OUT VDD_DEC pfet_05v0 L=0.5U W=6U AS=3.14P
+ AD=3.14P PS=11.14U PD=11.14U
M$452 DUT_OUT$49 \$418 IN|INV_OUT|OUT VDD_DEC pfet_05v0 L=0.5U W=6U AS=3.14P
+ AD=3.14P PS=11.14U PD=11.14U
M$455 DUT_OUT$50 \$420 IN|INV_OUT|OUT VDD_DEC pfet_05v0 L=0.5U W=6U AS=3.14P
+ AD=3.14P PS=11.14U PD=11.14U
M$458 DUT_OUT$51 \$422 IN|INV_OUT|OUT VDD_DEC pfet_05v0 L=0.5U W=6U AS=3.14P
+ AD=3.14P PS=11.14U PD=11.14U
M$461 DUT_OUT$53 \$426 IN|INV_OUT|OUT VDD_DEC pfet_05v0 L=0.5U W=6U AS=3.14P
+ AD=3.14P PS=11.14U PD=11.14U
M$464 DUT_OUT$54 \$428 IN|INV_OUT|OUT VDD_DEC pfet_05v0 L=0.5U W=6U AS=3.14P
+ AD=3.14P PS=11.14U PD=11.14U
M$467 DUT_OUT$55 \$430 IN|INV_OUT|OUT VDD_DEC pfet_05v0 L=0.5U W=6U AS=3.14P
+ AD=3.14P PS=11.14U PD=11.14U
M$470 DUT_OUT$57 \$434 IN|INV_OUT|OUT VDD_DEC pfet_05v0 L=0.5U W=6U AS=3.14P
+ AD=3.14P PS=11.14U PD=11.14U
M$473 DUT_OUT$58 \$436 IN|INV_OUT|OUT VDD_DEC pfet_05v0 L=0.5U W=6U AS=3.14P
+ AD=3.14P PS=11.14U PD=11.14U
M$476 DUT_OUT$60 \$440 IN|INV_OUT|OUT VDD_DEC pfet_05v0 L=0.5U W=6U AS=3.14P
+ AD=3.14P PS=11.14U PD=11.14U
M$479 DUT_OUT$61 \$442 IN|INV_OUT|OUT VDD_DEC pfet_05v0 L=0.5U W=6U AS=3.14P
+ AD=3.14P PS=11.14U PD=11.14U
M$482 DUT_OUT$63 \$446 IN|INV_OUT|OUT VDD_DEC pfet_05v0 L=0.5U W=6U AS=3.14P
+ AD=3.14P PS=11.14U PD=11.14U
M$485 DUT_OUT$52 \$424 IN|INV_OUT|OUT VDD_DEC pfet_05v0 L=0.5U W=6U AS=3.14P
+ AD=3.14P PS=11.14U PD=11.14U
M$488 DUT_OUT$56 \$432 IN|INV_OUT|OUT VDD_DEC pfet_05v0 L=0.5U W=6U AS=3.14P
+ AD=3.14P PS=11.14U PD=11.14U
M$491 DUT_OUT$59 \$438 IN|INV_OUT|OUT VDD_DEC pfet_05v0 L=0.5U W=6U AS=3.14P
+ AD=3.14P PS=11.14U PD=11.14U
M$494 DUT_OUT$62 \$444 IN|INV_OUT|OUT VDD_DEC pfet_05v0 L=0.5U W=6U AS=3.14P
+ AD=3.14P PS=11.14U PD=11.14U
M$497 \$416 SEL$48 VDD_DEC VDD_DEC pfet_05v0 L=0.5U W=2U AS=1.54P AD=1.54P
+ PS=5.54U PD=5.54U
M$498 \$418 SEL$49 VDD_DEC VDD_DEC pfet_05v0 L=0.5U W=2U AS=1.54P AD=1.54P
+ PS=5.54U PD=5.54U
M$499 \$420 SEL$50 VDD_DEC VDD_DEC pfet_05v0 L=0.5U W=2U AS=1.54P AD=1.54P
+ PS=5.54U PD=5.54U
M$500 \$422 SEL$51 VDD_DEC VDD_DEC pfet_05v0 L=0.5U W=2U AS=1.54P AD=1.54P
+ PS=5.54U PD=5.54U
M$501 \$424 SEL$52 VDD_DEC VDD_DEC pfet_05v0 L=0.5U W=2U AS=1.54P AD=1.54P
+ PS=5.54U PD=5.54U
M$502 \$426 SEL$53 VDD_DEC VDD_DEC pfet_05v0 L=0.5U W=2U AS=1.54P AD=1.54P
+ PS=5.54U PD=5.54U
M$503 \$428 SEL$54 VDD_DEC VDD_DEC pfet_05v0 L=0.5U W=2U AS=1.54P AD=1.54P
+ PS=5.54U PD=5.54U
M$504 \$430 SEL$55 VDD_DEC VDD_DEC pfet_05v0 L=0.5U W=2U AS=1.54P AD=1.54P
+ PS=5.54U PD=5.54U
M$505 \$432 SEL$56 VDD_DEC VDD_DEC pfet_05v0 L=0.5U W=2U AS=1.54P AD=1.54P
+ PS=5.54U PD=5.54U
M$506 \$434 SEL$57 VDD_DEC VDD_DEC pfet_05v0 L=0.5U W=2U AS=1.54P AD=1.54P
+ PS=5.54U PD=5.54U
M$507 \$436 SEL$58 VDD_DEC VDD_DEC pfet_05v0 L=0.5U W=2U AS=1.54P AD=1.54P
+ PS=5.54U PD=5.54U
M$508 \$438 SEL$59 VDD_DEC VDD_DEC pfet_05v0 L=0.5U W=2U AS=1.54P AD=1.54P
+ PS=5.54U PD=5.54U
M$509 \$440 SEL$60 VDD_DEC VDD_DEC pfet_05v0 L=0.5U W=2U AS=1.54P AD=1.54P
+ PS=5.54U PD=5.54U
M$510 \$442 SEL$61 VDD_DEC VDD_DEC pfet_05v0 L=0.5U W=2U AS=1.54P AD=1.54P
+ PS=5.54U PD=5.54U
M$511 \$444 SEL$62 VDD_DEC VDD_DEC pfet_05v0 L=0.5U W=2U AS=1.54P AD=1.54P
+ PS=5.54U PD=5.54U
M$512 \$446 SEL$63 VDD_DEC VDD_DEC pfet_05v0 L=0.5U W=2U AS=1.54P AD=1.54P
+ PS=5.54U PD=5.54U
M$513 DUT_OUT|IN|INV_IN|OUT \$514 DUT_IN$64 VDD_DEC pfet_05v0 L=0.5U W=6U
+ AS=3.14P AD=3.14P PS=11.14U PD=11.14U
M$516 DUT_OUT|IN|INV_IN|OUT \$515 DUT_IN$65 VDD_DEC pfet_05v0 L=0.5U W=6U
+ AS=3.14P AD=3.14P PS=11.14U PD=11.14U
M$519 DUT_OUT|IN|INV_IN|OUT \$516 DUT_IN$66 VDD_DEC pfet_05v0 L=0.5U W=6U
+ AS=3.14P AD=3.14P PS=11.14U PD=11.14U
M$522 DUT_OUT|IN|INV_IN|OUT \$517 DUT_IN$67 VDD_DEC pfet_05v0 L=0.5U W=6U
+ AS=3.14P AD=3.14P PS=11.14U PD=11.14U
M$525 DUT_OUT|IN|INV_IN|OUT \$518 DUT_IN$68 VDD_DEC pfet_05v0 L=0.5U W=6U
+ AS=3.14P AD=3.14P PS=11.14U PD=11.14U
M$528 DUT_OUT|IN|INV_IN|OUT \$519 DUT_IN$69 VDD_DEC pfet_05v0 L=0.5U W=6U
+ AS=3.14P AD=3.14P PS=11.14U PD=11.14U
M$531 DUT_OUT|IN|INV_IN|OUT \$520 DUT_IN$70 VDD_DEC pfet_05v0 L=0.5U W=6U
+ AS=3.14P AD=3.14P PS=11.14U PD=11.14U
M$534 DUT_OUT|IN|INV_IN|OUT \$521 DUT_IN$71 VDD_DEC pfet_05v0 L=0.5U W=6U
+ AS=3.14P AD=3.14P PS=11.14U PD=11.14U
M$537 DUT_OUT|IN|INV_IN|OUT \$522 DUT_IN$72 VDD_DEC pfet_05v0 L=0.5U W=6U
+ AS=3.14P AD=3.14P PS=11.14U PD=11.14U
M$540 DUT_OUT|IN|INV_IN|OUT \$524 DUT_IN$74 VDD_DEC pfet_05v0 L=0.5U W=6U
+ AS=3.14P AD=3.14P PS=11.14U PD=11.14U
M$543 DUT_OUT|IN|INV_IN|OUT \$525 DUT_IN$75 VDD_DEC pfet_05v0 L=0.5U W=6U
+ AS=3.14P AD=3.14P PS=11.14U PD=11.14U
M$546 DUT_OUT|IN|INV_IN|OUT \$526 DUT_IN$76 VDD_DEC pfet_05v0 L=0.5U W=6U
+ AS=3.14P AD=3.14P PS=11.14U PD=11.14U
M$549 DUT_OUT|IN|INV_IN|OUT \$527 DUT_IN$77 VDD_DEC pfet_05v0 L=0.5U W=6U
+ AS=3.14P AD=3.14P PS=11.14U PD=11.14U
M$552 DUT_OUT|IN|INV_IN|OUT \$528 DUT_IN$78 VDD_DEC pfet_05v0 L=0.5U W=6U
+ AS=3.14P AD=3.14P PS=11.14U PD=11.14U
M$555 DUT_OUT|IN|INV_IN|OUT \$529 DUT_IN$79 VDD_DEC pfet_05v0 L=0.5U W=6U
+ AS=3.14P AD=3.14P PS=11.14U PD=11.14U
M$558 DUT_OUT|IN|INV_IN|OUT \$523 DUT_IN$73 VDD_DEC pfet_05v0 L=0.5U W=6U
+ AS=3.14P AD=3.14P PS=11.14U PD=11.14U
M$561 \$514 SEL$64 VDD_DEC VDD_DEC pfet_05v0 L=0.5U W=2U AS=1.54P AD=1.54P
+ PS=5.54U PD=5.54U
M$562 \$515 SEL$65 VDD_DEC VDD_DEC pfet_05v0 L=0.5U W=2U AS=1.54P AD=1.54P
+ PS=5.54U PD=5.54U
M$563 \$516 SEL$66 VDD_DEC VDD_DEC pfet_05v0 L=0.5U W=2U AS=1.54P AD=1.54P
+ PS=5.54U PD=5.54U
M$564 \$517 SEL$67 VDD_DEC VDD_DEC pfet_05v0 L=0.5U W=2U AS=1.54P AD=1.54P
+ PS=5.54U PD=5.54U
M$565 \$518 SEL$68 VDD_DEC VDD_DEC pfet_05v0 L=0.5U W=2U AS=1.54P AD=1.54P
+ PS=5.54U PD=5.54U
M$566 \$519 SEL$69 VDD_DEC VDD_DEC pfet_05v0 L=0.5U W=2U AS=1.54P AD=1.54P
+ PS=5.54U PD=5.54U
M$567 \$520 SEL$70 VDD_DEC VDD_DEC pfet_05v0 L=0.5U W=2U AS=1.54P AD=1.54P
+ PS=5.54U PD=5.54U
M$568 \$521 SEL$71 VDD_DEC VDD_DEC pfet_05v0 L=0.5U W=2U AS=1.54P AD=1.54P
+ PS=5.54U PD=5.54U
M$569 \$522 SEL$72 VDD_DEC VDD_DEC pfet_05v0 L=0.5U W=2U AS=1.54P AD=1.54P
+ PS=5.54U PD=5.54U
M$570 \$523 SEL$73 VDD_DEC VDD_DEC pfet_05v0 L=0.5U W=2U AS=1.54P AD=1.54P
+ PS=5.54U PD=5.54U
M$571 \$524 SEL$74 VDD_DEC VDD_DEC pfet_05v0 L=0.5U W=2U AS=1.54P AD=1.54P
+ PS=5.54U PD=5.54U
M$572 \$525 SEL$75 VDD_DEC VDD_DEC pfet_05v0 L=0.5U W=2U AS=1.54P AD=1.54P
+ PS=5.54U PD=5.54U
M$573 \$526 SEL$76 VDD_DEC VDD_DEC pfet_05v0 L=0.5U W=2U AS=1.54P AD=1.54P
+ PS=5.54U PD=5.54U
M$574 \$527 SEL$77 VDD_DEC VDD_DEC pfet_05v0 L=0.5U W=2U AS=1.54P AD=1.54P
+ PS=5.54U PD=5.54U
M$575 \$528 SEL$78 VDD_DEC VDD_DEC pfet_05v0 L=0.5U W=2U AS=1.54P AD=1.54P
+ PS=5.54U PD=5.54U
M$576 \$529 SEL$79 VDD_DEC VDD_DEC pfet_05v0 L=0.5U W=2U AS=1.54P AD=1.54P
+ PS=5.54U PD=5.54U
M$577 DUT_OUT$64 \$535 IN|INV_OUT|OUT VDD_DEC pfet_05v0 L=0.5U W=6U AS=3.14P
+ AD=3.14P PS=11.14U PD=11.14U
M$580 DUT_OUT$66 \$537 IN|INV_OUT|OUT VDD_DEC pfet_05v0 L=0.5U W=6U AS=3.14P
+ AD=3.14P PS=11.14U PD=11.14U
M$583 DUT_OUT$67 \$538 IN|INV_OUT|OUT VDD_DEC pfet_05v0 L=0.5U W=6U AS=3.14P
+ AD=3.14P PS=11.14U PD=11.14U
M$586 DUT_OUT$68 \$531 IN|INV_OUT|OUT VDD_DEC pfet_05v0 L=0.5U W=6U AS=3.14P
+ AD=3.14P PS=11.14U PD=11.14U
M$589 DUT_OUT$69 \$539 IN|INV_OUT|OUT VDD_DEC pfet_05v0 L=0.5U W=6U AS=3.14P
+ AD=3.14P PS=11.14U PD=11.14U
M$592 DUT_OUT$70 \$540 IN|INV_OUT|OUT VDD_DEC pfet_05v0 L=0.5U W=6U AS=3.14P
+ AD=3.14P PS=11.14U PD=11.14U
M$595 DUT_OUT$71 \$541 IN|INV_OUT|OUT VDD_DEC pfet_05v0 L=0.5U W=6U AS=3.14P
+ AD=3.14P PS=11.14U PD=11.14U
M$598 DUT_OUT$72 \$542 IN|INV_OUT|OUT VDD_DEC pfet_05v0 L=0.5U W=6U AS=3.14P
+ AD=3.14P PS=11.14U PD=11.14U
M$601 DUT_OUT$74 \$544 IN|INV_OUT|OUT VDD_DEC pfet_05v0 L=0.5U W=6U AS=3.14P
+ AD=3.14P PS=11.14U PD=11.14U
M$604 DUT_OUT$75 \$532 IN|INV_OUT|OUT VDD_DEC pfet_05v0 L=0.5U W=6U AS=3.14P
+ AD=3.14P PS=11.14U PD=11.14U
M$607 DUT_OUT$77 \$546 IN|INV_OUT|OUT VDD_DEC pfet_05v0 L=0.5U W=6U AS=3.14P
+ AD=3.14P PS=11.14U PD=11.14U
M$610 DUT_OUT$65 \$536 IN|INV_OUT|OUT VDD_DEC pfet_05v0 L=0.5U W=6U AS=3.14P
+ AD=3.14P PS=11.14U PD=11.14U
M$613 DUT_OUT$73 \$543 IN|INV_OUT|OUT VDD_DEC pfet_05v0 L=0.5U W=6U AS=3.14P
+ AD=3.14P PS=11.14U PD=11.14U
M$616 DUT_OUT$76 \$545 IN|INV_OUT|OUT VDD_DEC pfet_05v0 L=0.5U W=6U AS=3.14P
+ AD=3.14P PS=11.14U PD=11.14U
M$619 DUT_OUT$78 \$533 IN|INV_OUT|OUT VDD_DEC pfet_05v0 L=0.5U W=6U AS=3.14P
+ AD=3.14P PS=11.14U PD=11.14U
M$622 DUT_OUT$79 \$534 IN|INV_OUT|OUT VDD_DEC pfet_05v0 L=0.5U W=6U AS=3.14P
+ AD=3.14P PS=11.14U PD=11.14U
M$625 \$535 SEL$64 VDD_DEC VDD_DEC pfet_05v0 L=0.5U W=2U AS=1.54P AD=1.54P
+ PS=5.54U PD=5.54U
M$626 \$536 SEL$65 VDD_DEC VDD_DEC pfet_05v0 L=0.5U W=2U AS=1.54P AD=1.54P
+ PS=5.54U PD=5.54U
M$627 \$537 SEL$66 VDD_DEC VDD_DEC pfet_05v0 L=0.5U W=2U AS=1.54P AD=1.54P
+ PS=5.54U PD=5.54U
M$628 \$538 SEL$67 VDD_DEC VDD_DEC pfet_05v0 L=0.5U W=2U AS=1.54P AD=1.54P
+ PS=5.54U PD=5.54U
M$629 \$531 SEL$68 VDD_DEC VDD_DEC pfet_05v0 L=0.5U W=2U AS=1.54P AD=1.54P
+ PS=5.54U PD=5.54U
M$630 \$539 SEL$69 VDD_DEC VDD_DEC pfet_05v0 L=0.5U W=2U AS=1.54P AD=1.54P
+ PS=5.54U PD=5.54U
M$631 \$540 SEL$70 VDD_DEC VDD_DEC pfet_05v0 L=0.5U W=2U AS=1.54P AD=1.54P
+ PS=5.54U PD=5.54U
M$632 \$541 SEL$71 VDD_DEC VDD_DEC pfet_05v0 L=0.5U W=2U AS=1.54P AD=1.54P
+ PS=5.54U PD=5.54U
M$633 \$542 SEL$72 VDD_DEC VDD_DEC pfet_05v0 L=0.5U W=2U AS=1.54P AD=1.54P
+ PS=5.54U PD=5.54U
M$634 \$543 SEL$73 VDD_DEC VDD_DEC pfet_05v0 L=0.5U W=2U AS=1.54P AD=1.54P
+ PS=5.54U PD=5.54U
M$635 \$544 SEL$74 VDD_DEC VDD_DEC pfet_05v0 L=0.5U W=2U AS=1.54P AD=1.54P
+ PS=5.54U PD=5.54U
M$636 \$532 SEL$75 VDD_DEC VDD_DEC pfet_05v0 L=0.5U W=2U AS=1.54P AD=1.54P
+ PS=5.54U PD=5.54U
M$637 \$545 SEL$76 VDD_DEC VDD_DEC pfet_05v0 L=0.5U W=2U AS=1.54P AD=1.54P
+ PS=5.54U PD=5.54U
M$638 \$546 SEL$77 VDD_DEC VDD_DEC pfet_05v0 L=0.5U W=2U AS=1.54P AD=1.54P
+ PS=5.54U PD=5.54U
M$639 \$533 SEL$78 VDD_DEC VDD_DEC pfet_05v0 L=0.5U W=2U AS=1.54P AD=1.54P
+ PS=5.54U PD=5.54U
M$640 \$534 SEL$79 VDD_DEC VDD_DEC pfet_05v0 L=0.5U W=2U AS=1.54P AD=1.54P
+ PS=5.54U PD=5.54U
M$641 DUT_OUT|IN|INV_IN|OUT \$629 DUT_IN$80 VDD_DEC pfet_05v0 L=0.5U W=6U
+ AS=3.14P AD=3.14P PS=11.14U PD=11.14U
M$644 DUT_OUT|IN|INV_IN|OUT \$630 DUT_IN$81 VDD_DEC pfet_05v0 L=0.5U W=6U
+ AS=3.14P AD=3.14P PS=11.14U PD=11.14U
M$647 DUT_OUT|IN|INV_IN|OUT \$631 DUT_IN$82 VDD_DEC pfet_05v0 L=0.5U W=6U
+ AS=3.14P AD=3.14P PS=11.14U PD=11.14U
M$650 DUT_OUT|IN|INV_IN|OUT \$632 DUT_IN$83 VDD_DEC pfet_05v0 L=0.5U W=6U
+ AS=3.14P AD=3.14P PS=11.14U PD=11.14U
M$653 DUT_OUT|IN|INV_IN|OUT \$633 DUT_IN$84 VDD_DEC pfet_05v0 L=0.5U W=6U
+ AS=3.14P AD=3.14P PS=11.14U PD=11.14U
M$656 DUT_OUT|IN|INV_IN|OUT \$634 DUT_IN$85 VDD_DEC pfet_05v0 L=0.5U W=6U
+ AS=3.14P AD=3.14P PS=11.14U PD=11.14U
M$659 DUT_OUT|IN|INV_IN|OUT \$635 DUT_IN$86 VDD_DEC pfet_05v0 L=0.5U W=6U
+ AS=3.14P AD=3.14P PS=11.14U PD=11.14U
M$662 DUT_OUT|IN|INV_IN|OUT \$636 DUT_IN$87 VDD_DEC pfet_05v0 L=0.5U W=6U
+ AS=3.14P AD=3.14P PS=11.14U PD=11.14U
M$665 DUT_OUT|IN|INV_IN|OUT \$637 DUT_IN$88 VDD_DEC pfet_05v0 L=0.5U W=6U
+ AS=3.14P AD=3.14P PS=11.14U PD=11.14U
M$668 DUT_OUT|IN|INV_IN|OUT \$638 DUT_IN$89 VDD_DEC pfet_05v0 L=0.5U W=6U
+ AS=3.14P AD=3.14P PS=11.14U PD=11.14U
M$671 DUT_OUT|IN|INV_IN|OUT \$639 DUT_IN$90 VDD_DEC pfet_05v0 L=0.5U W=6U
+ AS=3.14P AD=3.14P PS=11.14U PD=11.14U
M$674 DUT_OUT|IN|INV_IN|OUT \$640 DUT_IN$91 VDD_DEC pfet_05v0 L=0.5U W=6U
+ AS=3.14P AD=3.14P PS=11.14U PD=11.14U
M$677 DUT_OUT|IN|INV_IN|OUT \$641 DUT_IN$92 VDD_DEC pfet_05v0 L=0.5U W=6U
+ AS=3.14P AD=3.14P PS=11.14U PD=11.14U
M$680 DUT_OUT|IN|INV_IN|OUT \$642 DUT_IN$93 VDD_DEC pfet_05v0 L=0.5U W=6U
+ AS=3.14P AD=3.14P PS=11.14U PD=11.14U
M$683 DUT_OUT|IN|INV_IN|OUT \$643 DUT_IN$94 VDD_DEC pfet_05v0 L=0.5U W=6U
+ AS=3.14P AD=3.14P PS=11.14U PD=11.14U
M$686 DUT_OUT|IN|INV_IN|OUT \$644 DUT_IN$95 VDD_DEC pfet_05v0 L=0.5U W=6U
+ AS=3.14P AD=3.14P PS=11.14U PD=11.14U
M$689 \$629 SEL$80 VDD_DEC VDD_DEC pfet_05v0 L=0.5U W=2U AS=1.54P AD=1.54P
+ PS=5.54U PD=5.54U
M$690 \$630 SEL$81 VDD_DEC VDD_DEC pfet_05v0 L=0.5U W=2U AS=1.54P AD=1.54P
+ PS=5.54U PD=5.54U
M$691 \$631 SEL$82 VDD_DEC VDD_DEC pfet_05v0 L=0.5U W=2U AS=1.54P AD=1.54P
+ PS=5.54U PD=5.54U
M$692 \$632 SEL$83 VDD_DEC VDD_DEC pfet_05v0 L=0.5U W=2U AS=1.54P AD=1.54P
+ PS=5.54U PD=5.54U
M$693 \$633 SEL$84 VDD_DEC VDD_DEC pfet_05v0 L=0.5U W=2U AS=1.54P AD=1.54P
+ PS=5.54U PD=5.54U
M$694 \$634 SEL$85 VDD_DEC VDD_DEC pfet_05v0 L=0.5U W=2U AS=1.54P AD=1.54P
+ PS=5.54U PD=5.54U
M$695 \$635 SEL$86 VDD_DEC VDD_DEC pfet_05v0 L=0.5U W=2U AS=1.54P AD=1.54P
+ PS=5.54U PD=5.54U
M$696 \$636 SEL$87 VDD_DEC VDD_DEC pfet_05v0 L=0.5U W=2U AS=1.54P AD=1.54P
+ PS=5.54U PD=5.54U
M$697 \$637 SEL$88 VDD_DEC VDD_DEC pfet_05v0 L=0.5U W=2U AS=1.54P AD=1.54P
+ PS=5.54U PD=5.54U
M$698 \$638 SEL$89 VDD_DEC VDD_DEC pfet_05v0 L=0.5U W=2U AS=1.54P AD=1.54P
+ PS=5.54U PD=5.54U
M$699 \$639 SEL$90 VDD_DEC VDD_DEC pfet_05v0 L=0.5U W=2U AS=1.54P AD=1.54P
+ PS=5.54U PD=5.54U
M$700 \$640 SEL$91 VDD_DEC VDD_DEC pfet_05v0 L=0.5U W=2U AS=1.54P AD=1.54P
+ PS=5.54U PD=5.54U
M$701 \$641 SEL$92 VDD_DEC VDD_DEC pfet_05v0 L=0.5U W=2U AS=1.54P AD=1.54P
+ PS=5.54U PD=5.54U
M$702 \$642 SEL$93 VDD_DEC VDD_DEC pfet_05v0 L=0.5U W=2U AS=1.54P AD=1.54P
+ PS=5.54U PD=5.54U
M$703 \$643 SEL$94 VDD_DEC VDD_DEC pfet_05v0 L=0.5U W=2U AS=1.54P AD=1.54P
+ PS=5.54U PD=5.54U
M$704 \$644 SEL$95 VDD_DEC VDD_DEC pfet_05v0 L=0.5U W=2U AS=1.54P AD=1.54P
+ PS=5.54U PD=5.54U
M$705 DUT_OUT$80 \$646 IN|INV_OUT|OUT VDD_DEC pfet_05v0 L=0.5U W=6U AS=3.14P
+ AD=3.14P PS=11.14U PD=11.14U
M$708 DUT_OUT$81 \$647 IN|INV_OUT|OUT VDD_DEC pfet_05v0 L=0.5U W=6U AS=3.14P
+ AD=3.14P PS=11.14U PD=11.14U
M$711 DUT_OUT$82 \$648 IN|INV_OUT|OUT VDD_DEC pfet_05v0 L=0.5U W=6U AS=3.14P
+ AD=3.14P PS=11.14U PD=11.14U
M$714 DUT_OUT$83 \$649 IN|INV_OUT|OUT VDD_DEC pfet_05v0 L=0.5U W=6U AS=3.14P
+ AD=3.14P PS=11.14U PD=11.14U
M$717 DUT_OUT$84 \$650 IN|INV_OUT|OUT VDD_DEC pfet_05v0 L=0.5U W=6U AS=3.14P
+ AD=3.14P PS=11.14U PD=11.14U
M$720 DUT_OUT$85 \$651 IN|INV_OUT|OUT VDD_DEC pfet_05v0 L=0.5U W=6U AS=3.14P
+ AD=3.14P PS=11.14U PD=11.14U
M$723 DUT_OUT$86 \$652 IN|INV_OUT|OUT VDD_DEC pfet_05v0 L=0.5U W=6U AS=3.14P
+ AD=3.14P PS=11.14U PD=11.14U
M$726 DUT_OUT$88 \$654 IN|INV_OUT|OUT VDD_DEC pfet_05v0 L=0.5U W=6U AS=3.14P
+ AD=3.14P PS=11.14U PD=11.14U
M$729 DUT_OUT$89 \$655 IN|INV_OUT|OUT VDD_DEC pfet_05v0 L=0.5U W=6U AS=3.14P
+ AD=3.14P PS=11.14U PD=11.14U
M$732 DUT_OUT$90 \$656 IN|INV_OUT|OUT VDD_DEC pfet_05v0 L=0.5U W=6U AS=3.14P
+ AD=3.14P PS=11.14U PD=11.14U
M$735 DUT_OUT$91 \$657 IN|INV_OUT|OUT VDD_DEC pfet_05v0 L=0.5U W=6U AS=3.14P
+ AD=3.14P PS=11.14U PD=11.14U
M$738 DUT_OUT$92 \$658 IN|INV_OUT|OUT VDD_DEC pfet_05v0 L=0.5U W=6U AS=3.14P
+ AD=3.14P PS=11.14U PD=11.14U
M$741 DUT_OUT$93 \$659 IN|INV_OUT|OUT VDD_DEC pfet_05v0 L=0.5U W=6U AS=3.14P
+ AD=3.14P PS=11.14U PD=11.14U
M$744 DUT_OUT$94 \$660 IN|INV_OUT|OUT VDD_DEC pfet_05v0 L=0.5U W=6U AS=3.14P
+ AD=3.14P PS=11.14U PD=11.14U
M$747 DUT_OUT$95 \$661 IN|INV_OUT|OUT VDD_DEC pfet_05v0 L=0.5U W=6U AS=3.14P
+ AD=3.14P PS=11.14U PD=11.14U
M$750 DUT_OUT$87 \$653 IN|INV_OUT|OUT VDD_DEC pfet_05v0 L=0.5U W=6U AS=3.14P
+ AD=3.14P PS=11.14U PD=11.14U
M$753 \$646 SEL$80 VDD_DEC VDD_DEC pfet_05v0 L=0.5U W=2U AS=1.54P AD=1.54P
+ PS=5.54U PD=5.54U
M$754 \$647 SEL$81 VDD_DEC VDD_DEC pfet_05v0 L=0.5U W=2U AS=1.54P AD=1.54P
+ PS=5.54U PD=5.54U
M$755 \$648 SEL$82 VDD_DEC VDD_DEC pfet_05v0 L=0.5U W=2U AS=1.54P AD=1.54P
+ PS=5.54U PD=5.54U
M$756 \$649 SEL$83 VDD_DEC VDD_DEC pfet_05v0 L=0.5U W=2U AS=1.54P AD=1.54P
+ PS=5.54U PD=5.54U
M$757 \$650 SEL$84 VDD_DEC VDD_DEC pfet_05v0 L=0.5U W=2U AS=1.54P AD=1.54P
+ PS=5.54U PD=5.54U
M$758 \$651 SEL$85 VDD_DEC VDD_DEC pfet_05v0 L=0.5U W=2U AS=1.54P AD=1.54P
+ PS=5.54U PD=5.54U
M$759 \$652 SEL$86 VDD_DEC VDD_DEC pfet_05v0 L=0.5U W=2U AS=1.54P AD=1.54P
+ PS=5.54U PD=5.54U
M$760 \$653 SEL$87 VDD_DEC VDD_DEC pfet_05v0 L=0.5U W=2U AS=1.54P AD=1.54P
+ PS=5.54U PD=5.54U
M$761 \$654 SEL$88 VDD_DEC VDD_DEC pfet_05v0 L=0.5U W=2U AS=1.54P AD=1.54P
+ PS=5.54U PD=5.54U
M$762 \$655 SEL$89 VDD_DEC VDD_DEC pfet_05v0 L=0.5U W=2U AS=1.54P AD=1.54P
+ PS=5.54U PD=5.54U
M$763 \$656 SEL$90 VDD_DEC VDD_DEC pfet_05v0 L=0.5U W=2U AS=1.54P AD=1.54P
+ PS=5.54U PD=5.54U
M$764 \$657 SEL$91 VDD_DEC VDD_DEC pfet_05v0 L=0.5U W=2U AS=1.54P AD=1.54P
+ PS=5.54U PD=5.54U
M$765 \$658 SEL$92 VDD_DEC VDD_DEC pfet_05v0 L=0.5U W=2U AS=1.54P AD=1.54P
+ PS=5.54U PD=5.54U
M$766 \$659 SEL$93 VDD_DEC VDD_DEC pfet_05v0 L=0.5U W=2U AS=1.54P AD=1.54P
+ PS=5.54U PD=5.54U
M$767 \$660 SEL$94 VDD_DEC VDD_DEC pfet_05v0 L=0.5U W=2U AS=1.54P AD=1.54P
+ PS=5.54U PD=5.54U
M$768 \$661 SEL$95 VDD_DEC VDD_DEC pfet_05v0 L=0.5U W=2U AS=1.54P AD=1.54P
+ PS=5.54U PD=5.54U
M$769 DUT_OUT|IN|INV_IN|OUT \$746 DUT_IN$98 VDD_DEC pfet_05v0 L=0.5U W=6U
+ AS=3.14P AD=3.14P PS=11.14U PD=11.14U
M$772 DUT_OUT|IN|INV_IN|OUT \$747 DUT_IN$99 VDD_DEC pfet_05v0 L=0.5U W=6U
+ AS=3.14P AD=3.14P PS=11.14U PD=11.14U
M$775 DUT_OUT|IN|INV_IN|OUT \$748 DUT_IN$100 VDD_DEC pfet_05v0 L=0.5U W=6U
+ AS=3.14P AD=3.14P PS=11.14U PD=11.14U
M$778 DUT_OUT|IN|INV_IN|OUT \$749 DUT_IN$101 VDD_DEC pfet_05v0 L=0.5U W=6U
+ AS=3.14P AD=3.14P PS=11.14U PD=11.14U
M$781 DUT_OUT|IN|INV_IN|OUT \$750 DUT_IN$102 VDD_DEC pfet_05v0 L=0.5U W=6U
+ AS=3.14P AD=3.14P PS=11.14U PD=11.14U
M$784 DUT_OUT|IN|INV_IN|OUT \$752 DUT_IN$104 VDD_DEC pfet_05v0 L=0.5U W=6U
+ AS=3.14P AD=3.14P PS=11.14U PD=11.14U
M$787 DUT_OUT|IN|INV_IN|OUT \$753 DUT_IN$105 VDD_DEC pfet_05v0 L=0.5U W=6U
+ AS=3.14P AD=3.14P PS=11.14U PD=11.14U
M$790 DUT_OUT|IN|INV_IN|OUT \$754 DUT_IN$106 VDD_DEC pfet_05v0 L=0.5U W=6U
+ AS=3.14P AD=3.14P PS=11.14U PD=11.14U
M$793 DUT_OUT|IN|INV_IN|OUT \$755 DUT_IN$107 VDD_DEC pfet_05v0 L=0.5U W=6U
+ AS=3.14P AD=3.14P PS=11.14U PD=11.14U
M$796 DUT_OUT|IN|INV_IN|OUT \$756 DUT_IN$108 VDD_DEC pfet_05v0 L=0.5U W=6U
+ AS=3.14P AD=3.14P PS=11.14U PD=11.14U
M$799 DUT_OUT|IN|INV_IN|OUT \$757 DUT_IN$109 VDD_DEC pfet_05v0 L=0.5U W=6U
+ AS=3.14P AD=3.14P PS=11.14U PD=11.14U
M$802 DUT_OUT|IN|INV_IN|OUT \$758 DUT_IN$110 VDD_DEC pfet_05v0 L=0.5U W=6U
+ AS=3.14P AD=3.14P PS=11.14U PD=11.14U
M$805 DUT_OUT|IN|INV_IN|OUT \$759 DUT_IN$111 VDD_DEC pfet_05v0 L=0.5U W=6U
+ AS=3.14P AD=3.14P PS=11.14U PD=11.14U
M$808 DUT_OUT|IN|INV_IN|OUT \$744 DUT_IN$96 VDD_DEC pfet_05v0 L=0.5U W=6U
+ AS=3.14P AD=3.14P PS=11.14U PD=11.14U
M$811 DUT_OUT|IN|INV_IN|OUT \$745 DUT_IN$97 VDD_DEC pfet_05v0 L=0.5U W=6U
+ AS=3.14P AD=3.14P PS=11.14U PD=11.14U
M$814 DUT_OUT|IN|INV_IN|OUT \$751 DUT_IN$103 VDD_DEC pfet_05v0 L=0.5U W=6U
+ AS=3.14P AD=3.14P PS=11.14U PD=11.14U
M$817 \$744 SEL$96 VDD_DEC VDD_DEC pfet_05v0 L=0.5U W=2U AS=1.54P AD=1.54P
+ PS=5.54U PD=5.54U
M$818 \$745 SEL$97 VDD_DEC VDD_DEC pfet_05v0 L=0.5U W=2U AS=1.54P AD=1.54P
+ PS=5.54U PD=5.54U
M$819 \$746 SEL$98 VDD_DEC VDD_DEC pfet_05v0 L=0.5U W=2U AS=1.54P AD=1.54P
+ PS=5.54U PD=5.54U
M$820 \$747 SEL$99 VDD_DEC VDD_DEC pfet_05v0 L=0.5U W=2U AS=1.54P AD=1.54P
+ PS=5.54U PD=5.54U
M$821 \$748 SEL$100 VDD_DEC VDD_DEC pfet_05v0 L=0.5U W=2U AS=1.54P AD=1.54P
+ PS=5.54U PD=5.54U
M$822 \$749 SEL$101 VDD_DEC VDD_DEC pfet_05v0 L=0.5U W=2U AS=1.54P AD=1.54P
+ PS=5.54U PD=5.54U
M$823 \$750 SEL$102 VDD_DEC VDD_DEC pfet_05v0 L=0.5U W=2U AS=1.54P AD=1.54P
+ PS=5.54U PD=5.54U
M$824 \$751 SEL$103 VDD_DEC VDD_DEC pfet_05v0 L=0.5U W=2U AS=1.54P AD=1.54P
+ PS=5.54U PD=5.54U
M$825 \$752 SEL$104 VDD_DEC VDD_DEC pfet_05v0 L=0.5U W=2U AS=1.54P AD=1.54P
+ PS=5.54U PD=5.54U
M$826 \$753 SEL$105 VDD_DEC VDD_DEC pfet_05v0 L=0.5U W=2U AS=1.54P AD=1.54P
+ PS=5.54U PD=5.54U
M$827 \$754 SEL$106 VDD_DEC VDD_DEC pfet_05v0 L=0.5U W=2U AS=1.54P AD=1.54P
+ PS=5.54U PD=5.54U
M$828 \$755 SEL$107 VDD_DEC VDD_DEC pfet_05v0 L=0.5U W=2U AS=1.54P AD=1.54P
+ PS=5.54U PD=5.54U
M$829 \$756 SEL$108 VDD_DEC VDD_DEC pfet_05v0 L=0.5U W=2U AS=1.54P AD=1.54P
+ PS=5.54U PD=5.54U
M$830 \$757 SEL$109 VDD_DEC VDD_DEC pfet_05v0 L=0.5U W=2U AS=1.54P AD=1.54P
+ PS=5.54U PD=5.54U
M$831 \$758 SEL$110 VDD_DEC VDD_DEC pfet_05v0 L=0.5U W=2U AS=1.54P AD=1.54P
+ PS=5.54U PD=5.54U
M$832 \$759 SEL$111 VDD_DEC VDD_DEC pfet_05v0 L=0.5U W=2U AS=1.54P AD=1.54P
+ PS=5.54U PD=5.54U
M$833 DUT_OUT$96 \$777 IN|INV_OUT|OUT VDD_DEC pfet_05v0 L=0.5U W=6U AS=3.14P
+ AD=3.14P PS=11.14U PD=11.14U
M$836 DUT_OUT$97 \$778 IN|INV_OUT|OUT VDD_DEC pfet_05v0 L=0.5U W=6U AS=3.14P
+ AD=3.14P PS=11.14U PD=11.14U
M$839 DUT_OUT$98 \$779 IN|INV_OUT|OUT VDD_DEC pfet_05v0 L=0.5U W=6U AS=3.14P
+ AD=3.14P PS=11.14U PD=11.14U
M$842 DUT_OUT$99 \$780 IN|INV_OUT|OUT VDD_DEC pfet_05v0 L=0.5U W=6U AS=3.14P
+ AD=3.14P PS=11.14U PD=11.14U
M$845 DUT_OUT$100 \$781 IN|INV_OUT|OUT VDD_DEC pfet_05v0 L=0.5U W=6U AS=3.14P
+ AD=3.14P PS=11.14U PD=11.14U
M$848 DUT_OUT$101 \$782 IN|INV_OUT|OUT VDD_DEC pfet_05v0 L=0.5U W=6U AS=3.14P
+ AD=3.14P PS=11.14U PD=11.14U
M$851 DUT_OUT$102 \$783 IN|INV_OUT|OUT VDD_DEC pfet_05v0 L=0.5U W=6U AS=3.14P
+ AD=3.14P PS=11.14U PD=11.14U
M$854 DUT_OUT$103 \$784 IN|INV_OUT|OUT VDD_DEC pfet_05v0 L=0.5U W=6U AS=3.14P
+ AD=3.14P PS=11.14U PD=11.14U
M$857 DUT_OUT$104 \$785 IN|INV_OUT|OUT VDD_DEC pfet_05v0 L=0.5U W=6U AS=3.14P
+ AD=3.14P PS=11.14U PD=11.14U
M$860 DUT_OUT$105 \$786 IN|INV_OUT|OUT VDD_DEC pfet_05v0 L=0.5U W=6U AS=3.14P
+ AD=3.14P PS=11.14U PD=11.14U
M$863 DUT_OUT$106 \$787 IN|INV_OUT|OUT VDD_DEC pfet_05v0 L=0.5U W=6U AS=3.14P
+ AD=3.14P PS=11.14U PD=11.14U
M$866 DUT_OUT$107 \$788 IN|INV_OUT|OUT VDD_DEC pfet_05v0 L=0.5U W=6U AS=3.14P
+ AD=3.14P PS=11.14U PD=11.14U
M$869 DUT_OUT$108 \$789 IN|INV_OUT|OUT VDD_DEC pfet_05v0 L=0.5U W=6U AS=3.14P
+ AD=3.14P PS=11.14U PD=11.14U
M$872 DUT_OUT$109 \$790 IN|INV_OUT|OUT VDD_DEC pfet_05v0 L=0.5U W=6U AS=3.14P
+ AD=3.14P PS=11.14U PD=11.14U
M$875 DUT_OUT$110 \$791 IN|INV_OUT|OUT VDD_DEC pfet_05v0 L=0.5U W=6U AS=3.14P
+ AD=3.14P PS=11.14U PD=11.14U
M$878 DUT_OUT$111 \$792 IN|INV_OUT|OUT VDD_DEC pfet_05v0 L=0.5U W=6U AS=3.14P
+ AD=3.14P PS=11.14U PD=11.14U
M$881 \$777 SEL$96 VDD_DEC VDD_DEC pfet_05v0 L=0.5U W=2U AS=1.54P AD=1.54P
+ PS=5.54U PD=5.54U
M$882 \$778 SEL$97 VDD_DEC VDD_DEC pfet_05v0 L=0.5U W=2U AS=1.54P AD=1.54P
+ PS=5.54U PD=5.54U
M$883 \$779 SEL$98 VDD_DEC VDD_DEC pfet_05v0 L=0.5U W=2U AS=1.54P AD=1.54P
+ PS=5.54U PD=5.54U
M$884 \$780 SEL$99 VDD_DEC VDD_DEC pfet_05v0 L=0.5U W=2U AS=1.54P AD=1.54P
+ PS=5.54U PD=5.54U
M$885 \$781 SEL$100 VDD_DEC VDD_DEC pfet_05v0 L=0.5U W=2U AS=1.54P AD=1.54P
+ PS=5.54U PD=5.54U
M$886 \$782 SEL$101 VDD_DEC VDD_DEC pfet_05v0 L=0.5U W=2U AS=1.54P AD=1.54P
+ PS=5.54U PD=5.54U
M$887 \$783 SEL$102 VDD_DEC VDD_DEC pfet_05v0 L=0.5U W=2U AS=1.54P AD=1.54P
+ PS=5.54U PD=5.54U
M$888 \$784 SEL$103 VDD_DEC VDD_DEC pfet_05v0 L=0.5U W=2U AS=1.54P AD=1.54P
+ PS=5.54U PD=5.54U
M$889 \$785 SEL$104 VDD_DEC VDD_DEC pfet_05v0 L=0.5U W=2U AS=1.54P AD=1.54P
+ PS=5.54U PD=5.54U
M$890 \$786 SEL$105 VDD_DEC VDD_DEC pfet_05v0 L=0.5U W=2U AS=1.54P AD=1.54P
+ PS=5.54U PD=5.54U
M$891 \$787 SEL$106 VDD_DEC VDD_DEC pfet_05v0 L=0.5U W=2U AS=1.54P AD=1.54P
+ PS=5.54U PD=5.54U
M$892 \$788 SEL$107 VDD_DEC VDD_DEC pfet_05v0 L=0.5U W=2U AS=1.54P AD=1.54P
+ PS=5.54U PD=5.54U
M$893 \$789 SEL$108 VDD_DEC VDD_DEC pfet_05v0 L=0.5U W=2U AS=1.54P AD=1.54P
+ PS=5.54U PD=5.54U
M$894 \$790 SEL$109 VDD_DEC VDD_DEC pfet_05v0 L=0.5U W=2U AS=1.54P AD=1.54P
+ PS=5.54U PD=5.54U
M$895 \$791 SEL$110 VDD_DEC VDD_DEC pfet_05v0 L=0.5U W=2U AS=1.54P AD=1.54P
+ PS=5.54U PD=5.54U
M$896 \$792 SEL$111 VDD_DEC VDD_DEC pfet_05v0 L=0.5U W=2U AS=1.54P AD=1.54P
+ PS=5.54U PD=5.54U
M$897 DUT_OUT|IN|INV_IN|OUT \$859 DUT_IN$112 VDD_DEC pfet_05v0 L=0.5U W=6U
+ AS=3.14P AD=3.14P PS=11.14U PD=11.14U
M$900 DUT_OUT|IN|INV_IN|OUT \$860 DUT_IN$113 VDD_DEC pfet_05v0 L=0.5U W=6U
+ AS=3.14P AD=3.14P PS=11.14U PD=11.14U
M$903 DUT_OUT|IN|INV_IN|OUT \$861 DUT_IN$114 VDD_DEC pfet_05v0 L=0.5U W=6U
+ AS=3.14P AD=3.14P PS=11.14U PD=11.14U
M$906 DUT_OUT|IN|INV_IN|OUT \$862 DUT_IN$115 VDD_DEC pfet_05v0 L=0.5U W=6U
+ AS=3.14P AD=3.14P PS=11.14U PD=11.14U
M$909 DUT_OUT|IN|INV_IN|OUT \$863 DUT_IN$116 VDD_DEC pfet_05v0 L=0.5U W=6U
+ AS=3.14P AD=3.14P PS=11.14U PD=11.14U
M$912 DUT_OUT|IN|INV_IN|OUT \$864 DUT_IN$117 VDD_DEC pfet_05v0 L=0.5U W=6U
+ AS=3.14P AD=3.14P PS=11.14U PD=11.14U
M$915 DUT_OUT|IN|INV_IN|OUT \$865 DUT_IN$118 VDD_DEC pfet_05v0 L=0.5U W=6U
+ AS=3.14P AD=3.14P PS=11.14U PD=11.14U
M$918 DUT_OUT|IN|INV_IN|OUT \$866 DUT_IN$119 VDD_DEC pfet_05v0 L=0.5U W=6U
+ AS=3.14P AD=3.14P PS=11.14U PD=11.14U
M$921 DUT_OUT|IN|INV_IN|OUT \$867 DUT_IN$120 VDD_DEC pfet_05v0 L=0.5U W=6U
+ AS=3.14P AD=3.14P PS=11.14U PD=11.14U
M$924 DUT_OUT|IN|INV_IN|OUT \$868 DUT_IN$121 VDD_DEC pfet_05v0 L=0.5U W=6U
+ AS=3.14P AD=3.14P PS=11.14U PD=11.14U
M$927 DUT_OUT|IN|INV_IN|OUT \$869 DUT_IN$122 VDD_DEC pfet_05v0 L=0.5U W=6U
+ AS=3.14P AD=3.14P PS=11.14U PD=11.14U
M$930 DUT_OUT|IN|INV_IN|OUT \$871 DUT_IN$124 VDD_DEC pfet_05v0 L=0.5U W=6U
+ AS=3.14P AD=3.14P PS=11.14U PD=11.14U
M$933 DUT_OUT|IN|INV_IN|OUT \$872 DUT_IN$125 VDD_DEC pfet_05v0 L=0.5U W=6U
+ AS=3.14P AD=3.14P PS=11.14U PD=11.14U
M$936 DUT_OUT|IN|INV_IN|OUT \$873 DUT_IN$126 VDD_DEC pfet_05v0 L=0.5U W=6U
+ AS=3.14P AD=3.14P PS=11.14U PD=11.14U
M$939 DUT_OUT|IN|INV_IN|OUT \$870 DUT_IN$123 VDD_DEC pfet_05v0 L=0.5U W=6U
+ AS=3.14P AD=3.14P PS=11.14U PD=11.14U
M$942 DUT_OUT|IN|INV_IN|OUT \$874 DUT_IN$127 VDD_DEC pfet_05v0 L=0.5U W=6U
+ AS=3.14P AD=3.14P PS=11.14U PD=11.14U
M$945 \$859 SEL$112 VDD_DEC VDD_DEC pfet_05v0 L=0.5U W=2U AS=1.54P AD=1.54P
+ PS=5.54U PD=5.54U
M$946 \$860 SEL$113 VDD_DEC VDD_DEC pfet_05v0 L=0.5U W=2U AS=1.54P AD=1.54P
+ PS=5.54U PD=5.54U
M$947 \$861 SEL$114 VDD_DEC VDD_DEC pfet_05v0 L=0.5U W=2U AS=1.54P AD=1.54P
+ PS=5.54U PD=5.54U
M$948 \$862 SEL$115 VDD_DEC VDD_DEC pfet_05v0 L=0.5U W=2U AS=1.54P AD=1.54P
+ PS=5.54U PD=5.54U
M$949 \$863 SEL$116 VDD_DEC VDD_DEC pfet_05v0 L=0.5U W=2U AS=1.54P AD=1.54P
+ PS=5.54U PD=5.54U
M$950 \$864 SEL$117 VDD_DEC VDD_DEC pfet_05v0 L=0.5U W=2U AS=1.54P AD=1.54P
+ PS=5.54U PD=5.54U
M$951 \$865 SEL$118 VDD_DEC VDD_DEC pfet_05v0 L=0.5U W=2U AS=1.54P AD=1.54P
+ PS=5.54U PD=5.54U
M$952 \$866 SEL$119 VDD_DEC VDD_DEC pfet_05v0 L=0.5U W=2U AS=1.54P AD=1.54P
+ PS=5.54U PD=5.54U
M$953 \$867 SEL$120 VDD_DEC VDD_DEC pfet_05v0 L=0.5U W=2U AS=1.54P AD=1.54P
+ PS=5.54U PD=5.54U
M$954 \$868 SEL$121 VDD_DEC VDD_DEC pfet_05v0 L=0.5U W=2U AS=1.54P AD=1.54P
+ PS=5.54U PD=5.54U
M$955 \$869 SEL$122 VDD_DEC VDD_DEC pfet_05v0 L=0.5U W=2U AS=1.54P AD=1.54P
+ PS=5.54U PD=5.54U
M$956 \$870 SEL$123 VDD_DEC VDD_DEC pfet_05v0 L=0.5U W=2U AS=1.54P AD=1.54P
+ PS=5.54U PD=5.54U
M$957 \$871 SEL$124 VDD_DEC VDD_DEC pfet_05v0 L=0.5U W=2U AS=1.54P AD=1.54P
+ PS=5.54U PD=5.54U
M$958 \$872 SEL$125 VDD_DEC VDD_DEC pfet_05v0 L=0.5U W=2U AS=1.54P AD=1.54P
+ PS=5.54U PD=5.54U
M$959 \$873 SEL$126 VDD_DEC VDD_DEC pfet_05v0 L=0.5U W=2U AS=1.54P AD=1.54P
+ PS=5.54U PD=5.54U
M$960 \$874 SEL$127 VDD_DEC VDD_DEC pfet_05v0 L=0.5U W=2U AS=1.54P AD=1.54P
+ PS=5.54U PD=5.54U
M$961 DUT_OUT$112 \$876 IN|INV_OUT|OUT VDD_DEC pfet_05v0 L=0.5U W=6U AS=3.14P
+ AD=3.14P PS=11.14U PD=11.14U
M$964 DUT_OUT$113 \$877 IN|INV_OUT|OUT VDD_DEC pfet_05v0 L=0.5U W=6U AS=3.14P
+ AD=3.14P PS=11.14U PD=11.14U
M$967 DUT_OUT$114 \$878 IN|INV_OUT|OUT VDD_DEC pfet_05v0 L=0.5U W=6U AS=3.14P
+ AD=3.14P PS=11.14U PD=11.14U
M$970 DUT_OUT$115 \$879 IN|INV_OUT|OUT VDD_DEC pfet_05v0 L=0.5U W=6U AS=3.14P
+ AD=3.14P PS=11.14U PD=11.14U
M$973 DUT_OUT$116 \$880 IN|INV_OUT|OUT VDD_DEC pfet_05v0 L=0.5U W=6U AS=3.14P
+ AD=3.14P PS=11.14U PD=11.14U
M$976 DUT_OUT$117 \$881 IN|INV_OUT|OUT VDD_DEC pfet_05v0 L=0.5U W=6U AS=3.14P
+ AD=3.14P PS=11.14U PD=11.14U
M$979 DUT_OUT$118 \$882 IN|INV_OUT|OUT VDD_DEC pfet_05v0 L=0.5U W=6U AS=3.14P
+ AD=3.14P PS=11.14U PD=11.14U
M$982 DUT_OUT$119 \$883 IN|INV_OUT|OUT VDD_DEC pfet_05v0 L=0.5U W=6U AS=3.14P
+ AD=3.14P PS=11.14U PD=11.14U
M$985 DUT_OUT$120 \$884 IN|INV_OUT|OUT VDD_DEC pfet_05v0 L=0.5U W=6U AS=3.14P
+ AD=3.14P PS=11.14U PD=11.14U
M$988 DUT_OUT$121 \$885 IN|INV_OUT|OUT VDD_DEC pfet_05v0 L=0.5U W=6U AS=3.14P
+ AD=3.14P PS=11.14U PD=11.14U
M$991 DUT_OUT$122 \$886 IN|INV_OUT|OUT VDD_DEC pfet_05v0 L=0.5U W=6U AS=3.14P
+ AD=3.14P PS=11.14U PD=11.14U
M$994 DUT_OUT$123 \$887 IN|INV_OUT|OUT VDD_DEC pfet_05v0 L=0.5U W=6U AS=3.14P
+ AD=3.14P PS=11.14U PD=11.14U
M$997 DUT_OUT$124 \$888 IN|INV_OUT|OUT VDD_DEC pfet_05v0 L=0.5U W=6U AS=3.14P
+ AD=3.14P PS=11.14U PD=11.14U
M$1000 DUT_OUT$125 \$889 IN|INV_OUT|OUT VDD_DEC pfet_05v0 L=0.5U W=6U AS=3.14P
+ AD=3.14P PS=11.14U PD=11.14U
M$1003 DUT_OUT$126 \$890 IN|INV_OUT|OUT VDD_DEC pfet_05v0 L=0.5U W=6U AS=3.14P
+ AD=3.14P PS=11.14U PD=11.14U
M$1006 DUT_OUT$127 \$891 IN|INV_OUT|OUT VDD_DEC pfet_05v0 L=0.5U W=6U AS=3.14P
+ AD=3.14P PS=11.14U PD=11.14U
M$1009 \$876 SEL$112 VDD_DEC VDD_DEC pfet_05v0 L=0.5U W=2U AS=1.54P AD=1.54P
+ PS=5.54U PD=5.54U
M$1010 \$877 SEL$113 VDD_DEC VDD_DEC pfet_05v0 L=0.5U W=2U AS=1.54P AD=1.54P
+ PS=5.54U PD=5.54U
M$1011 \$878 SEL$114 VDD_DEC VDD_DEC pfet_05v0 L=0.5U W=2U AS=1.54P AD=1.54P
+ PS=5.54U PD=5.54U
M$1012 \$879 SEL$115 VDD_DEC VDD_DEC pfet_05v0 L=0.5U W=2U AS=1.54P AD=1.54P
+ PS=5.54U PD=5.54U
M$1013 \$880 SEL$116 VDD_DEC VDD_DEC pfet_05v0 L=0.5U W=2U AS=1.54P AD=1.54P
+ PS=5.54U PD=5.54U
M$1014 \$881 SEL$117 VDD_DEC VDD_DEC pfet_05v0 L=0.5U W=2U AS=1.54P AD=1.54P
+ PS=5.54U PD=5.54U
M$1015 \$882 SEL$118 VDD_DEC VDD_DEC pfet_05v0 L=0.5U W=2U AS=1.54P AD=1.54P
+ PS=5.54U PD=5.54U
M$1016 \$883 SEL$119 VDD_DEC VDD_DEC pfet_05v0 L=0.5U W=2U AS=1.54P AD=1.54P
+ PS=5.54U PD=5.54U
M$1017 \$884 SEL$120 VDD_DEC VDD_DEC pfet_05v0 L=0.5U W=2U AS=1.54P AD=1.54P
+ PS=5.54U PD=5.54U
M$1018 \$885 SEL$121 VDD_DEC VDD_DEC pfet_05v0 L=0.5U W=2U AS=1.54P AD=1.54P
+ PS=5.54U PD=5.54U
M$1019 \$886 SEL$122 VDD_DEC VDD_DEC pfet_05v0 L=0.5U W=2U AS=1.54P AD=1.54P
+ PS=5.54U PD=5.54U
M$1020 \$887 SEL$123 VDD_DEC VDD_DEC pfet_05v0 L=0.5U W=2U AS=1.54P AD=1.54P
+ PS=5.54U PD=5.54U
M$1021 \$888 SEL$124 VDD_DEC VDD_DEC pfet_05v0 L=0.5U W=2U AS=1.54P AD=1.54P
+ PS=5.54U PD=5.54U
M$1022 \$889 SEL$125 VDD_DEC VDD_DEC pfet_05v0 L=0.5U W=2U AS=1.54P AD=1.54P
+ PS=5.54U PD=5.54U
M$1023 \$890 SEL$126 VDD_DEC VDD_DEC pfet_05v0 L=0.5U W=2U AS=1.54P AD=1.54P
+ PS=5.54U PD=5.54U
M$1024 \$891 SEL$127 VDD_DEC VDD_DEC pfet_05v0 L=0.5U W=2U AS=1.54P AD=1.54P
+ PS=5.54U PD=5.54U
M$1025 \$938 SEL|VCO_EN VDD_DEC VDD_DEC pfet_05v0 L=0.5U W=2U AS=1.54P AD=1.54P
+ PS=5.54U PD=5.54U
M$1026 IN|INV_OUT|OUT \$938 DUT_IN$128 VDD_DEC pfet_05v0 L=0.5U W=6U AS=3.14P
+ AD=3.14P PS=11.14U PD=11.14U
M$1029 \$935 SEL|VCO_EN VDD_DEC VDD_DEC pfet_05v0 L=0.5U W=2U AS=1.54P AD=1.54P
+ PS=5.54U PD=5.54U
M$1030 IN|INV_OUT|OUT SEL|VCO_EN DUT_IN|OUT VDD_DEC pfet_05v0 L=0.5U W=6U
+ AS=3.14P AD=3.14P PS=11.14U PD=11.14U
M$1033 \$939 SEL|VCO_EN VDD_DEC VDD_DEC pfet_05v0 L=0.5U W=2U AS=1.54P AD=1.54P
+ PS=5.54U PD=5.54U
M$1034 IN|OUT SEL|VCO_EN DUT_OUT|IN|INV_IN|OUT VDD_DEC pfet_05v0 L=0.5U W=6U
+ AS=3.14P AD=3.14P PS=11.14U PD=11.14U
M$1037 \$940 SEL|VCO_EN VDD_DEC VDD_DEC pfet_05v0 L=0.5U W=2U AS=1.54P AD=1.54P
+ PS=5.54U PD=5.54U
M$1038 DUT_OUT$128 \$940 DUT_OUT|IN|INV_IN|OUT VDD_DEC pfet_05v0 L=0.5U W=6U
+ AS=3.14P AD=3.14P PS=11.14U PD=11.14U
M$1041 \$965 \$965 VDD_INV VDD_INV pfet_05v0 L=1U W=16U AS=6.2P AD=5.28P
+ PS=23.1U PD=18.64U
M$1045 \$944 \$965 VDD_INV VDD_INV pfet_05v0 L=1U W=16U AS=5.28P AD=6.2P
+ PS=18.64U PD=23.1U
M$1049 VDD_INV \$965 \$960 VDD_INV pfet_05v0 L=1U W=16U AS=6.2P AD=5.28P
+ PS=23.1U PD=18.64U
M$1053 \$946 DUT_IN$128 \$960 VDD_INV pfet_05v0 L=0.5U W=4U AS=2.16P AD=3.08P
+ PS=5.08U PD=9.54U
M$1054 VDD_INV \$965 \$961 VDD_INV pfet_05v0 L=1U W=16U AS=6.2P AD=5.28P
+ PS=23.1U PD=18.64U
M$1058 \$948 \$946 \$961 VDD_INV pfet_05v0 L=0.5U W=4U AS=2.16P AD=3.08P
+ PS=5.08U PD=9.54U
M$1059 VDD_INV \$965 \$962 VDD_INV pfet_05v0 L=1U W=16U AS=6.2P AD=5.28P
+ PS=23.1U PD=18.64U
M$1063 \$950 \$948 \$962 VDD_INV pfet_05v0 L=0.5U W=4U AS=2.16P AD=3.08P
+ PS=5.08U PD=9.54U
M$1064 \$951 \$950 VDD_INV VDD_INV pfet_05v0 L=0.5U W=2U AS=1.54P AD=1.54P
+ PS=5.54U PD=5.54U
M$1065 VDD_INV \$951 FOUT VDD_INV pfet_05v0 L=0.5U W=8U AS=3.94P AD=3.94P
+ PS=13.94U PD=13.94U
M$1069 VDD_INV \$965 \$963 VDD_INV pfet_05v0 L=1U W=16U AS=6.2P AD=5.28P
+ PS=23.1U PD=18.64U
M$1073 \$954 \$950 \$963 VDD_INV pfet_05v0 L=0.5U W=4U AS=2.16P AD=3.08P
+ PS=5.08U PD=9.54U
M$1074 VDD_INV \$965 \$964 VDD_INV pfet_05v0 L=1U W=16U AS=6.2P AD=5.28P
+ PS=23.1U PD=18.64U
M$1078 \$956 \$954 \$964 VDD_INV pfet_05v0 L=0.5U W=4U AS=2.16P AD=3.08P
+ PS=5.08U PD=9.54U
M$1079 VDD_INV \$965 \$959 VDD_INV pfet_05v0 L=1U W=64U AS=18.68P AD=17.76P
+ PS=77.34U PD=72.88U
M$1095 DUT_OUT$128 \$956 \$959 VDD_INV pfet_05v0 L=0.5U W=12U AS=5.36P AD=6.28P
+ PS=14.68U PD=19.14U
M$1098 DUT_OUT|IN|INV_IN|OUT SEL DUT_IN$10 VSS nfet_05v0 L=0.6U W=2U AS=1.46P
+ AD=1.46P PS=5.46U PD=5.46U
M$1099 DUT_OUT|IN|INV_IN|OUT SEL$1 DUT_IN VSS nfet_05v0 L=0.6U W=2U AS=1.46P
+ AD=1.46P PS=5.46U PD=5.46U
M$1100 DUT_OUT|IN|INV_IN|OUT SEL$2 DUT_IN$1 VSS nfet_05v0 L=0.6U W=2U AS=1.46P
+ AD=1.46P PS=5.46U PD=5.46U
M$1101 DUT_OUT|IN|INV_IN|OUT SEL$3 DUT_IN$11 VSS nfet_05v0 L=0.6U W=2U AS=1.46P
+ AD=1.46P PS=5.46U PD=5.46U
M$1102 DUT_OUT|IN|INV_IN|OUT SEL$4 DUT_IN$2 VSS nfet_05v0 L=0.6U W=2U AS=1.46P
+ AD=1.46P PS=5.46U PD=5.46U
M$1103 DUT_OUT|IN|INV_IN|OUT SEL$5 DUT_IN$3 VSS nfet_05v0 L=0.6U W=2U AS=1.46P
+ AD=1.46P PS=5.46U PD=5.46U
M$1104 DUT_OUT|IN|INV_IN|OUT SEL$6 DUT_IN$12 VSS nfet_05v0 L=0.6U W=2U AS=1.46P
+ AD=1.46P PS=5.46U PD=5.46U
M$1105 DUT_OUT|IN|INV_IN|OUT SEL$7 DUT_IN$4 VSS nfet_05v0 L=0.6U W=2U AS=1.46P
+ AD=1.46P PS=5.46U PD=5.46U
M$1106 DUT_OUT|IN|INV_IN|OUT SEL$8 DUT_IN$13 VSS nfet_05v0 L=0.6U W=2U AS=1.46P
+ AD=1.46P PS=5.46U PD=5.46U
M$1107 DUT_OUT|IN|INV_IN|OUT SEL$9 DUT_IN$5 VSS nfet_05v0 L=0.6U W=2U AS=1.46P
+ AD=1.46P PS=5.46U PD=5.46U
M$1108 DUT_OUT|IN|INV_IN|OUT SEL$10 DUT_IN$6 VSS nfet_05v0 L=0.6U W=2U AS=1.46P
+ AD=1.46P PS=5.46U PD=5.46U
M$1109 DUT_OUT|IN|INV_IN|OUT SEL$11 DUT_IN$7 VSS nfet_05v0 L=0.6U W=2U AS=1.46P
+ AD=1.46P PS=5.46U PD=5.46U
M$1110 DUT_OUT|IN|INV_IN|OUT SEL$12 DUT_IN$14 VSS nfet_05v0 L=0.6U W=2U
+ AS=1.46P AD=1.46P PS=5.46U PD=5.46U
M$1111 DUT_OUT|IN|INV_IN|OUT SEL$13 DUT_IN$8 VSS nfet_05v0 L=0.6U W=2U AS=1.46P
+ AD=1.46P PS=5.46U PD=5.46U
M$1112 DUT_OUT|IN|INV_IN|OUT SEL$14 DUT_IN$9 VSS nfet_05v0 L=0.6U W=2U AS=1.46P
+ AD=1.46P PS=5.46U PD=5.46U
M$1113 DUT_OUT|IN|INV_IN|OUT SEL$15 DUT_IN$15 VSS nfet_05v0 L=0.6U W=2U
+ AS=1.46P AD=1.46P PS=5.46U PD=5.46U
M$1114 VSS SEL \$53 VSS nfet_05v0 L=0.6U W=1U AS=0.73P AD=0.73P PS=3.46U
+ PD=3.46U
M$1115 VSS \$53 DUT_IN$10 VSS nfet_05v0 L=0.6U W=0.42U AS=0.315P AD=0.315P
+ PS=2.34U PD=2.34U
M$1116 VSS SEL$1 \$54 VSS nfet_05v0 L=0.6U W=1U AS=0.73P AD=0.73P PS=3.46U
+ PD=3.46U
M$1117 VSS \$54 DUT_IN VSS nfet_05v0 L=0.6U W=0.42U AS=0.315P AD=0.315P
+ PS=2.34U PD=2.34U
M$1118 VSS SEL$2 \$55 VSS nfet_05v0 L=0.6U W=1U AS=0.73P AD=0.73P PS=3.46U
+ PD=3.46U
M$1119 VSS \$55 DUT_IN$1 VSS nfet_05v0 L=0.6U W=0.42U AS=0.315P AD=0.315P
+ PS=2.34U PD=2.34U
M$1120 VSS SEL$3 \$56 VSS nfet_05v0 L=0.6U W=1U AS=0.73P AD=0.73P PS=3.46U
+ PD=3.46U
M$1121 VSS \$56 DUT_IN$11 VSS nfet_05v0 L=0.6U W=0.42U AS=0.315P AD=0.315P
+ PS=2.34U PD=2.34U
M$1122 VSS \$57 DUT_IN$2 VSS nfet_05v0 L=0.6U W=0.42U AS=0.315P AD=0.315P
+ PS=2.34U PD=2.34U
M$1123 VSS SEL$4 \$57 VSS nfet_05v0 L=0.6U W=1U AS=0.73P AD=0.73P PS=3.46U
+ PD=3.46U
M$1124 VSS SEL$5 \$58 VSS nfet_05v0 L=0.6U W=1U AS=0.73P AD=0.73P PS=3.46U
+ PD=3.46U
M$1125 VSS \$58 DUT_IN$3 VSS nfet_05v0 L=0.6U W=0.42U AS=0.315P AD=0.315P
+ PS=2.34U PD=2.34U
M$1126 VSS \$59 DUT_IN$12 VSS nfet_05v0 L=0.6U W=0.42U AS=0.315P AD=0.315P
+ PS=2.34U PD=2.34U
M$1127 VSS SEL$6 \$59 VSS nfet_05v0 L=0.6U W=1U AS=0.73P AD=0.73P PS=3.46U
+ PD=3.46U
M$1128 VSS \$60 DUT_IN$4 VSS nfet_05v0 L=0.6U W=0.42U AS=0.315P AD=0.315P
+ PS=2.34U PD=2.34U
M$1129 VSS SEL$7 \$60 VSS nfet_05v0 L=0.6U W=1U AS=0.73P AD=0.73P PS=3.46U
+ PD=3.46U
M$1130 VSS SEL$8 \$61 VSS nfet_05v0 L=0.6U W=1U AS=0.73P AD=0.73P PS=3.46U
+ PD=3.46U
M$1131 VSS \$61 DUT_IN$13 VSS nfet_05v0 L=0.6U W=0.42U AS=0.315P AD=0.315P
+ PS=2.34U PD=2.34U
M$1132 VSS \$62 DUT_IN$5 VSS nfet_05v0 L=0.6U W=0.42U AS=0.315P AD=0.315P
+ PS=2.34U PD=2.34U
M$1133 VSS SEL$9 \$62 VSS nfet_05v0 L=0.6U W=1U AS=0.73P AD=0.73P PS=3.46U
+ PD=3.46U
M$1134 VSS \$63 DUT_IN$6 VSS nfet_05v0 L=0.6U W=0.42U AS=0.315P AD=0.315P
+ PS=2.34U PD=2.34U
M$1135 VSS SEL$10 \$63 VSS nfet_05v0 L=0.6U W=1U AS=0.73P AD=0.73P PS=3.46U
+ PD=3.46U
M$1136 VSS \$64 DUT_IN$7 VSS nfet_05v0 L=0.6U W=0.42U AS=0.315P AD=0.315P
+ PS=2.34U PD=2.34U
M$1137 VSS SEL$11 \$64 VSS nfet_05v0 L=0.6U W=1U AS=0.73P AD=0.73P PS=3.46U
+ PD=3.46U
M$1138 VSS SEL$12 \$65 VSS nfet_05v0 L=0.6U W=1U AS=0.73P AD=0.73P PS=3.46U
+ PD=3.46U
M$1139 VSS \$65 DUT_IN$14 VSS nfet_05v0 L=0.6U W=0.42U AS=0.315P AD=0.315P
+ PS=2.34U PD=2.34U
M$1140 VSS \$66 DUT_IN$8 VSS nfet_05v0 L=0.6U W=0.42U AS=0.315P AD=0.315P
+ PS=2.34U PD=2.34U
M$1141 VSS SEL$13 \$66 VSS nfet_05v0 L=0.6U W=1U AS=0.73P AD=0.73P PS=3.46U
+ PD=3.46U
M$1142 VSS SEL$14 \$67 VSS nfet_05v0 L=0.6U W=1U AS=0.73P AD=0.73P PS=3.46U
+ PD=3.46U
M$1143 VSS \$67 DUT_IN$9 VSS nfet_05v0 L=0.6U W=0.42U AS=0.315P AD=0.315P
+ PS=2.34U PD=2.34U
M$1144 VSS SEL$15 \$68 VSS nfet_05v0 L=0.6U W=1U AS=0.73P AD=0.73P PS=3.46U
+ PD=3.46U
M$1145 VSS \$68 DUT_IN$15 VSS nfet_05v0 L=0.6U W=0.42U AS=0.315P AD=0.315P
+ PS=2.34U PD=2.34U
M$1146 DUT_OUT SEL IN|INV_OUT|OUT VSS nfet_05v0 L=0.6U W=2U AS=1.46P AD=1.46P
+ PS=5.46U PD=5.46U
M$1147 DUT_OUT$1 SEL$1 IN|INV_OUT|OUT VSS nfet_05v0 L=0.6U W=2U AS=1.46P
+ AD=1.46P PS=5.46U PD=5.46U
M$1148 DUT_OUT$2 SEL$2 IN|INV_OUT|OUT VSS nfet_05v0 L=0.6U W=2U AS=1.46P
+ AD=1.46P PS=5.46U PD=5.46U
M$1149 DUT_OUT$3 SEL$3 IN|INV_OUT|OUT VSS nfet_05v0 L=0.6U W=2U AS=1.46P
+ AD=1.46P PS=5.46U PD=5.46U
M$1150 DUT_OUT$4 SEL$4 IN|INV_OUT|OUT VSS nfet_05v0 L=0.6U W=2U AS=1.46P
+ AD=1.46P PS=5.46U PD=5.46U
M$1151 DUT_OUT$5 SEL$5 IN|INV_OUT|OUT VSS nfet_05v0 L=0.6U W=2U AS=1.46P
+ AD=1.46P PS=5.46U PD=5.46U
M$1152 DUT_OUT$6 SEL$6 IN|INV_OUT|OUT VSS nfet_05v0 L=0.6U W=2U AS=1.46P
+ AD=1.46P PS=5.46U PD=5.46U
M$1153 DUT_OUT$7 SEL$7 IN|INV_OUT|OUT VSS nfet_05v0 L=0.6U W=2U AS=1.46P
+ AD=1.46P PS=5.46U PD=5.46U
M$1154 DUT_OUT$8 SEL$8 IN|INV_OUT|OUT VSS nfet_05v0 L=0.6U W=2U AS=1.46P
+ AD=1.46P PS=5.46U PD=5.46U
M$1155 DUT_OUT$9 SEL$9 IN|INV_OUT|OUT VSS nfet_05v0 L=0.6U W=2U AS=1.46P
+ AD=1.46P PS=5.46U PD=5.46U
M$1156 DUT_OUT$10 SEL$10 IN|INV_OUT|OUT VSS nfet_05v0 L=0.6U W=2U AS=1.46P
+ AD=1.46P PS=5.46U PD=5.46U
M$1157 DUT_OUT$11 SEL$11 IN|INV_OUT|OUT VSS nfet_05v0 L=0.6U W=2U AS=1.46P
+ AD=1.46P PS=5.46U PD=5.46U
M$1158 DUT_OUT$12 SEL$12 IN|INV_OUT|OUT VSS nfet_05v0 L=0.6U W=2U AS=1.46P
+ AD=1.46P PS=5.46U PD=5.46U
M$1159 DUT_OUT$13 SEL$13 IN|INV_OUT|OUT VSS nfet_05v0 L=0.6U W=2U AS=1.46P
+ AD=1.46P PS=5.46U PD=5.46U
M$1160 DUT_OUT$14 SEL$14 IN|INV_OUT|OUT VSS nfet_05v0 L=0.6U W=2U AS=1.46P
+ AD=1.46P PS=5.46U PD=5.46U
M$1161 DUT_OUT$15 SEL$15 IN|INV_OUT|OUT VSS nfet_05v0 L=0.6U W=2U AS=1.46P
+ AD=1.46P PS=5.46U PD=5.46U
M$1162 VSS SEL \$87 VSS nfet_05v0 L=0.6U W=1U AS=0.73P AD=0.73P PS=3.46U
+ PD=3.46U
M$1163 VSS SEL$1 \$88 VSS nfet_05v0 L=0.6U W=1U AS=0.73P AD=0.73P PS=3.46U
+ PD=3.46U
M$1164 VSS SEL$2 \$89 VSS nfet_05v0 L=0.6U W=1U AS=0.73P AD=0.73P PS=3.46U
+ PD=3.46U
M$1165 VSS SEL$3 \$90 VSS nfet_05v0 L=0.6U W=1U AS=0.73P AD=0.73P PS=3.46U
+ PD=3.46U
M$1166 VSS SEL$4 \$91 VSS nfet_05v0 L=0.6U W=1U AS=0.73P AD=0.73P PS=3.46U
+ PD=3.46U
M$1167 VSS SEL$5 \$92 VSS nfet_05v0 L=0.6U W=1U AS=0.73P AD=0.73P PS=3.46U
+ PD=3.46U
M$1168 VSS SEL$6 \$93 VSS nfet_05v0 L=0.6U W=1U AS=0.73P AD=0.73P PS=3.46U
+ PD=3.46U
M$1169 VSS SEL$7 \$94 VSS nfet_05v0 L=0.6U W=1U AS=0.73P AD=0.73P PS=3.46U
+ PD=3.46U
M$1170 VSS SEL$8 \$95 VSS nfet_05v0 L=0.6U W=1U AS=0.73P AD=0.73P PS=3.46U
+ PD=3.46U
M$1171 VSS SEL$9 \$96 VSS nfet_05v0 L=0.6U W=1U AS=0.73P AD=0.73P PS=3.46U
+ PD=3.46U
M$1172 VSS SEL$10 \$97 VSS nfet_05v0 L=0.6U W=1U AS=0.73P AD=0.73P PS=3.46U
+ PD=3.46U
M$1173 VSS SEL$11 \$98 VSS nfet_05v0 L=0.6U W=1U AS=0.73P AD=0.73P PS=3.46U
+ PD=3.46U
M$1174 VSS SEL$12 \$99 VSS nfet_05v0 L=0.6U W=1U AS=0.73P AD=0.73P PS=3.46U
+ PD=3.46U
M$1175 VSS SEL$13 \$100 VSS nfet_05v0 L=0.6U W=1U AS=0.73P AD=0.73P PS=3.46U
+ PD=3.46U
M$1176 VSS SEL$14 \$101 VSS nfet_05v0 L=0.6U W=1U AS=0.73P AD=0.73P PS=3.46U
+ PD=3.46U
M$1177 VSS SEL$15 \$102 VSS nfet_05v0 L=0.6U W=1U AS=0.73P AD=0.73P PS=3.46U
+ PD=3.46U
M$1178 DUT_OUT|IN|INV_IN|OUT SEL$16 DUT_IN$16 VSS nfet_05v0 L=0.6U W=2U
+ AS=1.46P AD=1.46P PS=5.46U PD=5.46U
M$1179 DUT_OUT|IN|INV_IN|OUT SEL$17 DUT_IN$17 VSS nfet_05v0 L=0.6U W=2U
+ AS=1.46P AD=1.46P PS=5.46U PD=5.46U
M$1180 DUT_OUT|IN|INV_IN|OUT SEL$18 DUT_IN$18 VSS nfet_05v0 L=0.6U W=2U
+ AS=1.46P AD=1.46P PS=5.46U PD=5.46U
M$1181 DUT_OUT|IN|INV_IN|OUT SEL$19 DUT_IN$19 VSS nfet_05v0 L=0.6U W=2U
+ AS=1.46P AD=1.46P PS=5.46U PD=5.46U
M$1182 DUT_OUT|IN|INV_IN|OUT SEL$20 DUT_IN$20 VSS nfet_05v0 L=0.6U W=2U
+ AS=1.46P AD=1.46P PS=5.46U PD=5.46U
M$1183 DUT_OUT|IN|INV_IN|OUT SEL$21 DUT_IN$21 VSS nfet_05v0 L=0.6U W=2U
+ AS=1.46P AD=1.46P PS=5.46U PD=5.46U
M$1184 DUT_OUT|IN|INV_IN|OUT SEL$22 DUT_IN$22 VSS nfet_05v0 L=0.6U W=2U
+ AS=1.46P AD=1.46P PS=5.46U PD=5.46U
M$1185 DUT_OUT|IN|INV_IN|OUT SEL$23 DUT_IN$23 VSS nfet_05v0 L=0.6U W=2U
+ AS=1.46P AD=1.46P PS=5.46U PD=5.46U
M$1186 DUT_OUT|IN|INV_IN|OUT SEL$24 DUT_IN$24 VSS nfet_05v0 L=0.6U W=2U
+ AS=1.46P AD=1.46P PS=5.46U PD=5.46U
M$1187 DUT_OUT|IN|INV_IN|OUT SEL$25 DUT_IN$25 VSS nfet_05v0 L=0.6U W=2U
+ AS=1.46P AD=1.46P PS=5.46U PD=5.46U
M$1188 DUT_OUT|IN|INV_IN|OUT SEL$26 DUT_IN$26 VSS nfet_05v0 L=0.6U W=2U
+ AS=1.46P AD=1.46P PS=5.46U PD=5.46U
M$1189 DUT_OUT|IN|INV_IN|OUT SEL$27 DUT_IN$27 VSS nfet_05v0 L=0.6U W=2U
+ AS=1.46P AD=1.46P PS=5.46U PD=5.46U
M$1190 DUT_OUT|IN|INV_IN|OUT SEL$28 DUT_IN$28 VSS nfet_05v0 L=0.6U W=2U
+ AS=1.46P AD=1.46P PS=5.46U PD=5.46U
M$1191 DUT_OUT|IN|INV_IN|OUT SEL$29 DUT_IN$29 VSS nfet_05v0 L=0.6U W=2U
+ AS=1.46P AD=1.46P PS=5.46U PD=5.46U
M$1192 DUT_OUT|IN|INV_IN|OUT SEL$30 DUT_IN$30 VSS nfet_05v0 L=0.6U W=2U
+ AS=1.46P AD=1.46P PS=5.46U PD=5.46U
M$1193 DUT_OUT|IN|INV_IN|OUT SEL$31 DUT_IN$31 VSS nfet_05v0 L=0.6U W=2U
+ AS=1.46P AD=1.46P PS=5.46U PD=5.46U
M$1194 VSS \$169 DUT_IN$16 VSS nfet_05v0 L=0.6U W=0.42U AS=0.315P AD=0.315P
+ PS=2.34U PD=2.34U
M$1195 VSS SEL$16 \$169 VSS nfet_05v0 L=0.6U W=1U AS=0.73P AD=0.73P PS=3.46U
+ PD=3.46U
M$1196 VSS SEL$17 \$170 VSS nfet_05v0 L=0.6U W=1U AS=0.73P AD=0.73P PS=3.46U
+ PD=3.46U
M$1197 VSS \$170 DUT_IN$17 VSS nfet_05v0 L=0.6U W=0.42U AS=0.315P AD=0.315P
+ PS=2.34U PD=2.34U
M$1198 VSS \$171 DUT_IN$18 VSS nfet_05v0 L=0.6U W=0.42U AS=0.315P AD=0.315P
+ PS=2.34U PD=2.34U
M$1199 VSS SEL$18 \$171 VSS nfet_05v0 L=0.6U W=1U AS=0.73P AD=0.73P PS=3.46U
+ PD=3.46U
M$1200 VSS \$172 DUT_IN$19 VSS nfet_05v0 L=0.6U W=0.42U AS=0.315P AD=0.315P
+ PS=2.34U PD=2.34U
M$1201 VSS SEL$19 \$172 VSS nfet_05v0 L=0.6U W=1U AS=0.73P AD=0.73P PS=3.46U
+ PD=3.46U
M$1202 VSS \$173 DUT_IN$20 VSS nfet_05v0 L=0.6U W=0.42U AS=0.315P AD=0.315P
+ PS=2.34U PD=2.34U
M$1203 VSS SEL$20 \$173 VSS nfet_05v0 L=0.6U W=1U AS=0.73P AD=0.73P PS=3.46U
+ PD=3.46U
M$1204 VSS SEL$21 \$174 VSS nfet_05v0 L=0.6U W=1U AS=0.73P AD=0.73P PS=3.46U
+ PD=3.46U
M$1205 VSS \$174 DUT_IN$21 VSS nfet_05v0 L=0.6U W=0.42U AS=0.315P AD=0.315P
+ PS=2.34U PD=2.34U
M$1206 VSS \$175 DUT_IN$22 VSS nfet_05v0 L=0.6U W=0.42U AS=0.315P AD=0.315P
+ PS=2.34U PD=2.34U
M$1207 VSS SEL$22 \$175 VSS nfet_05v0 L=0.6U W=1U AS=0.73P AD=0.73P PS=3.46U
+ PD=3.46U
M$1208 VSS \$176 DUT_IN$23 VSS nfet_05v0 L=0.6U W=0.42U AS=0.315P AD=0.315P
+ PS=2.34U PD=2.34U
M$1209 VSS SEL$23 \$176 VSS nfet_05v0 L=0.6U W=1U AS=0.73P AD=0.73P PS=3.46U
+ PD=3.46U
M$1210 VSS SEL$24 \$177 VSS nfet_05v0 L=0.6U W=1U AS=0.73P AD=0.73P PS=3.46U
+ PD=3.46U
M$1211 VSS \$177 DUT_IN$24 VSS nfet_05v0 L=0.6U W=0.42U AS=0.315P AD=0.315P
+ PS=2.34U PD=2.34U
M$1212 VSS SEL$25 \$178 VSS nfet_05v0 L=0.6U W=1U AS=0.73P AD=0.73P PS=3.46U
+ PD=3.46U
M$1213 VSS \$178 DUT_IN$25 VSS nfet_05v0 L=0.6U W=0.42U AS=0.315P AD=0.315P
+ PS=2.34U PD=2.34U
M$1214 VSS SEL$26 \$179 VSS nfet_05v0 L=0.6U W=1U AS=0.73P AD=0.73P PS=3.46U
+ PD=3.46U
M$1215 VSS \$179 DUT_IN$26 VSS nfet_05v0 L=0.6U W=0.42U AS=0.315P AD=0.315P
+ PS=2.34U PD=2.34U
M$1216 VSS SEL$27 \$180 VSS nfet_05v0 L=0.6U W=1U AS=0.73P AD=0.73P PS=3.46U
+ PD=3.46U
M$1217 VSS \$180 DUT_IN$27 VSS nfet_05v0 L=0.6U W=0.42U AS=0.315P AD=0.315P
+ PS=2.34U PD=2.34U
M$1218 VSS SEL$28 \$181 VSS nfet_05v0 L=0.6U W=1U AS=0.73P AD=0.73P PS=3.46U
+ PD=3.46U
M$1219 VSS \$181 DUT_IN$28 VSS nfet_05v0 L=0.6U W=0.42U AS=0.315P AD=0.315P
+ PS=2.34U PD=2.34U
M$1220 VSS SEL$29 \$182 VSS nfet_05v0 L=0.6U W=1U AS=0.73P AD=0.73P PS=3.46U
+ PD=3.46U
M$1221 VSS \$182 DUT_IN$29 VSS nfet_05v0 L=0.6U W=0.42U AS=0.315P AD=0.315P
+ PS=2.34U PD=2.34U
M$1222 VSS \$183 DUT_IN$30 VSS nfet_05v0 L=0.6U W=0.42U AS=0.315P AD=0.315P
+ PS=2.34U PD=2.34U
M$1223 VSS SEL$30 \$183 VSS nfet_05v0 L=0.6U W=1U AS=0.73P AD=0.73P PS=3.46U
+ PD=3.46U
M$1224 VSS SEL$31 \$184 VSS nfet_05v0 L=0.6U W=1U AS=0.73P AD=0.73P PS=3.46U
+ PD=3.46U
M$1225 VSS \$184 DUT_IN$31 VSS nfet_05v0 L=0.6U W=0.42U AS=0.315P AD=0.315P
+ PS=2.34U PD=2.34U
M$1226 DUT_OUT$16 SEL$16 IN|INV_OUT|OUT VSS nfet_05v0 L=0.6U W=2U AS=1.46P
+ AD=1.46P PS=5.46U PD=5.46U
M$1227 DUT_OUT$17 SEL$17 IN|INV_OUT|OUT VSS nfet_05v0 L=0.6U W=2U AS=1.46P
+ AD=1.46P PS=5.46U PD=5.46U
M$1228 DUT_OUT$18 SEL$18 IN|INV_OUT|OUT VSS nfet_05v0 L=0.6U W=2U AS=1.46P
+ AD=1.46P PS=5.46U PD=5.46U
M$1229 DUT_OUT$19 SEL$19 IN|INV_OUT|OUT VSS nfet_05v0 L=0.6U W=2U AS=1.46P
+ AD=1.46P PS=5.46U PD=5.46U
M$1230 DUT_OUT$20 SEL$20 IN|INV_OUT|OUT VSS nfet_05v0 L=0.6U W=2U AS=1.46P
+ AD=1.46P PS=5.46U PD=5.46U
M$1231 DUT_OUT$21 SEL$21 IN|INV_OUT|OUT VSS nfet_05v0 L=0.6U W=2U AS=1.46P
+ AD=1.46P PS=5.46U PD=5.46U
M$1232 DUT_OUT$22 SEL$22 IN|INV_OUT|OUT VSS nfet_05v0 L=0.6U W=2U AS=1.46P
+ AD=1.46P PS=5.46U PD=5.46U
M$1233 DUT_OUT$23 SEL$23 IN|INV_OUT|OUT VSS nfet_05v0 L=0.6U W=2U AS=1.46P
+ AD=1.46P PS=5.46U PD=5.46U
M$1234 DUT_OUT$24 SEL$24 IN|INV_OUT|OUT VSS nfet_05v0 L=0.6U W=2U AS=1.46P
+ AD=1.46P PS=5.46U PD=5.46U
M$1235 DUT_OUT$25 SEL$25 IN|INV_OUT|OUT VSS nfet_05v0 L=0.6U W=2U AS=1.46P
+ AD=1.46P PS=5.46U PD=5.46U
M$1236 DUT_OUT$26 SEL$26 IN|INV_OUT|OUT VSS nfet_05v0 L=0.6U W=2U AS=1.46P
+ AD=1.46P PS=5.46U PD=5.46U
M$1237 DUT_OUT$27 SEL$27 IN|INV_OUT|OUT VSS nfet_05v0 L=0.6U W=2U AS=1.46P
+ AD=1.46P PS=5.46U PD=5.46U
M$1238 DUT_OUT$28 SEL$28 IN|INV_OUT|OUT VSS nfet_05v0 L=0.6U W=2U AS=1.46P
+ AD=1.46P PS=5.46U PD=5.46U
M$1239 DUT_OUT$29 SEL$29 IN|INV_OUT|OUT VSS nfet_05v0 L=0.6U W=2U AS=1.46P
+ AD=1.46P PS=5.46U PD=5.46U
M$1240 DUT_OUT$30 SEL$30 IN|INV_OUT|OUT VSS nfet_05v0 L=0.6U W=2U AS=1.46P
+ AD=1.46P PS=5.46U PD=5.46U
M$1241 DUT_OUT$31 SEL$31 IN|INV_OUT|OUT VSS nfet_05v0 L=0.6U W=2U AS=1.46P
+ AD=1.46P PS=5.46U PD=5.46U
M$1242 VSS SEL$16 \$202 VSS nfet_05v0 L=0.6U W=1U AS=0.73P AD=0.73P PS=3.46U
+ PD=3.46U
M$1243 VSS SEL$17 \$203 VSS nfet_05v0 L=0.6U W=1U AS=0.73P AD=0.73P PS=3.46U
+ PD=3.46U
M$1244 VSS SEL$18 \$204 VSS nfet_05v0 L=0.6U W=1U AS=0.73P AD=0.73P PS=3.46U
+ PD=3.46U
M$1245 VSS SEL$19 \$205 VSS nfet_05v0 L=0.6U W=1U AS=0.73P AD=0.73P PS=3.46U
+ PD=3.46U
M$1246 VSS SEL$20 \$206 VSS nfet_05v0 L=0.6U W=1U AS=0.73P AD=0.73P PS=3.46U
+ PD=3.46U
M$1247 VSS SEL$21 \$207 VSS nfet_05v0 L=0.6U W=1U AS=0.73P AD=0.73P PS=3.46U
+ PD=3.46U
M$1248 VSS SEL$22 \$208 VSS nfet_05v0 L=0.6U W=1U AS=0.73P AD=0.73P PS=3.46U
+ PD=3.46U
M$1249 VSS SEL$23 \$209 VSS nfet_05v0 L=0.6U W=1U AS=0.73P AD=0.73P PS=3.46U
+ PD=3.46U
M$1250 VSS SEL$24 \$210 VSS nfet_05v0 L=0.6U W=1U AS=0.73P AD=0.73P PS=3.46U
+ PD=3.46U
M$1251 VSS SEL$25 \$211 VSS nfet_05v0 L=0.6U W=1U AS=0.73P AD=0.73P PS=3.46U
+ PD=3.46U
M$1252 VSS SEL$26 \$212 VSS nfet_05v0 L=0.6U W=1U AS=0.73P AD=0.73P PS=3.46U
+ PD=3.46U
M$1253 VSS SEL$27 \$213 VSS nfet_05v0 L=0.6U W=1U AS=0.73P AD=0.73P PS=3.46U
+ PD=3.46U
M$1254 VSS SEL$28 \$214 VSS nfet_05v0 L=0.6U W=1U AS=0.73P AD=0.73P PS=3.46U
+ PD=3.46U
M$1255 VSS SEL$29 \$215 VSS nfet_05v0 L=0.6U W=1U AS=0.73P AD=0.73P PS=3.46U
+ PD=3.46U
M$1256 VSS SEL$30 \$216 VSS nfet_05v0 L=0.6U W=1U AS=0.73P AD=0.73P PS=3.46U
+ PD=3.46U
M$1257 VSS SEL$31 \$217 VSS nfet_05v0 L=0.6U W=1U AS=0.73P AD=0.73P PS=3.46U
+ PD=3.46U
M$1258 DUT_OUT|IN|INV_IN|OUT SEL$32 DUT_IN$32 VSS nfet_05v0 L=0.6U W=2U
+ AS=1.46P AD=1.46P PS=5.46U PD=5.46U
M$1259 DUT_OUT|IN|INV_IN|OUT SEL$33 DUT_IN$33 VSS nfet_05v0 L=0.6U W=2U
+ AS=1.46P AD=1.46P PS=5.46U PD=5.46U
M$1260 DUT_OUT|IN|INV_IN|OUT SEL$34 DUT_IN$34 VSS nfet_05v0 L=0.6U W=2U
+ AS=1.46P AD=1.46P PS=5.46U PD=5.46U
M$1261 DUT_OUT|IN|INV_IN|OUT SEL$35 DUT_IN$35 VSS nfet_05v0 L=0.6U W=2U
+ AS=1.46P AD=1.46P PS=5.46U PD=5.46U
M$1262 DUT_OUT|IN|INV_IN|OUT SEL$36 DUT_IN$36 VSS nfet_05v0 L=0.6U W=2U
+ AS=1.46P AD=1.46P PS=5.46U PD=5.46U
M$1263 DUT_OUT|IN|INV_IN|OUT SEL$37 DUT_IN$37 VSS nfet_05v0 L=0.6U W=2U
+ AS=1.46P AD=1.46P PS=5.46U PD=5.46U
M$1264 DUT_OUT|IN|INV_IN|OUT SEL$38 DUT_IN$38 VSS nfet_05v0 L=0.6U W=2U
+ AS=1.46P AD=1.46P PS=5.46U PD=5.46U
M$1265 DUT_OUT|IN|INV_IN|OUT SEL$39 DUT_IN$39 VSS nfet_05v0 L=0.6U W=2U
+ AS=1.46P AD=1.46P PS=5.46U PD=5.46U
M$1266 DUT_OUT|IN|INV_IN|OUT SEL$40 DUT_IN$40 VSS nfet_05v0 L=0.6U W=2U
+ AS=1.46P AD=1.46P PS=5.46U PD=5.46U
M$1267 DUT_OUT|IN|INV_IN|OUT SEL$41 DUT_IN$41 VSS nfet_05v0 L=0.6U W=2U
+ AS=1.46P AD=1.46P PS=5.46U PD=5.46U
M$1268 DUT_OUT|IN|INV_IN|OUT SEL$42 DUT_IN$42 VSS nfet_05v0 L=0.6U W=2U
+ AS=1.46P AD=1.46P PS=5.46U PD=5.46U
M$1269 DUT_OUT|IN|INV_IN|OUT SEL$43 DUT_IN$43 VSS nfet_05v0 L=0.6U W=2U
+ AS=1.46P AD=1.46P PS=5.46U PD=5.46U
M$1270 DUT_OUT|IN|INV_IN|OUT SEL$44 DUT_IN$44 VSS nfet_05v0 L=0.6U W=2U
+ AS=1.46P AD=1.46P PS=5.46U PD=5.46U
M$1271 DUT_OUT|IN|INV_IN|OUT SEL$45 DUT_IN$45 VSS nfet_05v0 L=0.6U W=2U
+ AS=1.46P AD=1.46P PS=5.46U PD=5.46U
M$1272 DUT_OUT|IN|INV_IN|OUT SEL$46 DUT_IN$46 VSS nfet_05v0 L=0.6U W=2U
+ AS=1.46P AD=1.46P PS=5.46U PD=5.46U
M$1273 DUT_OUT|IN|INV_IN|OUT SEL$47 DUT_IN$47 VSS nfet_05v0 L=0.6U W=2U
+ AS=1.46P AD=1.46P PS=5.46U PD=5.46U
M$1274 VSS SEL$32 \$284 VSS nfet_05v0 L=0.6U W=1U AS=0.73P AD=0.73P PS=3.46U
+ PD=3.46U
M$1275 VSS \$284 DUT_IN$32 VSS nfet_05v0 L=0.6U W=0.42U AS=0.315P AD=0.315P
+ PS=2.34U PD=2.34U
M$1276 VSS \$285 DUT_IN$33 VSS nfet_05v0 L=0.6U W=0.42U AS=0.315P AD=0.315P
+ PS=2.34U PD=2.34U
M$1277 VSS SEL$33 \$285 VSS nfet_05v0 L=0.6U W=1U AS=0.73P AD=0.73P PS=3.46U
+ PD=3.46U
M$1278 VSS \$286 DUT_IN$34 VSS nfet_05v0 L=0.6U W=0.42U AS=0.315P AD=0.315P
+ PS=2.34U PD=2.34U
M$1279 VSS SEL$34 \$286 VSS nfet_05v0 L=0.6U W=1U AS=0.73P AD=0.73P PS=3.46U
+ PD=3.46U
M$1280 VSS \$287 DUT_IN$35 VSS nfet_05v0 L=0.6U W=0.42U AS=0.315P AD=0.315P
+ PS=2.34U PD=2.34U
M$1281 VSS SEL$35 \$287 VSS nfet_05v0 L=0.6U W=1U AS=0.73P AD=0.73P PS=3.46U
+ PD=3.46U
M$1282 VSS SEL$36 \$288 VSS nfet_05v0 L=0.6U W=1U AS=0.73P AD=0.73P PS=3.46U
+ PD=3.46U
M$1283 VSS \$288 DUT_IN$36 VSS nfet_05v0 L=0.6U W=0.42U AS=0.315P AD=0.315P
+ PS=2.34U PD=2.34U
M$1284 VSS SEL$37 \$289 VSS nfet_05v0 L=0.6U W=1U AS=0.73P AD=0.73P PS=3.46U
+ PD=3.46U
M$1285 VSS \$289 DUT_IN$37 VSS nfet_05v0 L=0.6U W=0.42U AS=0.315P AD=0.315P
+ PS=2.34U PD=2.34U
M$1286 VSS \$290 DUT_IN$38 VSS nfet_05v0 L=0.6U W=0.42U AS=0.315P AD=0.315P
+ PS=2.34U PD=2.34U
M$1287 VSS SEL$38 \$290 VSS nfet_05v0 L=0.6U W=1U AS=0.73P AD=0.73P PS=3.46U
+ PD=3.46U
M$1288 VSS SEL$39 \$291 VSS nfet_05v0 L=0.6U W=1U AS=0.73P AD=0.73P PS=3.46U
+ PD=3.46U
M$1289 VSS \$291 DUT_IN$39 VSS nfet_05v0 L=0.6U W=0.42U AS=0.315P AD=0.315P
+ PS=2.34U PD=2.34U
M$1290 VSS SEL$40 \$292 VSS nfet_05v0 L=0.6U W=1U AS=0.73P AD=0.73P PS=3.46U
+ PD=3.46U
M$1291 VSS \$292 DUT_IN$40 VSS nfet_05v0 L=0.6U W=0.42U AS=0.315P AD=0.315P
+ PS=2.34U PD=2.34U
M$1292 VSS \$293 DUT_IN$41 VSS nfet_05v0 L=0.6U W=0.42U AS=0.315P AD=0.315P
+ PS=2.34U PD=2.34U
M$1293 VSS SEL$41 \$293 VSS nfet_05v0 L=0.6U W=1U AS=0.73P AD=0.73P PS=3.46U
+ PD=3.46U
M$1294 VSS SEL$42 \$294 VSS nfet_05v0 L=0.6U W=1U AS=0.73P AD=0.73P PS=3.46U
+ PD=3.46U
M$1295 VSS \$294 DUT_IN$42 VSS nfet_05v0 L=0.6U W=0.42U AS=0.315P AD=0.315P
+ PS=2.34U PD=2.34U
M$1296 VSS SEL$43 \$295 VSS nfet_05v0 L=0.6U W=1U AS=0.73P AD=0.73P PS=3.46U
+ PD=3.46U
M$1297 VSS \$295 DUT_IN$43 VSS nfet_05v0 L=0.6U W=0.42U AS=0.315P AD=0.315P
+ PS=2.34U PD=2.34U
M$1298 VSS \$296 DUT_IN$44 VSS nfet_05v0 L=0.6U W=0.42U AS=0.315P AD=0.315P
+ PS=2.34U PD=2.34U
M$1299 VSS SEL$44 \$296 VSS nfet_05v0 L=0.6U W=1U AS=0.73P AD=0.73P PS=3.46U
+ PD=3.46U
M$1300 VSS \$297 DUT_IN$45 VSS nfet_05v0 L=0.6U W=0.42U AS=0.315P AD=0.315P
+ PS=2.34U PD=2.34U
M$1301 VSS SEL$45 \$297 VSS nfet_05v0 L=0.6U W=1U AS=0.73P AD=0.73P PS=3.46U
+ PD=3.46U
M$1302 VSS \$298 DUT_IN$46 VSS nfet_05v0 L=0.6U W=0.42U AS=0.315P AD=0.315P
+ PS=2.34U PD=2.34U
M$1303 VSS SEL$46 \$298 VSS nfet_05v0 L=0.6U W=1U AS=0.73P AD=0.73P PS=3.46U
+ PD=3.46U
M$1304 VSS \$299 DUT_IN$47 VSS nfet_05v0 L=0.6U W=0.42U AS=0.315P AD=0.315P
+ PS=2.34U PD=2.34U
M$1305 VSS SEL$47 \$299 VSS nfet_05v0 L=0.6U W=1U AS=0.73P AD=0.73P PS=3.46U
+ PD=3.46U
M$1306 DUT_OUT$32 SEL$32 IN|INV_OUT|OUT VSS nfet_05v0 L=0.6U W=2U AS=1.46P
+ AD=1.46P PS=5.46U PD=5.46U
M$1307 DUT_OUT$33 SEL$33 IN|INV_OUT|OUT VSS nfet_05v0 L=0.6U W=2U AS=1.46P
+ AD=1.46P PS=5.46U PD=5.46U
M$1308 DUT_OUT$34 SEL$34 IN|INV_OUT|OUT VSS nfet_05v0 L=0.6U W=2U AS=1.46P
+ AD=1.46P PS=5.46U PD=5.46U
M$1309 DUT_OUT$35 SEL$35 IN|INV_OUT|OUT VSS nfet_05v0 L=0.6U W=2U AS=1.46P
+ AD=1.46P PS=5.46U PD=5.46U
M$1310 DUT_OUT$36 SEL$36 IN|INV_OUT|OUT VSS nfet_05v0 L=0.6U W=2U AS=1.46P
+ AD=1.46P PS=5.46U PD=5.46U
M$1311 DUT_OUT$37 SEL$37 IN|INV_OUT|OUT VSS nfet_05v0 L=0.6U W=2U AS=1.46P
+ AD=1.46P PS=5.46U PD=5.46U
M$1312 DUT_OUT$38 SEL$38 IN|INV_OUT|OUT VSS nfet_05v0 L=0.6U W=2U AS=1.46P
+ AD=1.46P PS=5.46U PD=5.46U
M$1313 DUT_OUT$39 SEL$39 IN|INV_OUT|OUT VSS nfet_05v0 L=0.6U W=2U AS=1.46P
+ AD=1.46P PS=5.46U PD=5.46U
M$1314 DUT_OUT$40 SEL$40 IN|INV_OUT|OUT VSS nfet_05v0 L=0.6U W=2U AS=1.46P
+ AD=1.46P PS=5.46U PD=5.46U
M$1315 DUT_OUT$41 SEL$41 IN|INV_OUT|OUT VSS nfet_05v0 L=0.6U W=2U AS=1.46P
+ AD=1.46P PS=5.46U PD=5.46U
M$1316 DUT_OUT$42 SEL$42 IN|INV_OUT|OUT VSS nfet_05v0 L=0.6U W=2U AS=1.46P
+ AD=1.46P PS=5.46U PD=5.46U
M$1317 DUT_OUT$43 SEL$43 IN|INV_OUT|OUT VSS nfet_05v0 L=0.6U W=2U AS=1.46P
+ AD=1.46P PS=5.46U PD=5.46U
M$1318 DUT_OUT$44 SEL$44 IN|INV_OUT|OUT VSS nfet_05v0 L=0.6U W=2U AS=1.46P
+ AD=1.46P PS=5.46U PD=5.46U
M$1319 DUT_OUT$45 SEL$45 IN|INV_OUT|OUT VSS nfet_05v0 L=0.6U W=2U AS=1.46P
+ AD=1.46P PS=5.46U PD=5.46U
M$1320 DUT_OUT$46 SEL$46 IN|INV_OUT|OUT VSS nfet_05v0 L=0.6U W=2U AS=1.46P
+ AD=1.46P PS=5.46U PD=5.46U
M$1321 DUT_OUT$47 SEL$47 IN|INV_OUT|OUT VSS nfet_05v0 L=0.6U W=2U AS=1.46P
+ AD=1.46P PS=5.46U PD=5.46U
M$1322 VSS SEL$32 \$317 VSS nfet_05v0 L=0.6U W=1U AS=0.73P AD=0.73P PS=3.46U
+ PD=3.46U
M$1323 VSS SEL$33 \$318 VSS nfet_05v0 L=0.6U W=1U AS=0.73P AD=0.73P PS=3.46U
+ PD=3.46U
M$1324 VSS SEL$34 \$319 VSS nfet_05v0 L=0.6U W=1U AS=0.73P AD=0.73P PS=3.46U
+ PD=3.46U
M$1325 VSS SEL$35 \$320 VSS nfet_05v0 L=0.6U W=1U AS=0.73P AD=0.73P PS=3.46U
+ PD=3.46U
M$1326 VSS SEL$36 \$321 VSS nfet_05v0 L=0.6U W=1U AS=0.73P AD=0.73P PS=3.46U
+ PD=3.46U
M$1327 VSS SEL$37 \$322 VSS nfet_05v0 L=0.6U W=1U AS=0.73P AD=0.73P PS=3.46U
+ PD=3.46U
M$1328 VSS SEL$38 \$323 VSS nfet_05v0 L=0.6U W=1U AS=0.73P AD=0.73P PS=3.46U
+ PD=3.46U
M$1329 VSS SEL$39 \$324 VSS nfet_05v0 L=0.6U W=1U AS=0.73P AD=0.73P PS=3.46U
+ PD=3.46U
M$1330 VSS SEL$40 \$325 VSS nfet_05v0 L=0.6U W=1U AS=0.73P AD=0.73P PS=3.46U
+ PD=3.46U
M$1331 VSS SEL$41 \$326 VSS nfet_05v0 L=0.6U W=1U AS=0.73P AD=0.73P PS=3.46U
+ PD=3.46U
M$1332 VSS SEL$42 \$327 VSS nfet_05v0 L=0.6U W=1U AS=0.73P AD=0.73P PS=3.46U
+ PD=3.46U
M$1333 VSS SEL$43 \$328 VSS nfet_05v0 L=0.6U W=1U AS=0.73P AD=0.73P PS=3.46U
+ PD=3.46U
M$1334 VSS SEL$44 \$329 VSS nfet_05v0 L=0.6U W=1U AS=0.73P AD=0.73P PS=3.46U
+ PD=3.46U
M$1335 VSS SEL$45 \$330 VSS nfet_05v0 L=0.6U W=1U AS=0.73P AD=0.73P PS=3.46U
+ PD=3.46U
M$1336 VSS SEL$46 \$331 VSS nfet_05v0 L=0.6U W=1U AS=0.73P AD=0.73P PS=3.46U
+ PD=3.46U
M$1337 VSS SEL$47 \$332 VSS nfet_05v0 L=0.6U W=1U AS=0.73P AD=0.73P PS=3.46U
+ PD=3.46U
M$1338 DUT_OUT|IN|INV_IN|OUT SEL$48 DUT_IN$48 VSS nfet_05v0 L=0.6U W=2U
+ AS=1.46P AD=1.46P PS=5.46U PD=5.46U
M$1339 DUT_OUT|IN|INV_IN|OUT SEL$49 DUT_IN$49 VSS nfet_05v0 L=0.6U W=2U
+ AS=1.46P AD=1.46P PS=5.46U PD=5.46U
M$1340 DUT_OUT|IN|INV_IN|OUT SEL$50 DUT_IN$50 VSS nfet_05v0 L=0.6U W=2U
+ AS=1.46P AD=1.46P PS=5.46U PD=5.46U
M$1341 DUT_OUT|IN|INV_IN|OUT SEL$51 DUT_IN$51 VSS nfet_05v0 L=0.6U W=2U
+ AS=1.46P AD=1.46P PS=5.46U PD=5.46U
M$1342 DUT_OUT|IN|INV_IN|OUT SEL$52 DUT_IN$52 VSS nfet_05v0 L=0.6U W=2U
+ AS=1.46P AD=1.46P PS=5.46U PD=5.46U
M$1343 DUT_OUT|IN|INV_IN|OUT SEL$53 DUT_IN$53 VSS nfet_05v0 L=0.6U W=2U
+ AS=1.46P AD=1.46P PS=5.46U PD=5.46U
M$1344 DUT_OUT|IN|INV_IN|OUT SEL$54 DUT_IN$54 VSS nfet_05v0 L=0.6U W=2U
+ AS=1.46P AD=1.46P PS=5.46U PD=5.46U
M$1345 DUT_OUT|IN|INV_IN|OUT SEL$55 DUT_IN$55 VSS nfet_05v0 L=0.6U W=2U
+ AS=1.46P AD=1.46P PS=5.46U PD=5.46U
M$1346 DUT_OUT|IN|INV_IN|OUT SEL$56 DUT_IN$56 VSS nfet_05v0 L=0.6U W=2U
+ AS=1.46P AD=1.46P PS=5.46U PD=5.46U
M$1347 DUT_OUT|IN|INV_IN|OUT SEL$57 DUT_IN$57 VSS nfet_05v0 L=0.6U W=2U
+ AS=1.46P AD=1.46P PS=5.46U PD=5.46U
M$1348 DUT_OUT|IN|INV_IN|OUT SEL$58 DUT_IN$58 VSS nfet_05v0 L=0.6U W=2U
+ AS=1.46P AD=1.46P PS=5.46U PD=5.46U
M$1349 DUT_OUT|IN|INV_IN|OUT SEL$59 DUT_IN$59 VSS nfet_05v0 L=0.6U W=2U
+ AS=1.46P AD=1.46P PS=5.46U PD=5.46U
M$1350 DUT_OUT|IN|INV_IN|OUT SEL$60 DUT_IN$60 VSS nfet_05v0 L=0.6U W=2U
+ AS=1.46P AD=1.46P PS=5.46U PD=5.46U
M$1351 DUT_OUT|IN|INV_IN|OUT SEL$61 DUT_IN$61 VSS nfet_05v0 L=0.6U W=2U
+ AS=1.46P AD=1.46P PS=5.46U PD=5.46U
M$1352 DUT_OUT|IN|INV_IN|OUT SEL$62 DUT_IN$62 VSS nfet_05v0 L=0.6U W=2U
+ AS=1.46P AD=1.46P PS=5.46U PD=5.46U
M$1353 DUT_OUT|IN|INV_IN|OUT SEL$63 DUT_IN$63 VSS nfet_05v0 L=0.6U W=2U
+ AS=1.46P AD=1.46P PS=5.46U PD=5.46U
M$1354 VSS \$399 DUT_IN$48 VSS nfet_05v0 L=0.6U W=0.42U AS=0.315P AD=0.315P
+ PS=2.34U PD=2.34U
M$1355 VSS SEL$48 \$399 VSS nfet_05v0 L=0.6U W=1U AS=0.73P AD=0.73P PS=3.46U
+ PD=3.46U
M$1356 VSS \$400 DUT_IN$49 VSS nfet_05v0 L=0.6U W=0.42U AS=0.315P AD=0.315P
+ PS=2.34U PD=2.34U
M$1357 VSS SEL$49 \$400 VSS nfet_05v0 L=0.6U W=1U AS=0.73P AD=0.73P PS=3.46U
+ PD=3.46U
M$1358 VSS SEL$50 \$401 VSS nfet_05v0 L=0.6U W=1U AS=0.73P AD=0.73P PS=3.46U
+ PD=3.46U
M$1359 VSS \$401 DUT_IN$50 VSS nfet_05v0 L=0.6U W=0.42U AS=0.315P AD=0.315P
+ PS=2.34U PD=2.34U
M$1360 VSS \$402 DUT_IN$51 VSS nfet_05v0 L=0.6U W=0.42U AS=0.315P AD=0.315P
+ PS=2.34U PD=2.34U
M$1361 VSS SEL$51 \$402 VSS nfet_05v0 L=0.6U W=1U AS=0.73P AD=0.73P PS=3.46U
+ PD=3.46U
M$1362 VSS \$403 DUT_IN$52 VSS nfet_05v0 L=0.6U W=0.42U AS=0.315P AD=0.315P
+ PS=2.34U PD=2.34U
M$1363 VSS SEL$52 \$403 VSS nfet_05v0 L=0.6U W=1U AS=0.73P AD=0.73P PS=3.46U
+ PD=3.46U
M$1364 VSS \$404 DUT_IN$53 VSS nfet_05v0 L=0.6U W=0.42U AS=0.315P AD=0.315P
+ PS=2.34U PD=2.34U
M$1365 VSS SEL$53 \$404 VSS nfet_05v0 L=0.6U W=1U AS=0.73P AD=0.73P PS=3.46U
+ PD=3.46U
M$1366 VSS \$405 DUT_IN$54 VSS nfet_05v0 L=0.6U W=0.42U AS=0.315P AD=0.315P
+ PS=2.34U PD=2.34U
M$1367 VSS SEL$54 \$405 VSS nfet_05v0 L=0.6U W=1U AS=0.73P AD=0.73P PS=3.46U
+ PD=3.46U
M$1368 VSS \$406 DUT_IN$55 VSS nfet_05v0 L=0.6U W=0.42U AS=0.315P AD=0.315P
+ PS=2.34U PD=2.34U
M$1369 VSS SEL$55 \$406 VSS nfet_05v0 L=0.6U W=1U AS=0.73P AD=0.73P PS=3.46U
+ PD=3.46U
M$1370 VSS \$407 DUT_IN$56 VSS nfet_05v0 L=0.6U W=0.42U AS=0.315P AD=0.315P
+ PS=2.34U PD=2.34U
M$1371 VSS SEL$56 \$407 VSS nfet_05v0 L=0.6U W=1U AS=0.73P AD=0.73P PS=3.46U
+ PD=3.46U
M$1372 VSS \$408 DUT_IN$57 VSS nfet_05v0 L=0.6U W=0.42U AS=0.315P AD=0.315P
+ PS=2.34U PD=2.34U
M$1373 VSS SEL$57 \$408 VSS nfet_05v0 L=0.6U W=1U AS=0.73P AD=0.73P PS=3.46U
+ PD=3.46U
M$1374 VSS SEL$58 \$409 VSS nfet_05v0 L=0.6U W=1U AS=0.73P AD=0.73P PS=3.46U
+ PD=3.46U
M$1375 VSS \$409 DUT_IN$58 VSS nfet_05v0 L=0.6U W=0.42U AS=0.315P AD=0.315P
+ PS=2.34U PD=2.34U
M$1376 VSS SEL$59 \$410 VSS nfet_05v0 L=0.6U W=1U AS=0.73P AD=0.73P PS=3.46U
+ PD=3.46U
M$1377 VSS \$410 DUT_IN$59 VSS nfet_05v0 L=0.6U W=0.42U AS=0.315P AD=0.315P
+ PS=2.34U PD=2.34U
M$1378 VSS SEL$60 \$411 VSS nfet_05v0 L=0.6U W=1U AS=0.73P AD=0.73P PS=3.46U
+ PD=3.46U
M$1379 VSS \$411 DUT_IN$60 VSS nfet_05v0 L=0.6U W=0.42U AS=0.315P AD=0.315P
+ PS=2.34U PD=2.34U
M$1380 VSS \$412 DUT_IN$61 VSS nfet_05v0 L=0.6U W=0.42U AS=0.315P AD=0.315P
+ PS=2.34U PD=2.34U
M$1381 VSS SEL$61 \$412 VSS nfet_05v0 L=0.6U W=1U AS=0.73P AD=0.73P PS=3.46U
+ PD=3.46U
M$1382 VSS SEL$62 \$413 VSS nfet_05v0 L=0.6U W=1U AS=0.73P AD=0.73P PS=3.46U
+ PD=3.46U
M$1383 VSS \$413 DUT_IN$62 VSS nfet_05v0 L=0.6U W=0.42U AS=0.315P AD=0.315P
+ PS=2.34U PD=2.34U
M$1384 VSS \$414 DUT_IN$63 VSS nfet_05v0 L=0.6U W=0.42U AS=0.315P AD=0.315P
+ PS=2.34U PD=2.34U
M$1385 VSS SEL$63 \$414 VSS nfet_05v0 L=0.6U W=1U AS=0.73P AD=0.73P PS=3.46U
+ PD=3.46U
M$1386 DUT_OUT$48 SEL$48 IN|INV_OUT|OUT VSS nfet_05v0 L=0.6U W=2U AS=1.46P
+ AD=1.46P PS=5.46U PD=5.46U
M$1387 DUT_OUT$49 SEL$49 IN|INV_OUT|OUT VSS nfet_05v0 L=0.6U W=2U AS=1.46P
+ AD=1.46P PS=5.46U PD=5.46U
M$1388 DUT_OUT$50 SEL$50 IN|INV_OUT|OUT VSS nfet_05v0 L=0.6U W=2U AS=1.46P
+ AD=1.46P PS=5.46U PD=5.46U
M$1389 DUT_OUT$51 SEL$51 IN|INV_OUT|OUT VSS nfet_05v0 L=0.6U W=2U AS=1.46P
+ AD=1.46P PS=5.46U PD=5.46U
M$1390 DUT_OUT$52 SEL$52 IN|INV_OUT|OUT VSS nfet_05v0 L=0.6U W=2U AS=1.46P
+ AD=1.46P PS=5.46U PD=5.46U
M$1391 DUT_OUT$53 SEL$53 IN|INV_OUT|OUT VSS nfet_05v0 L=0.6U W=2U AS=1.46P
+ AD=1.46P PS=5.46U PD=5.46U
M$1392 DUT_OUT$54 SEL$54 IN|INV_OUT|OUT VSS nfet_05v0 L=0.6U W=2U AS=1.46P
+ AD=1.46P PS=5.46U PD=5.46U
M$1393 DUT_OUT$55 SEL$55 IN|INV_OUT|OUT VSS nfet_05v0 L=0.6U W=2U AS=1.46P
+ AD=1.46P PS=5.46U PD=5.46U
M$1394 DUT_OUT$56 SEL$56 IN|INV_OUT|OUT VSS nfet_05v0 L=0.6U W=2U AS=1.46P
+ AD=1.46P PS=5.46U PD=5.46U
M$1395 DUT_OUT$57 SEL$57 IN|INV_OUT|OUT VSS nfet_05v0 L=0.6U W=2U AS=1.46P
+ AD=1.46P PS=5.46U PD=5.46U
M$1396 DUT_OUT$58 SEL$58 IN|INV_OUT|OUT VSS nfet_05v0 L=0.6U W=2U AS=1.46P
+ AD=1.46P PS=5.46U PD=5.46U
M$1397 DUT_OUT$59 SEL$59 IN|INV_OUT|OUT VSS nfet_05v0 L=0.6U W=2U AS=1.46P
+ AD=1.46P PS=5.46U PD=5.46U
M$1398 DUT_OUT$60 SEL$60 IN|INV_OUT|OUT VSS nfet_05v0 L=0.6U W=2U AS=1.46P
+ AD=1.46P PS=5.46U PD=5.46U
M$1399 DUT_OUT$61 SEL$61 IN|INV_OUT|OUT VSS nfet_05v0 L=0.6U W=2U AS=1.46P
+ AD=1.46P PS=5.46U PD=5.46U
M$1400 DUT_OUT$62 SEL$62 IN|INV_OUT|OUT VSS nfet_05v0 L=0.6U W=2U AS=1.46P
+ AD=1.46P PS=5.46U PD=5.46U
M$1401 DUT_OUT$63 SEL$63 IN|INV_OUT|OUT VSS nfet_05v0 L=0.6U W=2U AS=1.46P
+ AD=1.46P PS=5.46U PD=5.46U
M$1402 VSS SEL$48 \$416 VSS nfet_05v0 L=0.6U W=1U AS=0.73P AD=0.73P PS=3.46U
+ PD=3.46U
M$1403 VSS SEL$49 \$418 VSS nfet_05v0 L=0.6U W=1U AS=0.73P AD=0.73P PS=3.46U
+ PD=3.46U
M$1404 VSS SEL$50 \$420 VSS nfet_05v0 L=0.6U W=1U AS=0.73P AD=0.73P PS=3.46U
+ PD=3.46U
M$1405 VSS SEL$51 \$422 VSS nfet_05v0 L=0.6U W=1U AS=0.73P AD=0.73P PS=3.46U
+ PD=3.46U
M$1406 VSS SEL$52 \$424 VSS nfet_05v0 L=0.6U W=1U AS=0.73P AD=0.73P PS=3.46U
+ PD=3.46U
M$1407 VSS SEL$53 \$426 VSS nfet_05v0 L=0.6U W=1U AS=0.73P AD=0.73P PS=3.46U
+ PD=3.46U
M$1408 VSS SEL$54 \$428 VSS nfet_05v0 L=0.6U W=1U AS=0.73P AD=0.73P PS=3.46U
+ PD=3.46U
M$1409 VSS SEL$55 \$430 VSS nfet_05v0 L=0.6U W=1U AS=0.73P AD=0.73P PS=3.46U
+ PD=3.46U
M$1410 VSS SEL$56 \$432 VSS nfet_05v0 L=0.6U W=1U AS=0.73P AD=0.73P PS=3.46U
+ PD=3.46U
M$1411 VSS SEL$57 \$434 VSS nfet_05v0 L=0.6U W=1U AS=0.73P AD=0.73P PS=3.46U
+ PD=3.46U
M$1412 VSS SEL$58 \$436 VSS nfet_05v0 L=0.6U W=1U AS=0.73P AD=0.73P PS=3.46U
+ PD=3.46U
M$1413 VSS SEL$59 \$438 VSS nfet_05v0 L=0.6U W=1U AS=0.73P AD=0.73P PS=3.46U
+ PD=3.46U
M$1414 VSS SEL$60 \$440 VSS nfet_05v0 L=0.6U W=1U AS=0.73P AD=0.73P PS=3.46U
+ PD=3.46U
M$1415 VSS SEL$61 \$442 VSS nfet_05v0 L=0.6U W=1U AS=0.73P AD=0.73P PS=3.46U
+ PD=3.46U
M$1416 VSS SEL$62 \$444 VSS nfet_05v0 L=0.6U W=1U AS=0.73P AD=0.73P PS=3.46U
+ PD=3.46U
M$1417 VSS SEL$63 \$446 VSS nfet_05v0 L=0.6U W=1U AS=0.73P AD=0.73P PS=3.46U
+ PD=3.46U
M$1418 DUT_OUT|IN|INV_IN|OUT SEL$64 DUT_IN$64 VSS nfet_05v0 L=0.6U W=2U
+ AS=1.46P AD=1.46P PS=5.46U PD=5.46U
M$1419 DUT_OUT|IN|INV_IN|OUT SEL$65 DUT_IN$65 VSS nfet_05v0 L=0.6U W=2U
+ AS=1.46P AD=1.46P PS=5.46U PD=5.46U
M$1420 DUT_OUT|IN|INV_IN|OUT SEL$66 DUT_IN$66 VSS nfet_05v0 L=0.6U W=2U
+ AS=1.46P AD=1.46P PS=5.46U PD=5.46U
M$1421 DUT_OUT|IN|INV_IN|OUT SEL$67 DUT_IN$67 VSS nfet_05v0 L=0.6U W=2U
+ AS=1.46P AD=1.46P PS=5.46U PD=5.46U
M$1422 DUT_OUT|IN|INV_IN|OUT SEL$68 DUT_IN$68 VSS nfet_05v0 L=0.6U W=2U
+ AS=1.46P AD=1.46P PS=5.46U PD=5.46U
M$1423 DUT_OUT|IN|INV_IN|OUT SEL$69 DUT_IN$69 VSS nfet_05v0 L=0.6U W=2U
+ AS=1.46P AD=1.46P PS=5.46U PD=5.46U
M$1424 DUT_OUT|IN|INV_IN|OUT SEL$70 DUT_IN$70 VSS nfet_05v0 L=0.6U W=2U
+ AS=1.46P AD=1.46P PS=5.46U PD=5.46U
M$1425 DUT_OUT|IN|INV_IN|OUT SEL$71 DUT_IN$71 VSS nfet_05v0 L=0.6U W=2U
+ AS=1.46P AD=1.46P PS=5.46U PD=5.46U
M$1426 DUT_OUT|IN|INV_IN|OUT SEL$72 DUT_IN$72 VSS nfet_05v0 L=0.6U W=2U
+ AS=1.46P AD=1.46P PS=5.46U PD=5.46U
M$1427 DUT_OUT|IN|INV_IN|OUT SEL$73 DUT_IN$73 VSS nfet_05v0 L=0.6U W=2U
+ AS=1.46P AD=1.46P PS=5.46U PD=5.46U
M$1428 DUT_OUT|IN|INV_IN|OUT SEL$74 DUT_IN$74 VSS nfet_05v0 L=0.6U W=2U
+ AS=1.46P AD=1.46P PS=5.46U PD=5.46U
M$1429 DUT_OUT|IN|INV_IN|OUT SEL$75 DUT_IN$75 VSS nfet_05v0 L=0.6U W=2U
+ AS=1.46P AD=1.46P PS=5.46U PD=5.46U
M$1430 DUT_OUT|IN|INV_IN|OUT SEL$76 DUT_IN$76 VSS nfet_05v0 L=0.6U W=2U
+ AS=1.46P AD=1.46P PS=5.46U PD=5.46U
M$1431 DUT_OUT|IN|INV_IN|OUT SEL$77 DUT_IN$77 VSS nfet_05v0 L=0.6U W=2U
+ AS=1.46P AD=1.46P PS=5.46U PD=5.46U
M$1432 DUT_OUT|IN|INV_IN|OUT SEL$78 DUT_IN$78 VSS nfet_05v0 L=0.6U W=2U
+ AS=1.46P AD=1.46P PS=5.46U PD=5.46U
M$1433 DUT_OUT|IN|INV_IN|OUT SEL$79 DUT_IN$79 VSS nfet_05v0 L=0.6U W=2U
+ AS=1.46P AD=1.46P PS=5.46U PD=5.46U
M$1434 VSS SEL$64 \$514 VSS nfet_05v0 L=0.6U W=1U AS=0.73P AD=0.73P PS=3.46U
+ PD=3.46U
M$1435 VSS \$514 DUT_IN$64 VSS nfet_05v0 L=0.6U W=0.42U AS=0.315P AD=0.315P
+ PS=2.34U PD=2.34U
M$1436 VSS \$515 DUT_IN$65 VSS nfet_05v0 L=0.6U W=0.42U AS=0.315P AD=0.315P
+ PS=2.34U PD=2.34U
M$1437 VSS SEL$65 \$515 VSS nfet_05v0 L=0.6U W=1U AS=0.73P AD=0.73P PS=3.46U
+ PD=3.46U
M$1438 VSS SEL$66 \$516 VSS nfet_05v0 L=0.6U W=1U AS=0.73P AD=0.73P PS=3.46U
+ PD=3.46U
M$1439 VSS \$516 DUT_IN$66 VSS nfet_05v0 L=0.6U W=0.42U AS=0.315P AD=0.315P
+ PS=2.34U PD=2.34U
M$1440 VSS SEL$67 \$517 VSS nfet_05v0 L=0.6U W=1U AS=0.73P AD=0.73P PS=3.46U
+ PD=3.46U
M$1441 VSS \$517 DUT_IN$67 VSS nfet_05v0 L=0.6U W=0.42U AS=0.315P AD=0.315P
+ PS=2.34U PD=2.34U
M$1442 VSS \$518 DUT_IN$68 VSS nfet_05v0 L=0.6U W=0.42U AS=0.315P AD=0.315P
+ PS=2.34U PD=2.34U
M$1443 VSS SEL$68 \$518 VSS nfet_05v0 L=0.6U W=1U AS=0.73P AD=0.73P PS=3.46U
+ PD=3.46U
M$1444 VSS SEL$69 \$519 VSS nfet_05v0 L=0.6U W=1U AS=0.73P AD=0.73P PS=3.46U
+ PD=3.46U
M$1445 VSS \$519 DUT_IN$69 VSS nfet_05v0 L=0.6U W=0.42U AS=0.315P AD=0.315P
+ PS=2.34U PD=2.34U
M$1446 VSS SEL$70 \$520 VSS nfet_05v0 L=0.6U W=1U AS=0.73P AD=0.73P PS=3.46U
+ PD=3.46U
M$1447 VSS \$520 DUT_IN$70 VSS nfet_05v0 L=0.6U W=0.42U AS=0.315P AD=0.315P
+ PS=2.34U PD=2.34U
M$1448 VSS SEL$71 \$521 VSS nfet_05v0 L=0.6U W=1U AS=0.73P AD=0.73P PS=3.46U
+ PD=3.46U
M$1449 VSS \$521 DUT_IN$71 VSS nfet_05v0 L=0.6U W=0.42U AS=0.315P AD=0.315P
+ PS=2.34U PD=2.34U
M$1450 VSS SEL$72 \$522 VSS nfet_05v0 L=0.6U W=1U AS=0.73P AD=0.73P PS=3.46U
+ PD=3.46U
M$1451 VSS \$522 DUT_IN$72 VSS nfet_05v0 L=0.6U W=0.42U AS=0.315P AD=0.315P
+ PS=2.34U PD=2.34U
M$1452 VSS SEL$73 \$523 VSS nfet_05v0 L=0.6U W=1U AS=0.73P AD=0.73P PS=3.46U
+ PD=3.46U
M$1453 VSS \$523 DUT_IN$73 VSS nfet_05v0 L=0.6U W=0.42U AS=0.315P AD=0.315P
+ PS=2.34U PD=2.34U
M$1454 VSS SEL$74 \$524 VSS nfet_05v0 L=0.6U W=1U AS=0.73P AD=0.73P PS=3.46U
+ PD=3.46U
M$1455 VSS \$524 DUT_IN$74 VSS nfet_05v0 L=0.6U W=0.42U AS=0.315P AD=0.315P
+ PS=2.34U PD=2.34U
M$1456 VSS SEL$75 \$525 VSS nfet_05v0 L=0.6U W=1U AS=0.73P AD=0.73P PS=3.46U
+ PD=3.46U
M$1457 VSS \$525 DUT_IN$75 VSS nfet_05v0 L=0.6U W=0.42U AS=0.315P AD=0.315P
+ PS=2.34U PD=2.34U
M$1458 VSS \$526 DUT_IN$76 VSS nfet_05v0 L=0.6U W=0.42U AS=0.315P AD=0.315P
+ PS=2.34U PD=2.34U
M$1459 VSS SEL$76 \$526 VSS nfet_05v0 L=0.6U W=1U AS=0.73P AD=0.73P PS=3.46U
+ PD=3.46U
M$1460 VSS \$527 DUT_IN$77 VSS nfet_05v0 L=0.6U W=0.42U AS=0.315P AD=0.315P
+ PS=2.34U PD=2.34U
M$1461 VSS SEL$77 \$527 VSS nfet_05v0 L=0.6U W=1U AS=0.73P AD=0.73P PS=3.46U
+ PD=3.46U
M$1462 VSS SEL$78 \$528 VSS nfet_05v0 L=0.6U W=1U AS=0.73P AD=0.73P PS=3.46U
+ PD=3.46U
M$1463 VSS \$528 DUT_IN$78 VSS nfet_05v0 L=0.6U W=0.42U AS=0.315P AD=0.315P
+ PS=2.34U PD=2.34U
M$1464 VSS \$529 DUT_IN$79 VSS nfet_05v0 L=0.6U W=0.42U AS=0.315P AD=0.315P
+ PS=2.34U PD=2.34U
M$1465 VSS SEL$79 \$529 VSS nfet_05v0 L=0.6U W=1U AS=0.73P AD=0.73P PS=3.46U
+ PD=3.46U
M$1466 DUT_OUT$64 SEL$64 IN|INV_OUT|OUT VSS nfet_05v0 L=0.6U W=2U AS=1.46P
+ AD=1.46P PS=5.46U PD=5.46U
M$1467 DUT_OUT$65 SEL$65 IN|INV_OUT|OUT VSS nfet_05v0 L=0.6U W=2U AS=1.46P
+ AD=1.46P PS=5.46U PD=5.46U
M$1468 DUT_OUT$66 SEL$66 IN|INV_OUT|OUT VSS nfet_05v0 L=0.6U W=2U AS=1.46P
+ AD=1.46P PS=5.46U PD=5.46U
M$1469 DUT_OUT$67 SEL$67 IN|INV_OUT|OUT VSS nfet_05v0 L=0.6U W=2U AS=1.46P
+ AD=1.46P PS=5.46U PD=5.46U
M$1470 DUT_OUT$68 SEL$68 IN|INV_OUT|OUT VSS nfet_05v0 L=0.6U W=2U AS=1.46P
+ AD=1.46P PS=5.46U PD=5.46U
M$1471 DUT_OUT$69 SEL$69 IN|INV_OUT|OUT VSS nfet_05v0 L=0.6U W=2U AS=1.46P
+ AD=1.46P PS=5.46U PD=5.46U
M$1472 DUT_OUT$70 SEL$70 IN|INV_OUT|OUT VSS nfet_05v0 L=0.6U W=2U AS=1.46P
+ AD=1.46P PS=5.46U PD=5.46U
M$1473 DUT_OUT$71 SEL$71 IN|INV_OUT|OUT VSS nfet_05v0 L=0.6U W=2U AS=1.46P
+ AD=1.46P PS=5.46U PD=5.46U
M$1474 DUT_OUT$72 SEL$72 IN|INV_OUT|OUT VSS nfet_05v0 L=0.6U W=2U AS=1.46P
+ AD=1.46P PS=5.46U PD=5.46U
M$1475 DUT_OUT$73 SEL$73 IN|INV_OUT|OUT VSS nfet_05v0 L=0.6U W=2U AS=1.46P
+ AD=1.46P PS=5.46U PD=5.46U
M$1476 DUT_OUT$74 SEL$74 IN|INV_OUT|OUT VSS nfet_05v0 L=0.6U W=2U AS=1.46P
+ AD=1.46P PS=5.46U PD=5.46U
M$1477 DUT_OUT$75 SEL$75 IN|INV_OUT|OUT VSS nfet_05v0 L=0.6U W=2U AS=1.46P
+ AD=1.46P PS=5.46U PD=5.46U
M$1478 DUT_OUT$76 SEL$76 IN|INV_OUT|OUT VSS nfet_05v0 L=0.6U W=2U AS=1.46P
+ AD=1.46P PS=5.46U PD=5.46U
M$1479 DUT_OUT$77 SEL$77 IN|INV_OUT|OUT VSS nfet_05v0 L=0.6U W=2U AS=1.46P
+ AD=1.46P PS=5.46U PD=5.46U
M$1480 DUT_OUT$78 SEL$78 IN|INV_OUT|OUT VSS nfet_05v0 L=0.6U W=2U AS=1.46P
+ AD=1.46P PS=5.46U PD=5.46U
M$1481 DUT_OUT$79 SEL$79 IN|INV_OUT|OUT VSS nfet_05v0 L=0.6U W=2U AS=1.46P
+ AD=1.46P PS=5.46U PD=5.46U
M$1482 VSS SEL$64 \$535 VSS nfet_05v0 L=0.6U W=1U AS=0.73P AD=0.73P PS=3.46U
+ PD=3.46U
M$1483 VSS SEL$65 \$536 VSS nfet_05v0 L=0.6U W=1U AS=0.73P AD=0.73P PS=3.46U
+ PD=3.46U
M$1484 VSS SEL$66 \$537 VSS nfet_05v0 L=0.6U W=1U AS=0.73P AD=0.73P PS=3.46U
+ PD=3.46U
M$1485 VSS SEL$67 \$538 VSS nfet_05v0 L=0.6U W=1U AS=0.73P AD=0.73P PS=3.46U
+ PD=3.46U
M$1486 VSS SEL$68 \$531 VSS nfet_05v0 L=0.6U W=1U AS=0.73P AD=0.73P PS=3.46U
+ PD=3.46U
M$1487 VSS SEL$69 \$539 VSS nfet_05v0 L=0.6U W=1U AS=0.73P AD=0.73P PS=3.46U
+ PD=3.46U
M$1488 VSS SEL$70 \$540 VSS nfet_05v0 L=0.6U W=1U AS=0.73P AD=0.73P PS=3.46U
+ PD=3.46U
M$1489 VSS SEL$71 \$541 VSS nfet_05v0 L=0.6U W=1U AS=0.73P AD=0.73P PS=3.46U
+ PD=3.46U
M$1490 VSS SEL$72 \$542 VSS nfet_05v0 L=0.6U W=1U AS=0.73P AD=0.73P PS=3.46U
+ PD=3.46U
M$1491 VSS SEL$73 \$543 VSS nfet_05v0 L=0.6U W=1U AS=0.73P AD=0.73P PS=3.46U
+ PD=3.46U
M$1492 VSS SEL$74 \$544 VSS nfet_05v0 L=0.6U W=1U AS=0.73P AD=0.73P PS=3.46U
+ PD=3.46U
M$1493 VSS SEL$75 \$532 VSS nfet_05v0 L=0.6U W=1U AS=0.73P AD=0.73P PS=3.46U
+ PD=3.46U
M$1494 VSS SEL$76 \$545 VSS nfet_05v0 L=0.6U W=1U AS=0.73P AD=0.73P PS=3.46U
+ PD=3.46U
M$1495 VSS SEL$77 \$546 VSS nfet_05v0 L=0.6U W=1U AS=0.73P AD=0.73P PS=3.46U
+ PD=3.46U
M$1496 VSS SEL$78 \$533 VSS nfet_05v0 L=0.6U W=1U AS=0.73P AD=0.73P PS=3.46U
+ PD=3.46U
M$1497 VSS SEL$79 \$534 VSS nfet_05v0 L=0.6U W=1U AS=0.73P AD=0.73P PS=3.46U
+ PD=3.46U
M$1498 DUT_OUT|IN|INV_IN|OUT SEL$80 DUT_IN$80 VSS nfet_05v0 L=0.6U W=2U
+ AS=1.46P AD=1.46P PS=5.46U PD=5.46U
M$1499 DUT_OUT|IN|INV_IN|OUT SEL$81 DUT_IN$81 VSS nfet_05v0 L=0.6U W=2U
+ AS=1.46P AD=1.46P PS=5.46U PD=5.46U
M$1500 DUT_OUT|IN|INV_IN|OUT SEL$82 DUT_IN$82 VSS nfet_05v0 L=0.6U W=2U
+ AS=1.46P AD=1.46P PS=5.46U PD=5.46U
M$1501 DUT_OUT|IN|INV_IN|OUT SEL$83 DUT_IN$83 VSS nfet_05v0 L=0.6U W=2U
+ AS=1.46P AD=1.46P PS=5.46U PD=5.46U
M$1502 DUT_OUT|IN|INV_IN|OUT SEL$84 DUT_IN$84 VSS nfet_05v0 L=0.6U W=2U
+ AS=1.46P AD=1.46P PS=5.46U PD=5.46U
M$1503 DUT_OUT|IN|INV_IN|OUT SEL$85 DUT_IN$85 VSS nfet_05v0 L=0.6U W=2U
+ AS=1.46P AD=1.46P PS=5.46U PD=5.46U
M$1504 DUT_OUT|IN|INV_IN|OUT SEL$86 DUT_IN$86 VSS nfet_05v0 L=0.6U W=2U
+ AS=1.46P AD=1.46P PS=5.46U PD=5.46U
M$1505 DUT_OUT|IN|INV_IN|OUT SEL$87 DUT_IN$87 VSS nfet_05v0 L=0.6U W=2U
+ AS=1.46P AD=1.46P PS=5.46U PD=5.46U
M$1506 DUT_OUT|IN|INV_IN|OUT SEL$88 DUT_IN$88 VSS nfet_05v0 L=0.6U W=2U
+ AS=1.46P AD=1.46P PS=5.46U PD=5.46U
M$1507 DUT_OUT|IN|INV_IN|OUT SEL$89 DUT_IN$89 VSS nfet_05v0 L=0.6U W=2U
+ AS=1.46P AD=1.46P PS=5.46U PD=5.46U
M$1508 DUT_OUT|IN|INV_IN|OUT SEL$90 DUT_IN$90 VSS nfet_05v0 L=0.6U W=2U
+ AS=1.46P AD=1.46P PS=5.46U PD=5.46U
M$1509 DUT_OUT|IN|INV_IN|OUT SEL$91 DUT_IN$91 VSS nfet_05v0 L=0.6U W=2U
+ AS=1.46P AD=1.46P PS=5.46U PD=5.46U
M$1510 DUT_OUT|IN|INV_IN|OUT SEL$92 DUT_IN$92 VSS nfet_05v0 L=0.6U W=2U
+ AS=1.46P AD=1.46P PS=5.46U PD=5.46U
M$1511 DUT_OUT|IN|INV_IN|OUT SEL$93 DUT_IN$93 VSS nfet_05v0 L=0.6U W=2U
+ AS=1.46P AD=1.46P PS=5.46U PD=5.46U
M$1512 DUT_OUT|IN|INV_IN|OUT SEL$94 DUT_IN$94 VSS nfet_05v0 L=0.6U W=2U
+ AS=1.46P AD=1.46P PS=5.46U PD=5.46U
M$1513 DUT_OUT|IN|INV_IN|OUT SEL$95 DUT_IN$95 VSS nfet_05v0 L=0.6U W=2U
+ AS=1.46P AD=1.46P PS=5.46U PD=5.46U
M$1514 VSS \$629 DUT_IN$80 VSS nfet_05v0 L=0.6U W=0.42U AS=0.315P AD=0.315P
+ PS=2.34U PD=2.34U
M$1515 VSS SEL$80 \$629 VSS nfet_05v0 L=0.6U W=1U AS=0.73P AD=0.73P PS=3.46U
+ PD=3.46U
M$1516 VSS \$630 DUT_IN$81 VSS nfet_05v0 L=0.6U W=0.42U AS=0.315P AD=0.315P
+ PS=2.34U PD=2.34U
M$1517 VSS SEL$81 \$630 VSS nfet_05v0 L=0.6U W=1U AS=0.73P AD=0.73P PS=3.46U
+ PD=3.46U
M$1518 VSS \$631 DUT_IN$82 VSS nfet_05v0 L=0.6U W=0.42U AS=0.315P AD=0.315P
+ PS=2.34U PD=2.34U
M$1519 VSS SEL$82 \$631 VSS nfet_05v0 L=0.6U W=1U AS=0.73P AD=0.73P PS=3.46U
+ PD=3.46U
M$1520 VSS \$632 DUT_IN$83 VSS nfet_05v0 L=0.6U W=0.42U AS=0.315P AD=0.315P
+ PS=2.34U PD=2.34U
M$1521 VSS SEL$83 \$632 VSS nfet_05v0 L=0.6U W=1U AS=0.73P AD=0.73P PS=3.46U
+ PD=3.46U
M$1522 VSS SEL$84 \$633 VSS nfet_05v0 L=0.6U W=1U AS=0.73P AD=0.73P PS=3.46U
+ PD=3.46U
M$1523 VSS \$633 DUT_IN$84 VSS nfet_05v0 L=0.6U W=0.42U AS=0.315P AD=0.315P
+ PS=2.34U PD=2.34U
M$1524 VSS SEL$85 \$634 VSS nfet_05v0 L=0.6U W=1U AS=0.73P AD=0.73P PS=3.46U
+ PD=3.46U
M$1525 VSS \$634 DUT_IN$85 VSS nfet_05v0 L=0.6U W=0.42U AS=0.315P AD=0.315P
+ PS=2.34U PD=2.34U
M$1526 VSS SEL$86 \$635 VSS nfet_05v0 L=0.6U W=1U AS=0.73P AD=0.73P PS=3.46U
+ PD=3.46U
M$1527 VSS \$635 DUT_IN$86 VSS nfet_05v0 L=0.6U W=0.42U AS=0.315P AD=0.315P
+ PS=2.34U PD=2.34U
M$1528 VSS SEL$87 \$636 VSS nfet_05v0 L=0.6U W=1U AS=0.73P AD=0.73P PS=3.46U
+ PD=3.46U
M$1529 VSS \$636 DUT_IN$87 VSS nfet_05v0 L=0.6U W=0.42U AS=0.315P AD=0.315P
+ PS=2.34U PD=2.34U
M$1530 VSS \$637 DUT_IN$88 VSS nfet_05v0 L=0.6U W=0.42U AS=0.315P AD=0.315P
+ PS=2.34U PD=2.34U
M$1531 VSS SEL$88 \$637 VSS nfet_05v0 L=0.6U W=1U AS=0.73P AD=0.73P PS=3.46U
+ PD=3.46U
M$1532 VSS SEL$89 \$638 VSS nfet_05v0 L=0.6U W=1U AS=0.73P AD=0.73P PS=3.46U
+ PD=3.46U
M$1533 VSS \$638 DUT_IN$89 VSS nfet_05v0 L=0.6U W=0.42U AS=0.315P AD=0.315P
+ PS=2.34U PD=2.34U
M$1534 VSS SEL$90 \$639 VSS nfet_05v0 L=0.6U W=1U AS=0.73P AD=0.73P PS=3.46U
+ PD=3.46U
M$1535 VSS \$639 DUT_IN$90 VSS nfet_05v0 L=0.6U W=0.42U AS=0.315P AD=0.315P
+ PS=2.34U PD=2.34U
M$1536 VSS \$640 DUT_IN$91 VSS nfet_05v0 L=0.6U W=0.42U AS=0.315P AD=0.315P
+ PS=2.34U PD=2.34U
M$1537 VSS SEL$91 \$640 VSS nfet_05v0 L=0.6U W=1U AS=0.73P AD=0.73P PS=3.46U
+ PD=3.46U
M$1538 VSS \$641 DUT_IN$92 VSS nfet_05v0 L=0.6U W=0.42U AS=0.315P AD=0.315P
+ PS=2.34U PD=2.34U
M$1539 VSS SEL$92 \$641 VSS nfet_05v0 L=0.6U W=1U AS=0.73P AD=0.73P PS=3.46U
+ PD=3.46U
M$1540 VSS \$642 DUT_IN$93 VSS nfet_05v0 L=0.6U W=0.42U AS=0.315P AD=0.315P
+ PS=2.34U PD=2.34U
M$1541 VSS SEL$93 \$642 VSS nfet_05v0 L=0.6U W=1U AS=0.73P AD=0.73P PS=3.46U
+ PD=3.46U
M$1542 VSS \$643 DUT_IN$94 VSS nfet_05v0 L=0.6U W=0.42U AS=0.315P AD=0.315P
+ PS=2.34U PD=2.34U
M$1543 VSS SEL$94 \$643 VSS nfet_05v0 L=0.6U W=1U AS=0.73P AD=0.73P PS=3.46U
+ PD=3.46U
M$1544 VSS SEL$95 \$644 VSS nfet_05v0 L=0.6U W=1U AS=0.73P AD=0.73P PS=3.46U
+ PD=3.46U
M$1545 VSS \$644 DUT_IN$95 VSS nfet_05v0 L=0.6U W=0.42U AS=0.315P AD=0.315P
+ PS=2.34U PD=2.34U
M$1546 DUT_OUT$80 SEL$80 IN|INV_OUT|OUT VSS nfet_05v0 L=0.6U W=2U AS=1.46P
+ AD=1.46P PS=5.46U PD=5.46U
M$1547 DUT_OUT$81 SEL$81 IN|INV_OUT|OUT VSS nfet_05v0 L=0.6U W=2U AS=1.46P
+ AD=1.46P PS=5.46U PD=5.46U
M$1548 DUT_OUT$82 SEL$82 IN|INV_OUT|OUT VSS nfet_05v0 L=0.6U W=2U AS=1.46P
+ AD=1.46P PS=5.46U PD=5.46U
M$1549 DUT_OUT$83 SEL$83 IN|INV_OUT|OUT VSS nfet_05v0 L=0.6U W=2U AS=1.46P
+ AD=1.46P PS=5.46U PD=5.46U
M$1550 DUT_OUT$84 SEL$84 IN|INV_OUT|OUT VSS nfet_05v0 L=0.6U W=2U AS=1.46P
+ AD=1.46P PS=5.46U PD=5.46U
M$1551 DUT_OUT$85 SEL$85 IN|INV_OUT|OUT VSS nfet_05v0 L=0.6U W=2U AS=1.46P
+ AD=1.46P PS=5.46U PD=5.46U
M$1552 DUT_OUT$86 SEL$86 IN|INV_OUT|OUT VSS nfet_05v0 L=0.6U W=2U AS=1.46P
+ AD=1.46P PS=5.46U PD=5.46U
M$1553 DUT_OUT$87 SEL$87 IN|INV_OUT|OUT VSS nfet_05v0 L=0.6U W=2U AS=1.46P
+ AD=1.46P PS=5.46U PD=5.46U
M$1554 DUT_OUT$88 SEL$88 IN|INV_OUT|OUT VSS nfet_05v0 L=0.6U W=2U AS=1.46P
+ AD=1.46P PS=5.46U PD=5.46U
M$1555 DUT_OUT$89 SEL$89 IN|INV_OUT|OUT VSS nfet_05v0 L=0.6U W=2U AS=1.46P
+ AD=1.46P PS=5.46U PD=5.46U
M$1556 DUT_OUT$90 SEL$90 IN|INV_OUT|OUT VSS nfet_05v0 L=0.6U W=2U AS=1.46P
+ AD=1.46P PS=5.46U PD=5.46U
M$1557 DUT_OUT$91 SEL$91 IN|INV_OUT|OUT VSS nfet_05v0 L=0.6U W=2U AS=1.46P
+ AD=1.46P PS=5.46U PD=5.46U
M$1558 DUT_OUT$92 SEL$92 IN|INV_OUT|OUT VSS nfet_05v0 L=0.6U W=2U AS=1.46P
+ AD=1.46P PS=5.46U PD=5.46U
M$1559 DUT_OUT$93 SEL$93 IN|INV_OUT|OUT VSS nfet_05v0 L=0.6U W=2U AS=1.46P
+ AD=1.46P PS=5.46U PD=5.46U
M$1560 DUT_OUT$94 SEL$94 IN|INV_OUT|OUT VSS nfet_05v0 L=0.6U W=2U AS=1.46P
+ AD=1.46P PS=5.46U PD=5.46U
M$1561 DUT_OUT$95 SEL$95 IN|INV_OUT|OUT VSS nfet_05v0 L=0.6U W=2U AS=1.46P
+ AD=1.46P PS=5.46U PD=5.46U
M$1562 VSS SEL$80 \$646 VSS nfet_05v0 L=0.6U W=1U AS=0.73P AD=0.73P PS=3.46U
+ PD=3.46U
M$1563 VSS SEL$81 \$647 VSS nfet_05v0 L=0.6U W=1U AS=0.73P AD=0.73P PS=3.46U
+ PD=3.46U
M$1564 VSS SEL$82 \$648 VSS nfet_05v0 L=0.6U W=1U AS=0.73P AD=0.73P PS=3.46U
+ PD=3.46U
M$1565 VSS SEL$83 \$649 VSS nfet_05v0 L=0.6U W=1U AS=0.73P AD=0.73P PS=3.46U
+ PD=3.46U
M$1566 VSS SEL$84 \$650 VSS nfet_05v0 L=0.6U W=1U AS=0.73P AD=0.73P PS=3.46U
+ PD=3.46U
M$1567 VSS SEL$85 \$651 VSS nfet_05v0 L=0.6U W=1U AS=0.73P AD=0.73P PS=3.46U
+ PD=3.46U
M$1568 VSS SEL$86 \$652 VSS nfet_05v0 L=0.6U W=1U AS=0.73P AD=0.73P PS=3.46U
+ PD=3.46U
M$1569 VSS SEL$87 \$653 VSS nfet_05v0 L=0.6U W=1U AS=0.73P AD=0.73P PS=3.46U
+ PD=3.46U
M$1570 VSS SEL$88 \$654 VSS nfet_05v0 L=0.6U W=1U AS=0.73P AD=0.73P PS=3.46U
+ PD=3.46U
M$1571 VSS SEL$89 \$655 VSS nfet_05v0 L=0.6U W=1U AS=0.73P AD=0.73P PS=3.46U
+ PD=3.46U
M$1572 VSS SEL$90 \$656 VSS nfet_05v0 L=0.6U W=1U AS=0.73P AD=0.73P PS=3.46U
+ PD=3.46U
M$1573 VSS SEL$91 \$657 VSS nfet_05v0 L=0.6U W=1U AS=0.73P AD=0.73P PS=3.46U
+ PD=3.46U
M$1574 VSS SEL$92 \$658 VSS nfet_05v0 L=0.6U W=1U AS=0.73P AD=0.73P PS=3.46U
+ PD=3.46U
M$1575 VSS SEL$93 \$659 VSS nfet_05v0 L=0.6U W=1U AS=0.73P AD=0.73P PS=3.46U
+ PD=3.46U
M$1576 VSS SEL$94 \$660 VSS nfet_05v0 L=0.6U W=1U AS=0.73P AD=0.73P PS=3.46U
+ PD=3.46U
M$1577 VSS SEL$95 \$661 VSS nfet_05v0 L=0.6U W=1U AS=0.73P AD=0.73P PS=3.46U
+ PD=3.46U
M$1578 DUT_OUT|IN|INV_IN|OUT SEL$96 DUT_IN$96 VSS nfet_05v0 L=0.6U W=2U
+ AS=1.46P AD=1.46P PS=5.46U PD=5.46U
M$1579 DUT_OUT|IN|INV_IN|OUT SEL$97 DUT_IN$97 VSS nfet_05v0 L=0.6U W=2U
+ AS=1.46P AD=1.46P PS=5.46U PD=5.46U
M$1580 DUT_OUT|IN|INV_IN|OUT SEL$98 DUT_IN$98 VSS nfet_05v0 L=0.6U W=2U
+ AS=1.46P AD=1.46P PS=5.46U PD=5.46U
M$1581 DUT_OUT|IN|INV_IN|OUT SEL$99 DUT_IN$99 VSS nfet_05v0 L=0.6U W=2U
+ AS=1.46P AD=1.46P PS=5.46U PD=5.46U
M$1582 DUT_OUT|IN|INV_IN|OUT SEL$100 DUT_IN$100 VSS nfet_05v0 L=0.6U W=2U
+ AS=1.46P AD=1.46P PS=5.46U PD=5.46U
M$1583 DUT_OUT|IN|INV_IN|OUT SEL$101 DUT_IN$101 VSS nfet_05v0 L=0.6U W=2U
+ AS=1.46P AD=1.46P PS=5.46U PD=5.46U
M$1584 DUT_OUT|IN|INV_IN|OUT SEL$102 DUT_IN$102 VSS nfet_05v0 L=0.6U W=2U
+ AS=1.46P AD=1.46P PS=5.46U PD=5.46U
M$1585 DUT_OUT|IN|INV_IN|OUT SEL$103 DUT_IN$103 VSS nfet_05v0 L=0.6U W=2U
+ AS=1.46P AD=1.46P PS=5.46U PD=5.46U
M$1586 DUT_OUT|IN|INV_IN|OUT SEL$104 DUT_IN$104 VSS nfet_05v0 L=0.6U W=2U
+ AS=1.46P AD=1.46P PS=5.46U PD=5.46U
M$1587 DUT_OUT|IN|INV_IN|OUT SEL$105 DUT_IN$105 VSS nfet_05v0 L=0.6U W=2U
+ AS=1.46P AD=1.46P PS=5.46U PD=5.46U
M$1588 DUT_OUT|IN|INV_IN|OUT SEL$106 DUT_IN$106 VSS nfet_05v0 L=0.6U W=2U
+ AS=1.46P AD=1.46P PS=5.46U PD=5.46U
M$1589 DUT_OUT|IN|INV_IN|OUT SEL$107 DUT_IN$107 VSS nfet_05v0 L=0.6U W=2U
+ AS=1.46P AD=1.46P PS=5.46U PD=5.46U
M$1590 DUT_OUT|IN|INV_IN|OUT SEL$108 DUT_IN$108 VSS nfet_05v0 L=0.6U W=2U
+ AS=1.46P AD=1.46P PS=5.46U PD=5.46U
M$1591 DUT_OUT|IN|INV_IN|OUT SEL$109 DUT_IN$109 VSS nfet_05v0 L=0.6U W=2U
+ AS=1.46P AD=1.46P PS=5.46U PD=5.46U
M$1592 DUT_OUT|IN|INV_IN|OUT SEL$110 DUT_IN$110 VSS nfet_05v0 L=0.6U W=2U
+ AS=1.46P AD=1.46P PS=5.46U PD=5.46U
M$1593 DUT_OUT|IN|INV_IN|OUT SEL$111 DUT_IN$111 VSS nfet_05v0 L=0.6U W=2U
+ AS=1.46P AD=1.46P PS=5.46U PD=5.46U
M$1594 VSS SEL$96 \$744 VSS nfet_05v0 L=0.6U W=1U AS=0.73P AD=0.73P PS=3.46U
+ PD=3.46U
M$1595 VSS \$744 DUT_IN$96 VSS nfet_05v0 L=0.6U W=0.42U AS=0.315P AD=0.315P
+ PS=2.34U PD=2.34U
M$1596 VSS SEL$97 \$745 VSS nfet_05v0 L=0.6U W=1U AS=0.73P AD=0.73P PS=3.46U
+ PD=3.46U
M$1597 VSS \$745 DUT_IN$97 VSS nfet_05v0 L=0.6U W=0.42U AS=0.315P AD=0.315P
+ PS=2.34U PD=2.34U
M$1598 VSS \$746 DUT_IN$98 VSS nfet_05v0 L=0.6U W=0.42U AS=0.315P AD=0.315P
+ PS=2.34U PD=2.34U
M$1599 VSS SEL$98 \$746 VSS nfet_05v0 L=0.6U W=1U AS=0.73P AD=0.73P PS=3.46U
+ PD=3.46U
M$1600 VSS \$747 DUT_IN$99 VSS nfet_05v0 L=0.6U W=0.42U AS=0.315P AD=0.315P
+ PS=2.34U PD=2.34U
M$1601 VSS SEL$99 \$747 VSS nfet_05v0 L=0.6U W=1U AS=0.73P AD=0.73P PS=3.46U
+ PD=3.46U
M$1602 VSS SEL$100 \$748 VSS nfet_05v0 L=0.6U W=1U AS=0.73P AD=0.73P PS=3.46U
+ PD=3.46U
M$1603 VSS \$748 DUT_IN$100 VSS nfet_05v0 L=0.6U W=0.42U AS=0.315P AD=0.315P
+ PS=2.34U PD=2.34U
M$1604 VSS \$749 DUT_IN$101 VSS nfet_05v0 L=0.6U W=0.42U AS=0.315P AD=0.315P
+ PS=2.34U PD=2.34U
M$1605 VSS SEL$101 \$749 VSS nfet_05v0 L=0.6U W=1U AS=0.73P AD=0.73P PS=3.46U
+ PD=3.46U
M$1606 VSS \$750 DUT_IN$102 VSS nfet_05v0 L=0.6U W=0.42U AS=0.315P AD=0.315P
+ PS=2.34U PD=2.34U
M$1607 VSS SEL$102 \$750 VSS nfet_05v0 L=0.6U W=1U AS=0.73P AD=0.73P PS=3.46U
+ PD=3.46U
M$1608 VSS \$751 DUT_IN$103 VSS nfet_05v0 L=0.6U W=0.42U AS=0.315P AD=0.315P
+ PS=2.34U PD=2.34U
M$1609 VSS SEL$103 \$751 VSS nfet_05v0 L=0.6U W=1U AS=0.73P AD=0.73P PS=3.46U
+ PD=3.46U
M$1610 VSS SEL$104 \$752 VSS nfet_05v0 L=0.6U W=1U AS=0.73P AD=0.73P PS=3.46U
+ PD=3.46U
M$1611 VSS \$752 DUT_IN$104 VSS nfet_05v0 L=0.6U W=0.42U AS=0.315P AD=0.315P
+ PS=2.34U PD=2.34U
M$1612 VSS \$753 DUT_IN$105 VSS nfet_05v0 L=0.6U W=0.42U AS=0.315P AD=0.315P
+ PS=2.34U PD=2.34U
M$1613 VSS SEL$105 \$753 VSS nfet_05v0 L=0.6U W=1U AS=0.73P AD=0.73P PS=3.46U
+ PD=3.46U
M$1614 VSS \$754 DUT_IN$106 VSS nfet_05v0 L=0.6U W=0.42U AS=0.315P AD=0.315P
+ PS=2.34U PD=2.34U
M$1615 VSS SEL$106 \$754 VSS nfet_05v0 L=0.6U W=1U AS=0.73P AD=0.73P PS=3.46U
+ PD=3.46U
M$1616 VSS \$755 DUT_IN$107 VSS nfet_05v0 L=0.6U W=0.42U AS=0.315P AD=0.315P
+ PS=2.34U PD=2.34U
M$1617 VSS SEL$107 \$755 VSS nfet_05v0 L=0.6U W=1U AS=0.73P AD=0.73P PS=3.46U
+ PD=3.46U
M$1618 VSS \$756 DUT_IN$108 VSS nfet_05v0 L=0.6U W=0.42U AS=0.315P AD=0.315P
+ PS=2.34U PD=2.34U
M$1619 VSS SEL$108 \$756 VSS nfet_05v0 L=0.6U W=1U AS=0.73P AD=0.73P PS=3.46U
+ PD=3.46U
M$1620 VSS SEL$109 \$757 VSS nfet_05v0 L=0.6U W=1U AS=0.73P AD=0.73P PS=3.46U
+ PD=3.46U
M$1621 VSS \$757 DUT_IN$109 VSS nfet_05v0 L=0.6U W=0.42U AS=0.315P AD=0.315P
+ PS=2.34U PD=2.34U
M$1622 VSS SEL$110 \$758 VSS nfet_05v0 L=0.6U W=1U AS=0.73P AD=0.73P PS=3.46U
+ PD=3.46U
M$1623 VSS \$758 DUT_IN$110 VSS nfet_05v0 L=0.6U W=0.42U AS=0.315P AD=0.315P
+ PS=2.34U PD=2.34U
M$1624 VSS SEL$111 \$759 VSS nfet_05v0 L=0.6U W=1U AS=0.73P AD=0.73P PS=3.46U
+ PD=3.46U
M$1625 VSS \$759 DUT_IN$111 VSS nfet_05v0 L=0.6U W=0.42U AS=0.315P AD=0.315P
+ PS=2.34U PD=2.34U
M$1626 DUT_OUT$96 SEL$96 IN|INV_OUT|OUT VSS nfet_05v0 L=0.6U W=2U AS=1.46P
+ AD=1.46P PS=5.46U PD=5.46U
M$1627 DUT_OUT$97 SEL$97 IN|INV_OUT|OUT VSS nfet_05v0 L=0.6U W=2U AS=1.46P
+ AD=1.46P PS=5.46U PD=5.46U
M$1628 DUT_OUT$98 SEL$98 IN|INV_OUT|OUT VSS nfet_05v0 L=0.6U W=2U AS=1.46P
+ AD=1.46P PS=5.46U PD=5.46U
M$1629 DUT_OUT$99 SEL$99 IN|INV_OUT|OUT VSS nfet_05v0 L=0.6U W=2U AS=1.46P
+ AD=1.46P PS=5.46U PD=5.46U
M$1630 DUT_OUT$100 SEL$100 IN|INV_OUT|OUT VSS nfet_05v0 L=0.6U W=2U AS=1.46P
+ AD=1.46P PS=5.46U PD=5.46U
M$1631 DUT_OUT$101 SEL$101 IN|INV_OUT|OUT VSS nfet_05v0 L=0.6U W=2U AS=1.46P
+ AD=1.46P PS=5.46U PD=5.46U
M$1632 DUT_OUT$102 SEL$102 IN|INV_OUT|OUT VSS nfet_05v0 L=0.6U W=2U AS=1.46P
+ AD=1.46P PS=5.46U PD=5.46U
M$1633 DUT_OUT$103 SEL$103 IN|INV_OUT|OUT VSS nfet_05v0 L=0.6U W=2U AS=1.46P
+ AD=1.46P PS=5.46U PD=5.46U
M$1634 DUT_OUT$104 SEL$104 IN|INV_OUT|OUT VSS nfet_05v0 L=0.6U W=2U AS=1.46P
+ AD=1.46P PS=5.46U PD=5.46U
M$1635 DUT_OUT$105 SEL$105 IN|INV_OUT|OUT VSS nfet_05v0 L=0.6U W=2U AS=1.46P
+ AD=1.46P PS=5.46U PD=5.46U
M$1636 DUT_OUT$106 SEL$106 IN|INV_OUT|OUT VSS nfet_05v0 L=0.6U W=2U AS=1.46P
+ AD=1.46P PS=5.46U PD=5.46U
M$1637 DUT_OUT$107 SEL$107 IN|INV_OUT|OUT VSS nfet_05v0 L=0.6U W=2U AS=1.46P
+ AD=1.46P PS=5.46U PD=5.46U
M$1638 DUT_OUT$108 SEL$108 IN|INV_OUT|OUT VSS nfet_05v0 L=0.6U W=2U AS=1.46P
+ AD=1.46P PS=5.46U PD=5.46U
M$1639 DUT_OUT$109 SEL$109 IN|INV_OUT|OUT VSS nfet_05v0 L=0.6U W=2U AS=1.46P
+ AD=1.46P PS=5.46U PD=5.46U
M$1640 DUT_OUT$110 SEL$110 IN|INV_OUT|OUT VSS nfet_05v0 L=0.6U W=2U AS=1.46P
+ AD=1.46P PS=5.46U PD=5.46U
M$1641 DUT_OUT$111 SEL$111 IN|INV_OUT|OUT VSS nfet_05v0 L=0.6U W=2U AS=1.46P
+ AD=1.46P PS=5.46U PD=5.46U
M$1642 VSS SEL$96 \$777 VSS nfet_05v0 L=0.6U W=1U AS=0.73P AD=0.73P PS=3.46U
+ PD=3.46U
M$1643 VSS SEL$97 \$778 VSS nfet_05v0 L=0.6U W=1U AS=0.73P AD=0.73P PS=3.46U
+ PD=3.46U
M$1644 VSS SEL$98 \$779 VSS nfet_05v0 L=0.6U W=1U AS=0.73P AD=0.73P PS=3.46U
+ PD=3.46U
M$1645 VSS SEL$99 \$780 VSS nfet_05v0 L=0.6U W=1U AS=0.73P AD=0.73P PS=3.46U
+ PD=3.46U
M$1646 VSS SEL$100 \$781 VSS nfet_05v0 L=0.6U W=1U AS=0.73P AD=0.73P PS=3.46U
+ PD=3.46U
M$1647 VSS SEL$101 \$782 VSS nfet_05v0 L=0.6U W=1U AS=0.73P AD=0.73P PS=3.46U
+ PD=3.46U
M$1648 VSS SEL$102 \$783 VSS nfet_05v0 L=0.6U W=1U AS=0.73P AD=0.73P PS=3.46U
+ PD=3.46U
M$1649 VSS SEL$103 \$784 VSS nfet_05v0 L=0.6U W=1U AS=0.73P AD=0.73P PS=3.46U
+ PD=3.46U
M$1650 VSS SEL$104 \$785 VSS nfet_05v0 L=0.6U W=1U AS=0.73P AD=0.73P PS=3.46U
+ PD=3.46U
M$1651 VSS SEL$105 \$786 VSS nfet_05v0 L=0.6U W=1U AS=0.73P AD=0.73P PS=3.46U
+ PD=3.46U
M$1652 VSS SEL$106 \$787 VSS nfet_05v0 L=0.6U W=1U AS=0.73P AD=0.73P PS=3.46U
+ PD=3.46U
M$1653 VSS SEL$107 \$788 VSS nfet_05v0 L=0.6U W=1U AS=0.73P AD=0.73P PS=3.46U
+ PD=3.46U
M$1654 VSS SEL$108 \$789 VSS nfet_05v0 L=0.6U W=1U AS=0.73P AD=0.73P PS=3.46U
+ PD=3.46U
M$1655 VSS SEL$109 \$790 VSS nfet_05v0 L=0.6U W=1U AS=0.73P AD=0.73P PS=3.46U
+ PD=3.46U
M$1656 VSS SEL$110 \$791 VSS nfet_05v0 L=0.6U W=1U AS=0.73P AD=0.73P PS=3.46U
+ PD=3.46U
M$1657 VSS SEL$111 \$792 VSS nfet_05v0 L=0.6U W=1U AS=0.73P AD=0.73P PS=3.46U
+ PD=3.46U
M$1658 DUT_OUT|IN|INV_IN|OUT SEL$112 DUT_IN$112 VSS nfet_05v0 L=0.6U W=2U
+ AS=1.46P AD=1.46P PS=5.46U PD=5.46U
M$1659 DUT_OUT|IN|INV_IN|OUT SEL$113 DUT_IN$113 VSS nfet_05v0 L=0.6U W=2U
+ AS=1.46P AD=1.46P PS=5.46U PD=5.46U
M$1660 DUT_OUT|IN|INV_IN|OUT SEL$114 DUT_IN$114 VSS nfet_05v0 L=0.6U W=2U
+ AS=1.46P AD=1.46P PS=5.46U PD=5.46U
M$1661 DUT_OUT|IN|INV_IN|OUT SEL$115 DUT_IN$115 VSS nfet_05v0 L=0.6U W=2U
+ AS=1.46P AD=1.46P PS=5.46U PD=5.46U
M$1662 DUT_OUT|IN|INV_IN|OUT SEL$116 DUT_IN$116 VSS nfet_05v0 L=0.6U W=2U
+ AS=1.46P AD=1.46P PS=5.46U PD=5.46U
M$1663 DUT_OUT|IN|INV_IN|OUT SEL$117 DUT_IN$117 VSS nfet_05v0 L=0.6U W=2U
+ AS=1.46P AD=1.46P PS=5.46U PD=5.46U
M$1664 DUT_OUT|IN|INV_IN|OUT SEL$118 DUT_IN$118 VSS nfet_05v0 L=0.6U W=2U
+ AS=1.46P AD=1.46P PS=5.46U PD=5.46U
M$1665 DUT_OUT|IN|INV_IN|OUT SEL$119 DUT_IN$119 VSS nfet_05v0 L=0.6U W=2U
+ AS=1.46P AD=1.46P PS=5.46U PD=5.46U
M$1666 DUT_OUT|IN|INV_IN|OUT SEL$120 DUT_IN$120 VSS nfet_05v0 L=0.6U W=2U
+ AS=1.46P AD=1.46P PS=5.46U PD=5.46U
M$1667 DUT_OUT|IN|INV_IN|OUT SEL$121 DUT_IN$121 VSS nfet_05v0 L=0.6U W=2U
+ AS=1.46P AD=1.46P PS=5.46U PD=5.46U
M$1668 DUT_OUT|IN|INV_IN|OUT SEL$122 DUT_IN$122 VSS nfet_05v0 L=0.6U W=2U
+ AS=1.46P AD=1.46P PS=5.46U PD=5.46U
M$1669 DUT_OUT|IN|INV_IN|OUT SEL$123 DUT_IN$123 VSS nfet_05v0 L=0.6U W=2U
+ AS=1.46P AD=1.46P PS=5.46U PD=5.46U
M$1670 DUT_OUT|IN|INV_IN|OUT SEL$124 DUT_IN$124 VSS nfet_05v0 L=0.6U W=2U
+ AS=1.46P AD=1.46P PS=5.46U PD=5.46U
M$1671 DUT_OUT|IN|INV_IN|OUT SEL$125 DUT_IN$125 VSS nfet_05v0 L=0.6U W=2U
+ AS=1.46P AD=1.46P PS=5.46U PD=5.46U
M$1672 DUT_OUT|IN|INV_IN|OUT SEL$126 DUT_IN$126 VSS nfet_05v0 L=0.6U W=2U
+ AS=1.46P AD=1.46P PS=5.46U PD=5.46U
M$1673 DUT_OUT|IN|INV_IN|OUT SEL$127 DUT_IN$127 VSS nfet_05v0 L=0.6U W=2U
+ AS=1.46P AD=1.46P PS=5.46U PD=5.46U
M$1674 VSS \$859 DUT_IN$112 VSS nfet_05v0 L=0.6U W=0.42U AS=0.315P AD=0.315P
+ PS=2.34U PD=2.34U
M$1675 VSS SEL$112 \$859 VSS nfet_05v0 L=0.6U W=1U AS=0.73P AD=0.73P PS=3.46U
+ PD=3.46U
M$1676 VSS SEL$113 \$860 VSS nfet_05v0 L=0.6U W=1U AS=0.73P AD=0.73P PS=3.46U
+ PD=3.46U
M$1677 VSS \$860 DUT_IN$113 VSS nfet_05v0 L=0.6U W=0.42U AS=0.315P AD=0.315P
+ PS=2.34U PD=2.34U
M$1678 VSS SEL$114 \$861 VSS nfet_05v0 L=0.6U W=1U AS=0.73P AD=0.73P PS=3.46U
+ PD=3.46U
M$1679 VSS \$861 DUT_IN$114 VSS nfet_05v0 L=0.6U W=0.42U AS=0.315P AD=0.315P
+ PS=2.34U PD=2.34U
M$1680 VSS \$862 DUT_IN$115 VSS nfet_05v0 L=0.6U W=0.42U AS=0.315P AD=0.315P
+ PS=2.34U PD=2.34U
M$1681 VSS SEL$115 \$862 VSS nfet_05v0 L=0.6U W=1U AS=0.73P AD=0.73P PS=3.46U
+ PD=3.46U
M$1682 VSS SEL$116 \$863 VSS nfet_05v0 L=0.6U W=1U AS=0.73P AD=0.73P PS=3.46U
+ PD=3.46U
M$1683 VSS \$863 DUT_IN$116 VSS nfet_05v0 L=0.6U W=0.42U AS=0.315P AD=0.315P
+ PS=2.34U PD=2.34U
M$1684 VSS SEL$117 \$864 VSS nfet_05v0 L=0.6U W=1U AS=0.73P AD=0.73P PS=3.46U
+ PD=3.46U
M$1685 VSS \$864 DUT_IN$117 VSS nfet_05v0 L=0.6U W=0.42U AS=0.315P AD=0.315P
+ PS=2.34U PD=2.34U
M$1686 VSS \$865 DUT_IN$118 VSS nfet_05v0 L=0.6U W=0.42U AS=0.315P AD=0.315P
+ PS=2.34U PD=2.34U
M$1687 VSS SEL$118 \$865 VSS nfet_05v0 L=0.6U W=1U AS=0.73P AD=0.73P PS=3.46U
+ PD=3.46U
M$1688 VSS SEL$119 \$866 VSS nfet_05v0 L=0.6U W=1U AS=0.73P AD=0.73P PS=3.46U
+ PD=3.46U
M$1689 VSS \$866 DUT_IN$119 VSS nfet_05v0 L=0.6U W=0.42U AS=0.315P AD=0.315P
+ PS=2.34U PD=2.34U
M$1690 VSS SEL$120 \$867 VSS nfet_05v0 L=0.6U W=1U AS=0.73P AD=0.73P PS=3.46U
+ PD=3.46U
M$1691 VSS \$867 DUT_IN$120 VSS nfet_05v0 L=0.6U W=0.42U AS=0.315P AD=0.315P
+ PS=2.34U PD=2.34U
M$1692 VSS SEL$121 \$868 VSS nfet_05v0 L=0.6U W=1U AS=0.73P AD=0.73P PS=3.46U
+ PD=3.46U
M$1693 VSS \$868 DUT_IN$121 VSS nfet_05v0 L=0.6U W=0.42U AS=0.315P AD=0.315P
+ PS=2.34U PD=2.34U
M$1694 VSS \$869 DUT_IN$122 VSS nfet_05v0 L=0.6U W=0.42U AS=0.315P AD=0.315P
+ PS=2.34U PD=2.34U
M$1695 VSS SEL$122 \$869 VSS nfet_05v0 L=0.6U W=1U AS=0.73P AD=0.73P PS=3.46U
+ PD=3.46U
M$1696 VSS SEL$123 \$870 VSS nfet_05v0 L=0.6U W=1U AS=0.73P AD=0.73P PS=3.46U
+ PD=3.46U
M$1697 VSS \$870 DUT_IN$123 VSS nfet_05v0 L=0.6U W=0.42U AS=0.315P AD=0.315P
+ PS=2.34U PD=2.34U
M$1698 VSS \$871 DUT_IN$124 VSS nfet_05v0 L=0.6U W=0.42U AS=0.315P AD=0.315P
+ PS=2.34U PD=2.34U
M$1699 VSS SEL$124 \$871 VSS nfet_05v0 L=0.6U W=1U AS=0.73P AD=0.73P PS=3.46U
+ PD=3.46U
M$1700 VSS SEL$125 \$872 VSS nfet_05v0 L=0.6U W=1U AS=0.73P AD=0.73P PS=3.46U
+ PD=3.46U
M$1701 VSS \$872 DUT_IN$125 VSS nfet_05v0 L=0.6U W=0.42U AS=0.315P AD=0.315P
+ PS=2.34U PD=2.34U
M$1702 VSS \$873 DUT_IN$126 VSS nfet_05v0 L=0.6U W=0.42U AS=0.315P AD=0.315P
+ PS=2.34U PD=2.34U
M$1703 VSS SEL$126 \$873 VSS nfet_05v0 L=0.6U W=1U AS=0.73P AD=0.73P PS=3.46U
+ PD=3.46U
M$1704 VSS \$874 DUT_IN$127 VSS nfet_05v0 L=0.6U W=0.42U AS=0.315P AD=0.315P
+ PS=2.34U PD=2.34U
M$1705 VSS SEL$127 \$874 VSS nfet_05v0 L=0.6U W=1U AS=0.73P AD=0.73P PS=3.46U
+ PD=3.46U
M$1706 DUT_OUT$112 SEL$112 IN|INV_OUT|OUT VSS nfet_05v0 L=0.6U W=2U AS=1.46P
+ AD=1.46P PS=5.46U PD=5.46U
M$1707 DUT_OUT$113 SEL$113 IN|INV_OUT|OUT VSS nfet_05v0 L=0.6U W=2U AS=1.46P
+ AD=1.46P PS=5.46U PD=5.46U
M$1708 DUT_OUT$114 SEL$114 IN|INV_OUT|OUT VSS nfet_05v0 L=0.6U W=2U AS=1.46P
+ AD=1.46P PS=5.46U PD=5.46U
M$1709 DUT_OUT$115 SEL$115 IN|INV_OUT|OUT VSS nfet_05v0 L=0.6U W=2U AS=1.46P
+ AD=1.46P PS=5.46U PD=5.46U
M$1710 DUT_OUT$116 SEL$116 IN|INV_OUT|OUT VSS nfet_05v0 L=0.6U W=2U AS=1.46P
+ AD=1.46P PS=5.46U PD=5.46U
M$1711 DUT_OUT$117 SEL$117 IN|INV_OUT|OUT VSS nfet_05v0 L=0.6U W=2U AS=1.46P
+ AD=1.46P PS=5.46U PD=5.46U
M$1712 DUT_OUT$118 SEL$118 IN|INV_OUT|OUT VSS nfet_05v0 L=0.6U W=2U AS=1.46P
+ AD=1.46P PS=5.46U PD=5.46U
M$1713 DUT_OUT$119 SEL$119 IN|INV_OUT|OUT VSS nfet_05v0 L=0.6U W=2U AS=1.46P
+ AD=1.46P PS=5.46U PD=5.46U
M$1714 DUT_OUT$120 SEL$120 IN|INV_OUT|OUT VSS nfet_05v0 L=0.6U W=2U AS=1.46P
+ AD=1.46P PS=5.46U PD=5.46U
M$1715 DUT_OUT$121 SEL$121 IN|INV_OUT|OUT VSS nfet_05v0 L=0.6U W=2U AS=1.46P
+ AD=1.46P PS=5.46U PD=5.46U
M$1716 DUT_OUT$122 SEL$122 IN|INV_OUT|OUT VSS nfet_05v0 L=0.6U W=2U AS=1.46P
+ AD=1.46P PS=5.46U PD=5.46U
M$1717 DUT_OUT$123 SEL$123 IN|INV_OUT|OUT VSS nfet_05v0 L=0.6U W=2U AS=1.46P
+ AD=1.46P PS=5.46U PD=5.46U
M$1718 DUT_OUT$124 SEL$124 IN|INV_OUT|OUT VSS nfet_05v0 L=0.6U W=2U AS=1.46P
+ AD=1.46P PS=5.46U PD=5.46U
M$1719 DUT_OUT$125 SEL$125 IN|INV_OUT|OUT VSS nfet_05v0 L=0.6U W=2U AS=1.46P
+ AD=1.46P PS=5.46U PD=5.46U
M$1720 DUT_OUT$126 SEL$126 IN|INV_OUT|OUT VSS nfet_05v0 L=0.6U W=2U AS=1.46P
+ AD=1.46P PS=5.46U PD=5.46U
M$1721 DUT_OUT$127 SEL$127 IN|INV_OUT|OUT VSS nfet_05v0 L=0.6U W=2U AS=1.46P
+ AD=1.46P PS=5.46U PD=5.46U
M$1722 VSS SEL$112 \$876 VSS nfet_05v0 L=0.6U W=1U AS=0.73P AD=0.73P PS=3.46U
+ PD=3.46U
M$1723 VSS SEL$113 \$877 VSS nfet_05v0 L=0.6U W=1U AS=0.73P AD=0.73P PS=3.46U
+ PD=3.46U
M$1724 VSS SEL$114 \$878 VSS nfet_05v0 L=0.6U W=1U AS=0.73P AD=0.73P PS=3.46U
+ PD=3.46U
M$1725 VSS SEL$115 \$879 VSS nfet_05v0 L=0.6U W=1U AS=0.73P AD=0.73P PS=3.46U
+ PD=3.46U
M$1726 VSS SEL$116 \$880 VSS nfet_05v0 L=0.6U W=1U AS=0.73P AD=0.73P PS=3.46U
+ PD=3.46U
M$1727 VSS SEL$117 \$881 VSS nfet_05v0 L=0.6U W=1U AS=0.73P AD=0.73P PS=3.46U
+ PD=3.46U
M$1728 VSS SEL$118 \$882 VSS nfet_05v0 L=0.6U W=1U AS=0.73P AD=0.73P PS=3.46U
+ PD=3.46U
M$1729 VSS SEL$119 \$883 VSS nfet_05v0 L=0.6U W=1U AS=0.73P AD=0.73P PS=3.46U
+ PD=3.46U
M$1730 VSS SEL$120 \$884 VSS nfet_05v0 L=0.6U W=1U AS=0.73P AD=0.73P PS=3.46U
+ PD=3.46U
M$1731 VSS SEL$121 \$885 VSS nfet_05v0 L=0.6U W=1U AS=0.73P AD=0.73P PS=3.46U
+ PD=3.46U
M$1732 VSS SEL$122 \$886 VSS nfet_05v0 L=0.6U W=1U AS=0.73P AD=0.73P PS=3.46U
+ PD=3.46U
M$1733 VSS SEL$123 \$887 VSS nfet_05v0 L=0.6U W=1U AS=0.73P AD=0.73P PS=3.46U
+ PD=3.46U
M$1734 VSS SEL$124 \$888 VSS nfet_05v0 L=0.6U W=1U AS=0.73P AD=0.73P PS=3.46U
+ PD=3.46U
M$1735 VSS SEL$125 \$889 VSS nfet_05v0 L=0.6U W=1U AS=0.73P AD=0.73P PS=3.46U
+ PD=3.46U
M$1736 VSS SEL$126 \$890 VSS nfet_05v0 L=0.6U W=1U AS=0.73P AD=0.73P PS=3.46U
+ PD=3.46U
M$1737 VSS SEL$127 \$891 VSS nfet_05v0 L=0.6U W=1U AS=0.73P AD=0.73P PS=3.46U
+ PD=3.46U
M$1738 VSS VCTRL \$965 VSS nfet_05v0 L=2U W=2U AS=1.46P AD=1.04P PS=5.46U
+ PD=3.04U
M$1739 \$944 \$944 VSS VSS nfet_05v0 L=1U W=4U AS=1.56P AD=1.98P PS=5.56U
+ PD=7.98U
M$1741 VSS \$944 \$945 VSS nfet_05v0 L=1U W=4U AS=1.98P AD=1.56P PS=7.98U
+ PD=5.56U
M$1743 \$946 DUT_IN$128 \$945 VSS nfet_05v0 L=0.6U W=2U AS=1.04P AD=1.46P
+ PS=3.04U PD=5.46U
M$1744 IN|INV_OUT|OUT SEL|VCO_EN DUT_IN$128 VSS nfet_05v0 L=0.6U W=2U AS=1.46P
+ AD=1.46P PS=5.46U PD=5.46U
M$1745 VSS \$938 DUT_IN$128 VSS nfet_05v0 L=0.6U W=0.42U AS=0.315P AD=0.315P
+ PS=2.34U PD=2.34U
M$1746 VSS SEL|VCO_EN \$938 VSS nfet_05v0 L=0.6U W=1U AS=0.73P AD=0.73P
+ PS=3.46U PD=3.46U
M$1747 VSS \$944 \$947 VSS nfet_05v0 L=1U W=4U AS=1.98P AD=1.56P PS=7.98U
+ PD=5.56U
M$1749 \$948 \$946 \$947 VSS nfet_05v0 L=0.6U W=2U AS=1.04P AD=1.46P PS=3.04U
+ PD=5.46U
M$1750 IN|INV_OUT|OUT \$935 DUT_IN|OUT VSS nfet_05v0 L=0.6U W=2U AS=1.46P
+ AD=1.46P PS=5.46U PD=5.46U
M$1751 VSS SEL|VCO_EN \$935 VSS nfet_05v0 L=0.6U W=1U AS=0.73P AD=0.73P
+ PS=3.46U PD=3.46U
M$1752 VSS \$944 \$949 VSS nfet_05v0 L=1U W=4U AS=1.98P AD=1.56P PS=7.98U
+ PD=5.56U
M$1754 \$950 \$948 \$949 VSS nfet_05v0 L=0.6U W=2U AS=1.04P AD=1.46P PS=3.04U
+ PD=5.46U
M$1755 \$951 \$950 VSS VSS nfet_05v0 L=0.6U W=1U AS=0.73P AD=0.73P PS=3.46U
+ PD=3.46U
M$1756 VSS \$951 FOUT VSS nfet_05v0 L=0.6U W=4U AS=1.93P AD=1.93P PS=8.86U
+ PD=8.86U
M$1760 VSS \$944 \$953 VSS nfet_05v0 L=1U W=4U AS=1.98P AD=1.56P PS=7.98U
+ PD=5.56U
M$1762 \$954 \$950 \$953 VSS nfet_05v0 L=0.6U W=2U AS=1.04P AD=1.46P PS=3.04U
+ PD=5.46U
M$1763 VSS \$944 \$955 VSS nfet_05v0 L=1U W=4U AS=1.98P AD=1.56P PS=7.98U
+ PD=5.56U
M$1765 \$956 \$954 \$955 VSS nfet_05v0 L=0.6U W=2U AS=1.04P AD=1.46P PS=3.04U
+ PD=5.46U
M$1766 VSS \$944 \$957 VSS nfet_05v0 L=1U W=16U AS=5.1P AD=4.68P PS=23.1U
+ PD=20.68U
M$1774 DUT_OUT$128 \$956 \$957 VSS nfet_05v0 L=0.6U W=6U AS=2.64P AD=3.06P
+ PS=8.64U PD=11.06U
M$1777 IN|OUT \$939 DUT_OUT|IN|INV_IN|OUT VSS nfet_05v0 L=0.6U W=2U AS=1.46P
+ AD=1.46P PS=5.46U PD=5.46U
M$1778 VSS SEL|VCO_EN \$939 VSS nfet_05v0 L=0.6U W=1U AS=0.73P AD=0.73P
+ PS=3.46U PD=3.46U
M$1779 DUT_OUT$128 SEL|VCO_EN DUT_OUT|IN|INV_IN|OUT VSS nfet_05v0 L=0.6U W=2U
+ AS=1.46P AD=1.46P PS=5.46U PD=5.46U
M$1780 VSS SEL|VCO_EN \$940 VSS nfet_05v0 L=0.6U W=1U AS=0.73P AD=0.73P
+ PS=3.46U PD=3.46U
D$1781 VSS SEL diode_nw2ps_06v0 A=0.864P P=6.24U
D$1782 VSS SEL$1 diode_nw2ps_06v0 A=0.864P P=6.24U
D$1783 VSS SEL$2 diode_nw2ps_06v0 A=0.864P P=6.24U
D$1784 VSS SEL$3 diode_nw2ps_06v0 A=0.864P P=6.24U
D$1785 VSS SEL$4 diode_nw2ps_06v0 A=0.864P P=6.24U
D$1786 VSS SEL$5 diode_nw2ps_06v0 A=0.864P P=6.24U
D$1787 VSS SEL$6 diode_nw2ps_06v0 A=0.864P P=6.24U
D$1788 VSS SEL$7 diode_nw2ps_06v0 A=0.864P P=6.24U
D$1789 VSS SEL$8 diode_nw2ps_06v0 A=0.864P P=6.24U
D$1790 VSS SEL$9 diode_nw2ps_06v0 A=0.864P P=6.24U
D$1791 VSS SEL$10 diode_nw2ps_06v0 A=0.864P P=6.24U
D$1792 VSS SEL$11 diode_nw2ps_06v0 A=0.864P P=6.24U
D$1793 VSS SEL$12 diode_nw2ps_06v0 A=0.864P P=6.24U
D$1794 VSS SEL$13 diode_nw2ps_06v0 A=0.864P P=6.24U
D$1795 VSS SEL$14 diode_nw2ps_06v0 A=0.864P P=6.24U
D$1796 VSS SEL$15 diode_nw2ps_06v0 A=0.864P P=6.24U
D$1813 VSS SEL$16 diode_nw2ps_06v0 A=0.864P P=6.24U
D$1814 VSS SEL$17 diode_nw2ps_06v0 A=0.864P P=6.24U
D$1815 VSS SEL$18 diode_nw2ps_06v0 A=0.864P P=6.24U
D$1816 VSS SEL$19 diode_nw2ps_06v0 A=0.864P P=6.24U
D$1817 VSS SEL$20 diode_nw2ps_06v0 A=0.864P P=6.24U
D$1818 VSS SEL$21 diode_nw2ps_06v0 A=0.864P P=6.24U
D$1819 VSS SEL$22 diode_nw2ps_06v0 A=0.864P P=6.24U
D$1820 VSS SEL$23 diode_nw2ps_06v0 A=0.864P P=6.24U
D$1821 VSS SEL$24 diode_nw2ps_06v0 A=0.864P P=6.24U
D$1822 VSS SEL$25 diode_nw2ps_06v0 A=0.864P P=6.24U
D$1823 VSS SEL$26 diode_nw2ps_06v0 A=0.864P P=6.24U
D$1824 VSS SEL$27 diode_nw2ps_06v0 A=0.864P P=6.24U
D$1825 VSS SEL$28 diode_nw2ps_06v0 A=0.864P P=6.24U
D$1826 VSS SEL$29 diode_nw2ps_06v0 A=0.864P P=6.24U
D$1827 VSS SEL$30 diode_nw2ps_06v0 A=0.864P P=6.24U
D$1828 VSS SEL$31 diode_nw2ps_06v0 A=0.864P P=6.24U
D$1845 VSS SEL$32 diode_nw2ps_06v0 A=0.864P P=6.24U
D$1846 VSS SEL$33 diode_nw2ps_06v0 A=0.864P P=6.24U
D$1847 VSS SEL$34 diode_nw2ps_06v0 A=0.864P P=6.24U
D$1848 VSS SEL$35 diode_nw2ps_06v0 A=0.864P P=6.24U
D$1849 VSS SEL$36 diode_nw2ps_06v0 A=0.864P P=6.24U
D$1850 VSS SEL$37 diode_nw2ps_06v0 A=0.864P P=6.24U
D$1851 VSS SEL$38 diode_nw2ps_06v0 A=0.864P P=6.24U
D$1852 VSS SEL$39 diode_nw2ps_06v0 A=0.864P P=6.24U
D$1853 VSS SEL$40 diode_nw2ps_06v0 A=0.864P P=6.24U
D$1854 VSS SEL$41 diode_nw2ps_06v0 A=0.864P P=6.24U
D$1855 VSS SEL$42 diode_nw2ps_06v0 A=0.864P P=6.24U
D$1856 VSS SEL$43 diode_nw2ps_06v0 A=0.864P P=6.24U
D$1857 VSS SEL$44 diode_nw2ps_06v0 A=0.864P P=6.24U
D$1858 VSS SEL$45 diode_nw2ps_06v0 A=0.864P P=6.24U
D$1859 VSS SEL$46 diode_nw2ps_06v0 A=0.864P P=6.24U
D$1860 VSS SEL$47 diode_nw2ps_06v0 A=0.864P P=6.24U
D$1877 VSS SEL$48 diode_nw2ps_06v0 A=0.864P P=6.24U
D$1878 VSS SEL$49 diode_nw2ps_06v0 A=0.864P P=6.24U
D$1879 VSS SEL$50 diode_nw2ps_06v0 A=0.864P P=6.24U
D$1880 VSS SEL$51 diode_nw2ps_06v0 A=0.864P P=6.24U
D$1881 VSS SEL$52 diode_nw2ps_06v0 A=0.864P P=6.24U
D$1882 VSS SEL$53 diode_nw2ps_06v0 A=0.864P P=6.24U
D$1883 VSS SEL$54 diode_nw2ps_06v0 A=0.864P P=6.24U
D$1884 VSS SEL$55 diode_nw2ps_06v0 A=0.864P P=6.24U
D$1885 VSS SEL$56 diode_nw2ps_06v0 A=0.864P P=6.24U
D$1886 VSS SEL$57 diode_nw2ps_06v0 A=0.864P P=6.24U
D$1887 VSS SEL$58 diode_nw2ps_06v0 A=0.864P P=6.24U
D$1888 VSS SEL$59 diode_nw2ps_06v0 A=0.864P P=6.24U
D$1889 VSS SEL$60 diode_nw2ps_06v0 A=0.864P P=6.24U
D$1890 VSS SEL$61 diode_nw2ps_06v0 A=0.864P P=6.24U
D$1891 VSS SEL$62 diode_nw2ps_06v0 A=0.864P P=6.24U
D$1892 VSS SEL$63 diode_nw2ps_06v0 A=0.864P P=6.24U
D$1909 VSS SEL$64 diode_nw2ps_06v0 A=0.864P P=6.24U
D$1910 VSS SEL$65 diode_nw2ps_06v0 A=0.864P P=6.24U
D$1911 VSS SEL$66 diode_nw2ps_06v0 A=0.864P P=6.24U
D$1912 VSS SEL$67 diode_nw2ps_06v0 A=0.864P P=6.24U
D$1913 VSS SEL$68 diode_nw2ps_06v0 A=0.864P P=6.24U
D$1914 VSS SEL$69 diode_nw2ps_06v0 A=0.864P P=6.24U
D$1915 VSS SEL$70 diode_nw2ps_06v0 A=0.864P P=6.24U
D$1916 VSS SEL$71 diode_nw2ps_06v0 A=0.864P P=6.24U
D$1917 VSS SEL$72 diode_nw2ps_06v0 A=0.864P P=6.24U
D$1918 VSS SEL$73 diode_nw2ps_06v0 A=0.864P P=6.24U
D$1919 VSS SEL$74 diode_nw2ps_06v0 A=0.864P P=6.24U
D$1920 VSS SEL$75 diode_nw2ps_06v0 A=0.864P P=6.24U
D$1921 VSS SEL$76 diode_nw2ps_06v0 A=0.864P P=6.24U
D$1922 VSS SEL$77 diode_nw2ps_06v0 A=0.864P P=6.24U
D$1923 VSS SEL$78 diode_nw2ps_06v0 A=0.864P P=6.24U
D$1924 VSS SEL$79 diode_nw2ps_06v0 A=0.864P P=6.24U
D$1941 VSS SEL$80 diode_nw2ps_06v0 A=0.864P P=6.24U
D$1942 VSS SEL$81 diode_nw2ps_06v0 A=0.864P P=6.24U
D$1943 VSS SEL$82 diode_nw2ps_06v0 A=0.864P P=6.24U
D$1944 VSS SEL$83 diode_nw2ps_06v0 A=0.864P P=6.24U
D$1945 VSS SEL$84 diode_nw2ps_06v0 A=0.864P P=6.24U
D$1946 VSS SEL$85 diode_nw2ps_06v0 A=0.864P P=6.24U
D$1947 VSS SEL$86 diode_nw2ps_06v0 A=0.864P P=6.24U
D$1948 VSS SEL$87 diode_nw2ps_06v0 A=0.864P P=6.24U
D$1949 VSS SEL$88 diode_nw2ps_06v0 A=0.864P P=6.24U
D$1950 VSS SEL$89 diode_nw2ps_06v0 A=0.864P P=6.24U
D$1951 VSS SEL$90 diode_nw2ps_06v0 A=0.864P P=6.24U
D$1952 VSS SEL$91 diode_nw2ps_06v0 A=0.864P P=6.24U
D$1953 VSS SEL$92 diode_nw2ps_06v0 A=0.864P P=6.24U
D$1954 VSS SEL$93 diode_nw2ps_06v0 A=0.864P P=6.24U
D$1955 VSS SEL$94 diode_nw2ps_06v0 A=0.864P P=6.24U
D$1956 VSS SEL$95 diode_nw2ps_06v0 A=0.864P P=6.24U
D$1973 VSS SEL$96 diode_nw2ps_06v0 A=0.864P P=6.24U
D$1974 VSS SEL$97 diode_nw2ps_06v0 A=0.864P P=6.24U
D$1975 VSS SEL$98 diode_nw2ps_06v0 A=0.864P P=6.24U
D$1976 VSS SEL$99 diode_nw2ps_06v0 A=0.864P P=6.24U
D$1977 VSS SEL$100 diode_nw2ps_06v0 A=0.864P P=6.24U
D$1978 VSS SEL$101 diode_nw2ps_06v0 A=0.864P P=6.24U
D$1979 VSS SEL$102 diode_nw2ps_06v0 A=0.864P P=6.24U
D$1980 VSS SEL$103 diode_nw2ps_06v0 A=0.864P P=6.24U
D$1981 VSS SEL$104 diode_nw2ps_06v0 A=0.864P P=6.24U
D$1982 VSS SEL$105 diode_nw2ps_06v0 A=0.864P P=6.24U
D$1983 VSS SEL$106 diode_nw2ps_06v0 A=0.864P P=6.24U
D$1984 VSS SEL$107 diode_nw2ps_06v0 A=0.864P P=6.24U
D$1985 VSS SEL$108 diode_nw2ps_06v0 A=0.864P P=6.24U
D$1986 VSS SEL$109 diode_nw2ps_06v0 A=0.864P P=6.24U
D$1987 VSS SEL$110 diode_nw2ps_06v0 A=0.864P P=6.24U
D$1988 VSS SEL$111 diode_nw2ps_06v0 A=0.864P P=6.24U
D$2005 VSS SEL$112 diode_nw2ps_06v0 A=0.864P P=6.24U
D$2006 VSS SEL$113 diode_nw2ps_06v0 A=0.864P P=6.24U
D$2007 VSS SEL$114 diode_nw2ps_06v0 A=0.864P P=6.24U
D$2008 VSS SEL$115 diode_nw2ps_06v0 A=0.864P P=6.24U
D$2009 VSS SEL$116 diode_nw2ps_06v0 A=0.864P P=6.24U
D$2010 VSS SEL$117 diode_nw2ps_06v0 A=0.864P P=6.24U
D$2011 VSS SEL$118 diode_nw2ps_06v0 A=0.864P P=6.24U
D$2012 VSS SEL$119 diode_nw2ps_06v0 A=0.864P P=6.24U
D$2013 VSS SEL$120 diode_nw2ps_06v0 A=0.864P P=6.24U
D$2014 VSS SEL$121 diode_nw2ps_06v0 A=0.864P P=6.24U
D$2015 VSS SEL$122 diode_nw2ps_06v0 A=0.864P P=6.24U
D$2016 VSS SEL$123 diode_nw2ps_06v0 A=0.864P P=6.24U
D$2017 VSS SEL$124 diode_nw2ps_06v0 A=0.864P P=6.24U
D$2018 VSS SEL$125 diode_nw2ps_06v0 A=0.864P P=6.24U
D$2019 VSS SEL$126 diode_nw2ps_06v0 A=0.864P P=6.24U
D$2020 VSS SEL$127 diode_nw2ps_06v0 A=0.864P P=6.24U
D$2037 VSS VCTRL diode_nw2ps_06v0 A=0.3344P P=2.52U
D$2038 VSS SEL|VCO_EN diode_nw2ps_06v0 A=1.728P P=12.48U
D$2042 VSS D[0] diode_nw2ps_06v0 A=0.3888P P=2.88U
D$2043 VSS D[1] diode_nw2ps_06v0 A=0.3888P P=2.88U
D$2044 VSS D[2] diode_nw2ps_06v0 A=0.3888P P=2.88U
D$2045 VSS D[3] diode_nw2ps_06v0 A=0.3888P P=2.88U
D$2046 VSS D[4] diode_nw2ps_06v0 A=0.3888P P=2.88U
D$2047 VSS D[5] diode_nw2ps_06v0 A=0.3888P P=2.88U
D$2048 VSS D[6] diode_nw2ps_06v0 A=0.3888P P=2.88U
.ENDS workshop_inverter

.SUBCKT inv_dut_125 Q A VDD VSS
M$1 Q A VDD VDD pfet_03v3 L=0.6U W=5.4U AS=3.51P AD=3.51P PS=12.1U PD=12.1U
M$2 Q A VSS VSS nfet_03v3 L=0.6U W=1.8U AS=1.098P AD=1.098P PS=4.82U PD=4.82U
.ENDS inv_dut_125

.SUBCKT inv_dut_124 Q A VDD VSS
M$1 Q A VDD VDD pfet_03v3 L=0.6U W=2.7U AS=1.755P AD=1.755P PS=6.7U PD=6.7U
M$2 Q A VSS VSS nfet_03v3 L=0.6U W=0.9U AS=0.549P AD=0.549P PS=3.02U PD=3.02U
.ENDS inv_dut_124

.SUBCKT inv_dut_095 Q A VDD VSS
M$1 Q A VDD VDD pfet_03v3 L=0.9U W=8.1U AS=5.265P AD=5.265P PS=17.5U PD=17.5U
M$2 Q A VSS VSS nfet_03v3 L=0.9U W=2.7U AS=1.647P AD=1.647P PS=6.62U PD=6.62U
.ENDS inv_dut_095

.SUBCKT inv_dut_094 Q A VDD VSS
M$1 Q A VDD VDD pfet_03v3 L=0.6U W=8.1U AS=5.265P AD=5.265P PS=17.5U PD=17.5U
M$2 Q A VSS VSS nfet_03v3 L=0.6U W=2.7U AS=1.647P AD=1.647P PS=6.62U PD=6.62U
.ENDS inv_dut_094

.SUBCKT inv_dut_093 Q A VDD VSS
M$1 Q A VDD VDD pfet_03v3 L=0.6U W=5.4U AS=3.51P AD=3.51P PS=12.1U PD=12.1U
M$2 Q A VSS VSS nfet_03v3 L=0.6U W=1.8U AS=1.098P AD=1.098P PS=4.82U PD=4.82U
.ENDS inv_dut_093

.SUBCKT inv_dut_111 Q A VDD VSS
M$1 Q A VDD VDD pfet_05v0 L=1.8U W=16.2U AS=12.474P AD=12.474P PS=33.94U
+ PD=33.94U
M$2 Q A VSS VSS nfet_05v0 L=1.8U W=5.4U AS=3.942P AD=3.942P PS=12.26U PD=12.26U
.ENDS inv_dut_111

.SUBCKT inv_dut_110 Q A VDD VSS
M$1 Q A VDD VDD pfet_05v0 L=1.2U W=16.2U AS=12.474P AD=12.474P PS=33.94U
+ PD=33.94U
M$2 Q A VSS VSS nfet_05v0 L=1.2U W=5.4U AS=3.942P AD=3.942P PS=12.26U PD=12.26U
.ENDS inv_dut_110

.SUBCKT inv_dut_092 Q A VDD VSS
M$1 Q A VDD VDD pfet_03v3 L=0.6U W=2.7U AS=1.755P AD=1.755P PS=6.7U PD=6.7U
M$2 Q A VSS VSS nfet_03v3 L=0.6U W=0.9U AS=0.549P AD=0.549P PS=3.02U PD=3.02U
.ENDS inv_dut_092

.SUBCKT inv_dut_109 Q A VDD VSS
M$1 Q A VDD VDD pfet_05v0 L=1.2U W=10.8U AS=8.316P AD=8.316P PS=23.14U PD=23.14U
M$2 Q A VSS VSS nfet_05v0 L=1.2U W=3.6U AS=2.628P AD=2.628P PS=8.66U PD=8.66U
.ENDS inv_dut_109

.SUBCKT inv_dut_108 Q A VDD VSS
M$1 Q A VDD VDD pfet_05v0 L=1.2U W=5.4U AS=4.158P AD=4.158P PS=12.34U PD=12.34U
M$2 Q A VSS VSS nfet_05v0 L=1.2U W=1.8U AS=1.314P AD=1.314P PS=5.06U PD=5.06U
.ENDS inv_dut_108

.SUBCKT inv_dut_127 Q A VDD VSS
M$1 Q A VDD VDD pfet_03v3 L=0.9U W=8.1U AS=5.265P AD=5.265P PS=17.5U PD=17.5U
M$2 Q A VSS VSS nfet_03v3 L=0.9U W=2.7U AS=1.647P AD=1.647P PS=6.62U PD=6.62U
.ENDS inv_dut_127

.SUBCKT inv_dut_126 Q A VDD VSS
M$1 Q A VDD VDD pfet_03v3 L=0.6U W=8.1U AS=5.265P AD=5.265P PS=17.5U PD=17.5U
M$2 Q A VSS VSS nfet_03v3 L=0.6U W=2.7U AS=1.647P AD=1.647P PS=6.62U PD=6.62U
.ENDS inv_dut_126

.SUBCKT inv_dut_091 Q A VDD VSS
M$1 Q A VDD VDD pfet_03v3 L=0.6U W=5.4U AS=3.51P AD=3.51P PS=12.1U PD=12.1U
M$2 Q A VSS VSS nfet_03v3 L=0.6U W=2.7U AS=1.647P AD=1.647P PS=6.62U PD=6.62U
.ENDS inv_dut_091

.SUBCKT inv_dut_090 Q A VDD VSS
M$1 Q A VDD VDD pfet_03v3 L=0.6U W=3.6U AS=2.34P AD=2.34P PS=8.5U PD=8.5U
M$2 Q A VSS VSS nfet_03v3 L=0.6U W=1.8U AS=1.098P AD=1.098P PS=4.82U PD=4.82U
.ENDS inv_dut_090

.SUBCKT inv_dut_089 Q A VDD VSS
M$1 Q A VDD VDD pfet_03v3 L=0.6U W=1.8U AS=1.17P AD=1.17P PS=4.9U PD=4.9U
M$2 Q A VSS VSS nfet_03v3 L=0.6U W=0.9U AS=0.549P AD=0.549P PS=3.02U PD=3.02U
.ENDS inv_dut_089

.SUBCKT inv_dut_121 Q A VDD VSS
M$1 Q A VDD VDD pfet_03v3 L=0.6U W=1.8U AS=1.17P AD=1.17P PS=4.9U PD=4.9U
M$2 Q A VSS VSS nfet_03v3 L=0.6U W=0.9U AS=0.549P AD=0.549P PS=3.02U PD=3.02U
.ENDS inv_dut_121

.SUBCKT inv_dut_088 Q A VDD VSS
M$1 Q A VDD VDD pfet_03v3 L=0.3U W=8.1U AS=5.265P AD=5.265P PS=17.5U PD=17.5U
M$2 Q A VSS VSS nfet_03v3 L=0.3U W=2.7U AS=1.647P AD=1.647P PS=6.62U PD=6.62U
.ENDS inv_dut_088

.SUBCKT inv_dut_107 Q A VDD VSS
M$1 Q A VDD VDD pfet_05v0 L=1.2U W=10.8U AS=8.316P AD=8.316P PS=23.14U PD=23.14U
M$2 Q A VSS VSS nfet_05v0 L=1.2U W=5.4U AS=3.942P AD=3.942P PS=12.26U PD=12.26U
.ENDS inv_dut_107

.SUBCKT inv_dut_106 Q A VDD VSS
M$1 Q A VDD VDD pfet_05v0 L=1.2U W=7.2U AS=5.544P AD=5.544P PS=15.94U PD=15.94U
M$2 Q A VSS VSS nfet_05v0 L=1.2U W=3.6U AS=2.628P AD=2.628P PS=8.66U PD=8.66U
.ENDS inv_dut_106

.SUBCKT inv_dut_105 Q A VDD VSS
M$1 Q A VDD VDD pfet_05v0 L=1.2U W=3.6U AS=2.772P AD=2.772P PS=8.74U PD=8.74U
M$2 Q A VSS VSS nfet_05v0 L=1.2U W=1.8U AS=1.314P AD=1.314P PS=5.06U PD=5.06U
.ENDS inv_dut_105

.SUBCKT inv_dut_104 Q A VDD VSS
M$1 Q A VDD VDD pfet_05v0 L=0.6U W=16.2U AS=12.474P AD=12.474P PS=33.94U
+ PD=33.94U
M$2 Q A VSS VSS nfet_05v0 L=0.6U W=5.4U AS=3.942P AD=3.942P PS=12.26U PD=12.26U
.ENDS inv_dut_104

.SUBCKT inv_dut_120 Q A VDD VSS
M$1 Q A VDD VDD pfet_03v3 L=0.3U W=8.1U AS=5.265P AD=5.265P PS=17.5U PD=17.5U
M$2 Q A VSS VSS nfet_03v3 L=0.3U W=2.7U AS=1.647P AD=1.647P PS=6.62U PD=6.62U
.ENDS inv_dut_120

.SUBCKT inv_dut_123 Q A VDD VSS
M$1 Q A VDD VDD pfet_03v3 L=0.6U W=5.4U AS=3.51P AD=3.51P PS=12.1U PD=12.1U
M$2 Q A VSS VSS nfet_03v3 L=0.6U W=2.7U AS=1.647P AD=1.647P PS=6.62U PD=6.62U
.ENDS inv_dut_123

.SUBCKT inv_dut_122 Q A VDD VSS
M$1 Q A VDD VDD pfet_03v3 L=0.6U W=3.6U AS=2.34P AD=2.34P PS=8.5U PD=8.5U
M$2 Q A VSS VSS nfet_03v3 L=0.6U W=1.8U AS=1.098P AD=1.098P PS=4.82U PD=4.82U
.ENDS inv_dut_122

.SUBCKT inv_dut_061 Q A VDD VSS
M$1 Q A VDD VDD pfet_03v3 L=0.6U W=5.4U AS=3.51P AD=3.51P PS=12.1U PD=12.1U
M$2 Q A VSS VSS nfet_03v3 L=0.6U W=1.8U AS=1.098P AD=1.098P PS=4.82U PD=4.82U
.ENDS inv_dut_061

.SUBCKT inv_dut_056 Q A VDD VSS
M$1 Q A VDD VDD pfet_03v3 L=0.3U W=8.1U AS=5.265P AD=5.265P PS=17.5U PD=17.5U
M$2 Q A VSS VSS nfet_03v3 L=0.3U W=2.7U AS=1.647P AD=1.647P PS=6.62U PD=6.62U
.ENDS inv_dut_056

.SUBCKT inv_dut_075 Q A VDD VSS
M$1 Q A VDD VDD pfet_05v0 L=1.2U W=10.8U AS=8.316P AD=8.316P PS=23.14U PD=23.14U
M$2 Q A VSS VSS nfet_05v0 L=1.2U W=5.4U AS=3.942P AD=3.942P PS=12.26U PD=12.26U
.ENDS inv_dut_075

.SUBCKT inv_dut_074 Q A VDD VSS
M$1 Q A VDD VDD pfet_05v0 L=1.2U W=7.2U AS=5.544P AD=5.544P PS=15.94U PD=15.94U
M$2 Q A VSS VSS nfet_05v0 L=1.2U W=3.6U AS=2.628P AD=2.628P PS=8.66U PD=8.66U
.ENDS inv_dut_074

.SUBCKT inv_dut_073 Q A VDD VSS
M$1 Q A VDD VDD pfet_05v0 L=1.2U W=3.6U AS=2.772P AD=2.772P PS=8.74U PD=8.74U
M$2 Q A VSS VSS nfet_05v0 L=1.2U W=1.8U AS=1.314P AD=1.314P PS=5.06U PD=5.06U
.ENDS inv_dut_073

.SUBCKT inv_dut_072 Q A VDD VSS
M$1 Q A VDD VDD pfet_05v0 L=0.6U W=16.2U AS=12.474P AD=12.474P PS=33.94U
+ PD=33.94U
M$2 Q A VSS VSS nfet_05v0 L=0.6U W=5.4U AS=3.942P AD=3.942P PS=12.26U PD=12.26U
.ENDS inv_dut_072

.SUBCKT inv_dut_059 Q A VDD VSS
M$1 Q A VDD VDD pfet_03v3 L=0.6U W=5.4U AS=3.51P AD=3.51P PS=12.1U PD=12.1U
M$2 Q A VSS VSS nfet_03v3 L=0.6U W=2.7U AS=1.647P AD=1.647P PS=6.62U PD=6.62U
.ENDS inv_dut_059

.SUBCKT inv_dut_058 Q A VDD VSS
M$1 Q A VDD VDD pfet_03v3 L=0.6U W=3.6U AS=2.34P AD=2.34P PS=8.5U PD=8.5U
M$2 Q A VSS VSS nfet_03v3 L=0.6U W=1.8U AS=1.098P AD=1.098P PS=4.82U PD=4.82U
.ENDS inv_dut_058

.SUBCKT inv_dut_057 Q A VDD VSS
M$1 Q A VDD VDD pfet_03v3 L=0.6U W=1.8U AS=1.17P AD=1.17P PS=4.9U PD=4.9U
M$2 Q A VSS VSS nfet_03v3 L=0.6U W=0.9U AS=0.549P AD=0.549P PS=3.02U PD=3.02U
.ENDS inv_dut_057

.SUBCKT inv_dut_063 Q A VDD VSS
M$1 Q A VDD VDD pfet_03v3 L=0.9U W=8.1U AS=5.265P AD=5.265P PS=17.5U PD=17.5U
M$2 Q A VSS VSS nfet_03v3 L=0.9U W=2.7U AS=1.647P AD=1.647P PS=6.62U PD=6.62U
.ENDS inv_dut_063

.SUBCKT inv_dut_062 Q A VDD VSS
M$1 Q A VDD VDD pfet_03v3 L=0.6U W=8.1U AS=5.265P AD=5.265P PS=17.5U PD=17.5U
M$2 Q A VSS VSS nfet_03v3 L=0.6U W=2.7U AS=1.647P AD=1.647P PS=6.62U PD=6.62U
.ENDS inv_dut_062

.SUBCKT inv_dut_076 Q A VDD VSS
M$1 Q A VDD VDD pfet_05v0 L=1.2U W=5.4U AS=4.158P AD=4.158P PS=12.34U PD=12.34U
M$2 Q A VSS VSS nfet_05v0 L=1.2U W=1.8U AS=1.314P AD=1.314P PS=5.06U PD=5.06U
.ENDS inv_dut_076

.SUBCKT inv_dut_060 Q A VDD VSS
M$1 Q A VDD VDD pfet_03v3 L=0.6U W=2.7U AS=1.755P AD=1.755P PS=6.7U PD=6.7U
M$2 Q A VSS VSS nfet_03v3 L=0.6U W=0.9U AS=0.549P AD=0.549P PS=3.02U PD=3.02U
.ENDS inv_dut_060

.SUBCKT inv_dut_079 Q A VDD VSS
M$1 Q A VDD VDD pfet_05v0 L=1.8U W=16.2U AS=12.474P AD=12.474P PS=33.94U
+ PD=33.94U
M$2 Q A VSS VSS nfet_05v0 L=1.8U W=5.4U AS=3.942P AD=3.942P PS=12.26U PD=12.26U
.ENDS inv_dut_079

.SUBCKT inv_dut_077 Q A VDD VSS
M$1 Q A VDD VDD pfet_05v0 L=1.2U W=10.8U AS=8.316P AD=8.316P PS=23.14U PD=23.14U
M$2 Q A VSS VSS nfet_05v0 L=1.2U W=3.6U AS=2.628P AD=2.628P PS=8.66U PD=8.66U
.ENDS inv_dut_077

.SUBCKT inv_dut_078 Q A VDD VSS
M$1 Q A VDD VDD pfet_05v0 L=1.2U W=16.2U AS=12.474P AD=12.474P PS=33.94U
+ PD=33.94U
M$2 Q A VSS VSS nfet_05v0 L=1.2U W=5.4U AS=3.942P AD=3.942P PS=12.26U PD=12.26U
.ENDS inv_dut_078

.SUBCKT inv_dut_087 Q A VDD VSS
M$1 Q A VDD VDD pfet_03v3 L=0.3U W=5.4U AS=3.51P AD=3.51P PS=12.1U PD=12.1U
M$2 Q A VSS VSS nfet_03v3 L=0.3U W=1.8U AS=1.098P AD=1.098P PS=4.82U PD=4.82U
.ENDS inv_dut_087

.SUBCKT inv_dut_054 Q A VDD VSS
M$1 Q A VDD VDD pfet_03v3 L=0.3U W=2.7U AS=1.755P AD=1.755P PS=6.7U PD=6.7U
M$2 Q A VSS VSS nfet_03v3 L=0.3U W=0.9U AS=0.549P AD=0.549P PS=3.02U PD=3.02U
.ENDS inv_dut_054

.SUBCKT inv_dut_053 Q A VDD VSS
M$1 Q A VDD VDD pfet_03v3 L=0.3U W=5.4U AS=3.51P AD=3.51P PS=12.1U PD=12.1U
M$2 Q A VSS VSS nfet_03v3 L=0.3U W=2.7U AS=1.647P AD=1.647P PS=6.62U PD=6.62U
.ENDS inv_dut_053

.SUBCKT inv_dut_052 Q A VDD VSS
M$1 Q A VDD VDD pfet_03v3 L=0.3U W=3.6U AS=2.34P AD=2.34P PS=8.5U PD=8.5U
M$2 Q A VSS VSS nfet_03v3 L=0.3U W=1.8U AS=1.098P AD=1.098P PS=4.82U PD=4.82U
.ENDS inv_dut_052

.SUBCKT inv_dut_071 Q A VDD VSS
M$1 Q A VDD VDD pfet_05v0 L=0.6U W=10.8U AS=8.316P AD=8.316P PS=23.14U PD=23.14U
M$2 Q A VSS VSS nfet_05v0 L=0.6U W=3.6U AS=2.628P AD=2.628P PS=8.66U PD=8.66U
.ENDS inv_dut_071

.SUBCKT inv_dut_083 Q A VDD VSS
M$1 Q A VDD VDD pfet_03v3 L=0.3U W=1.8U AS=1.17P AD=1.17P PS=4.9U PD=4.9U
M$2 Q A VSS VSS nfet_03v3 L=0.3U W=0.9U AS=0.549P AD=0.549P PS=3.02U PD=3.02U
.ENDS inv_dut_083

.SUBCKT inv_dut_067 Q A VDD VSS
M$1 Q A VDD VDD pfet_05v0 L=0.6U W=3.6U AS=2.772P AD=2.772P PS=8.74U PD=8.74U
M$2 Q A VSS VSS nfet_05v0 L=0.6U W=1.8U AS=1.314P AD=1.314P PS=5.06U PD=5.06U
.ENDS inv_dut_067

.SUBCKT inv_dut_051 Q A VDD VSS
M$1 Q A VDD VDD pfet_03v3 L=0.3U W=1.8U AS=1.17P AD=1.17P PS=4.9U PD=4.9U
M$2 Q A VSS VSS nfet_03v3 L=0.3U W=0.9U AS=0.549P AD=0.549P PS=3.02U PD=3.02U
.ENDS inv_dut_051

.SUBCKT inv_dut_118 Q A VDD VSS
M$1 Q A VDD VDD pfet_03v3 L=0.3U W=2.7U AS=1.755P AD=1.755P PS=6.7U PD=6.7U
M$2 Q A VSS VSS nfet_03v3 L=0.3U W=0.9U AS=0.549P AD=0.549P PS=3.02U PD=3.02U
.ENDS inv_dut_118

.SUBCKT inv_dut_117 Q A VDD VSS
M$1 Q A VDD VDD pfet_03v3 L=0.3U W=5.4U AS=3.51P AD=3.51P PS=12.1U PD=12.1U
M$2 Q A VSS VSS nfet_03v3 L=0.3U W=2.7U AS=1.647P AD=1.647P PS=6.62U PD=6.62U
.ENDS inv_dut_117

.SUBCKT inv_dut_116 Q A VDD VSS
M$1 Q A VDD VDD pfet_03v3 L=0.3U W=3.6U AS=2.34P AD=2.34P PS=8.5U PD=8.5U
M$2 Q A VSS VSS nfet_03v3 L=0.3U W=1.8U AS=1.098P AD=1.098P PS=4.82U PD=4.82U
.ENDS inv_dut_116

.SUBCKT inv_dut_086 Q A VDD VSS
M$1 Q A VDD VDD pfet_03v3 L=0.3U W=2.7U AS=1.755P AD=1.755P PS=6.7U PD=6.7U
M$2 Q A VSS VSS nfet_03v3 L=0.3U W=0.9U AS=0.549P AD=0.549P PS=3.02U PD=3.02U
.ENDS inv_dut_086

.SUBCKT inv_dut_085 Q A VDD VSS
M$1 Q A VDD VDD pfet_03v3 L=0.3U W=5.4U AS=3.51P AD=3.51P PS=12.1U PD=12.1U
M$2 Q A VSS VSS nfet_03v3 L=0.3U W=2.7U AS=1.647P AD=1.647P PS=6.62U PD=6.62U
.ENDS inv_dut_085

.SUBCKT inv_dut_084 Q A VDD VSS
M$1 Q A VDD VDD pfet_03v3 L=0.3U W=3.6U AS=2.34P AD=2.34P PS=8.5U PD=8.5U
M$2 Q A VSS VSS nfet_03v3 L=0.3U W=1.8U AS=1.098P AD=1.098P PS=4.82U PD=4.82U
.ENDS inv_dut_084

.SUBCKT inv_dut_102 Q A VDD VSS
M$1 Q A VDD VDD pfet_05v0 L=0.6U W=5.4U AS=4.158P AD=4.158P PS=12.34U PD=12.34U
M$2 Q A VSS VSS nfet_05v0 L=0.6U W=1.8U AS=1.314P AD=1.314P PS=5.06U PD=5.06U
.ENDS inv_dut_102

.SUBCKT inv_dut_100 Q A VDD VSS
M$1 Q A VDD VDD pfet_05v0 L=0.6U W=7.2U AS=5.544P AD=5.544P PS=15.94U PD=15.94U
M$2 Q A VSS VSS nfet_05v0 L=0.6U W=3.6U AS=2.628P AD=2.628P PS=8.66U PD=8.66U
.ENDS inv_dut_100

.SUBCKT inv_dut_101 Q A VDD VSS
M$1 Q A VDD VDD pfet_05v0 L=0.6U W=10.8U AS=8.316P AD=8.316P PS=23.14U PD=23.14U
M$2 Q A VSS VSS nfet_05v0 L=0.6U W=5.4U AS=3.942P AD=3.942P PS=12.26U PD=12.26U
.ENDS inv_dut_101

.SUBCKT inv_dut_098 Q A VDD VSS
M$1 Q A VDD VDD pfet_05v0 L=0.6U W=5.4U AS=4.158P AD=4.158P PS=12.34U PD=12.34U
M$2 Q A VSS VSS nfet_05v0 L=0.6U W=5.4U AS=3.942P AD=3.942P PS=12.26U PD=12.26U
.ENDS inv_dut_098

.SUBCKT inv_dut_097 Q A VDD VSS
M$1 Q A VDD VDD pfet_05v0 L=0.6U W=3.6U AS=2.772P AD=2.772P PS=8.74U PD=8.74U
M$2 Q A VSS VSS nfet_05v0 L=0.6U W=3.6U AS=2.628P AD=2.628P PS=8.66U PD=8.66U
.ENDS inv_dut_097

.SUBCKT inv_dut_096 Q A VDD VSS
M$1 Q A VDD VDD pfet_05v0 L=0.6U W=1.8U AS=1.386P AD=1.386P PS=5.14U PD=5.14U
M$2 Q A VSS VSS nfet_05v0 L=0.6U W=1.8U AS=1.314P AD=1.314P PS=5.06U PD=5.06U
.ENDS inv_dut_096

.SUBCKT inv_dut_114 Q A VDD VSS
M$1 Q A VDD VDD pfet_03v3 L=0.3U W=3.6U AS=2.34P AD=2.34P PS=8.5U PD=8.5U
M$2 Q A VSS VSS nfet_03v3 L=0.3U W=3.6U AS=2.196P AD=2.196P PS=8.42U PD=8.42U
.ENDS inv_dut_114

.SUBCKT inv_dut_113 Q A VDD VSS
M$1 Q A VDD VDD pfet_03v3 L=0.3U W=1.8U AS=1.17P AD=1.17P PS=4.9U PD=4.9U
M$2 Q A VSS VSS nfet_03v3 L=0.3U W=1.8U AS=1.098P AD=1.098P PS=4.82U PD=4.82U
.ENDS inv_dut_113

.SUBCKT inv_dut_082 Q A VDD VSS
M$1 Q A VDD VDD pfet_03v3 L=0.3U W=3.6U AS=2.34P AD=2.34P PS=8.5U PD=8.5U
M$2 Q A VSS VSS nfet_03v3 L=0.3U W=3.6U AS=2.196P AD=2.196P PS=8.42U PD=8.42U
.ENDS inv_dut_082

.SUBCKT inv_dut_081 Q A VDD VSS
M$1 Q A VDD VDD pfet_03v3 L=0.3U W=1.8U AS=1.17P AD=1.17P PS=4.9U PD=4.9U
M$2 Q A VSS VSS nfet_03v3 L=0.3U W=1.8U AS=1.098P AD=1.098P PS=4.82U PD=4.82U
.ENDS inv_dut_081

.SUBCKT inv_dut_112 Q A VDD VSS
M$1 Q A VDD VDD pfet_03v3 L=0.3U W=0.9U AS=0.585P AD=0.585P PS=3.1U PD=3.1U
M$2 Q A VSS VSS nfet_03v3 L=0.3U W=0.9U AS=0.549P AD=0.549P PS=3.02U PD=3.02U
.ENDS inv_dut_112

.SUBCKT inv_dut_080 Q A VDD VSS
M$1 Q A VDD VDD pfet_03v3 L=0.3U W=0.9U AS=0.585P AD=0.585P PS=3.1U PD=3.1U
M$2 Q A VSS VSS nfet_03v3 L=0.3U W=0.9U AS=0.549P AD=0.549P PS=3.02U PD=3.02U
.ENDS inv_dut_080

.SUBCKT inv_dut_050 Q A VDD VSS
M$1 Q A VDD VDD pfet_03v3 L=0.3U W=3.6U AS=2.34P AD=2.34P PS=8.5U PD=8.5U
M$2 Q A VSS VSS nfet_03v3 L=0.3U W=3.6U AS=2.196P AD=2.196P PS=8.42U PD=8.42U
.ENDS inv_dut_050

.SUBCKT inv_dut_049 Q A VDD VSS
M$1 Q A VDD VDD pfet_03v3 L=0.3U W=1.8U AS=1.17P AD=1.17P PS=4.9U PD=4.9U
M$2 Q A VSS VSS nfet_03v3 L=0.3U W=1.8U AS=1.098P AD=1.098P PS=4.82U PD=4.82U
.ENDS inv_dut_049

.SUBCKT inv_dut_115 Q A VDD VSS
M$1 Q A VDD VDD pfet_03v3 L=0.3U W=1.8U AS=1.17P AD=1.17P PS=4.9U PD=4.9U
M$2 Q A VSS VSS nfet_03v3 L=0.3U W=0.9U AS=0.549P AD=0.549P PS=3.02U PD=3.02U
.ENDS inv_dut_115

.SUBCKT inv_dut_066 Q A VDD VSS
M$1 Q A VDD VDD pfet_05v0 L=0.6U W=5.4U AS=4.158P AD=4.158P PS=12.34U PD=12.34U
M$2 Q A VSS VSS nfet_05v0 L=0.6U W=5.4U AS=3.942P AD=3.942P PS=12.26U PD=12.26U
.ENDS inv_dut_066

.SUBCKT inv_dut_065 Q A VDD VSS
M$1 Q A VDD VDD pfet_05v0 L=0.6U W=3.6U AS=2.772P AD=2.772P PS=8.74U PD=8.74U
M$2 Q A VSS VSS nfet_05v0 L=0.6U W=3.6U AS=2.628P AD=2.628P PS=8.66U PD=8.66U
.ENDS inv_dut_065

.SUBCKT inv_dut_064 Q A VDD VSS
M$1 Q A VDD VDD pfet_05v0 L=0.6U W=1.8U AS=1.386P AD=1.386P PS=5.14U PD=5.14U
M$2 Q A VSS VSS nfet_05v0 L=0.6U W=1.8U AS=1.314P AD=1.314P PS=5.06U PD=5.06U
.ENDS inv_dut_064

.SUBCKT inv_dut_099 Q A VDD VSS
M$1 Q A VDD VDD pfet_05v0 L=0.6U W=3.6U AS=2.772P AD=2.772P PS=8.74U PD=8.74U
M$2 Q A VSS VSS nfet_05v0 L=0.6U W=1.8U AS=1.314P AD=1.314P PS=5.06U PD=5.06U
.ENDS inv_dut_099

.SUBCKT inv_dut_048 Q A VDD VSS
M$1 Q A VDD VDD pfet_03v3 L=0.3U W=0.9U AS=0.585P AD=0.585P PS=3.1U PD=3.1U
M$2 Q A VSS VSS nfet_03v3 L=0.3U W=0.9U AS=0.549P AD=0.549P PS=3.02U PD=3.02U
.ENDS inv_dut_048

.SUBCKT inv_dut_055 Q A VDD VSS
M$1 Q A VDD VDD pfet_03v3 L=0.3U W=5.4U AS=3.51P AD=3.51P PS=12.1U PD=12.1U
M$2 Q A VSS VSS nfet_03v3 L=0.3U W=1.8U AS=1.098P AD=1.098P PS=4.82U PD=4.82U
.ENDS inv_dut_055

.SUBCKT inv_dut_119 Q A VDD VSS
M$1 Q A VDD VDD pfet_03v3 L=0.3U W=5.4U AS=3.51P AD=3.51P PS=12.1U PD=12.1U
M$2 Q A VSS VSS nfet_03v3 L=0.3U W=1.8U AS=1.098P AD=1.098P PS=4.82U PD=4.82U
.ENDS inv_dut_119

.SUBCKT inv_dut_070 Q A VDD VSS
M$1 Q A VDD VDD pfet_05v0 L=0.6U W=5.4U AS=4.158P AD=4.158P PS=12.34U PD=12.34U
M$2 Q A VSS VSS nfet_05v0 L=0.6U W=1.8U AS=1.314P AD=1.314P PS=5.06U PD=5.06U
.ENDS inv_dut_070

.SUBCKT inv_dut_103 Q A VDD VSS
M$1 Q A VDD VDD pfet_05v0 L=0.6U W=10.8U AS=8.316P AD=8.316P PS=23.14U PD=23.14U
M$2 Q A VSS VSS nfet_05v0 L=0.6U W=3.6U AS=2.628P AD=2.628P PS=8.66U PD=8.66U
.ENDS inv_dut_103

.SUBCKT inv_dut_069 Q A VDD VSS
M$1 Q A VDD VDD pfet_05v0 L=0.6U W=10.8U AS=8.316P AD=8.316P PS=23.14U PD=23.14U
M$2 Q A VSS VSS nfet_05v0 L=0.6U W=5.4U AS=3.942P AD=3.942P PS=12.26U PD=12.26U
.ENDS inv_dut_069

.SUBCKT inv_dut_068 Q A VDD VSS
M$1 Q A VDD VDD pfet_05v0 L=0.6U W=7.2U AS=5.544P AD=5.544P PS=15.94U PD=15.94U
M$2 Q A VSS VSS nfet_05v0 L=0.6U W=3.6U AS=2.628P AD=2.628P PS=8.66U PD=8.66U
.ENDS inv_dut_068

.SUBCKT inv_dut_020 Q A VDD VSS
M$1 Q A VDD VDD pfet_03v3 L=0.3U W=3.6U AS=2.34P AD=2.34P PS=8.5U PD=8.5U
M$2 Q A VSS VSS nfet_03v3 L=0.3U W=1.8U AS=1.098P AD=1.098P PS=4.82U PD=4.82U
.ENDS inv_dut_020

.SUBCKT inv_dut_006 Q A VDD VSS
M$1 Q A VDD VDD pfet_05v0 L=0.6U W=5.4U AS=4.158P AD=4.158P PS=12.34U PD=12.34U
M$2 Q A VSS VSS nfet_05v0 L=0.6U W=1.8U AS=1.314P AD=1.314P PS=5.06U PD=5.06U
.ENDS inv_dut_006

.SUBCKT inv_dut_005 Q A VDD VSS
M$1 Q A VDD VDD pfet_05v0 L=0.6U W=10.8U AS=8.316P AD=8.316P PS=23.14U PD=23.14U
M$2 Q A VSS VSS nfet_05v0 L=0.6U W=5.4U AS=3.942P AD=3.942P PS=12.26U PD=12.26U
.ENDS inv_dut_005

.SUBCKT inv_dut_022 Q A VDD VSS
M$1 Q A VDD VDD pfet_03v3 L=0.3U W=2.7U AS=1.755P AD=1.755P PS=6.7U PD=6.7U
M$2 Q A VSS VSS nfet_03v3 L=0.3U W=0.9U AS=0.549P AD=0.549P PS=3.02U PD=3.02U
.ENDS inv_dut_022

.SUBCKT inv_dut_021 Q A VDD VSS
M$1 Q A VDD VDD pfet_03v3 L=0.3U W=5.4U AS=3.51P AD=3.51P PS=12.1U PD=12.1U
M$2 Q A VSS VSS nfet_03v3 L=0.3U W=2.7U AS=1.647P AD=1.647P PS=6.62U PD=6.62U
.ENDS inv_dut_021

.SUBCKT inv_dut_018 Q A VDD VSS
M$1 Q A VDD VDD pfet_03v3 L=0.3U W=3.6U AS=2.34P AD=2.34P PS=8.5U PD=8.5U
M$2 Q A VSS VSS nfet_03v3 L=0.3U W=3.6U AS=2.196P AD=2.196P PS=8.42U PD=8.42U
.ENDS inv_dut_018

.SUBCKT inv_dut_017 Q A VDD VSS
M$1 Q A VDD VDD pfet_03v3 L=0.3U W=1.8U AS=1.17P AD=1.17P PS=4.9U PD=4.9U
M$2 Q A VSS VSS nfet_03v3 L=0.3U W=1.8U AS=1.098P AD=1.098P PS=4.82U PD=4.82U
.ENDS inv_dut_017

.SUBCKT inv_dut_002 Q A VDD VSS
M$1 Q A VDD VDD pfet_05v0 L=0.6U W=5.4U AS=4.158P AD=4.158P PS=12.34U PD=12.34U
M$2 Q A VSS VSS nfet_05v0 L=0.6U W=5.4U AS=3.942P AD=3.942P PS=12.26U PD=12.26U
.ENDS inv_dut_002

.SUBCKT inv_dut_016 Q A VDD VSS
M$1 Q A VDD VDD pfet_03v3 L=0.3U W=0.9U AS=0.585P AD=0.585P PS=3.1U PD=3.1U
M$2 Q A VSS VSS nfet_03v3 L=0.3U W=0.9U AS=0.549P AD=0.549P PS=3.02U PD=3.02U
.ENDS inv_dut_016

.SUBCKT inv_dut_001 Q A VDD VSS
M$1 Q A VDD VDD pfet_05v0 L=0.6U W=3.6U AS=2.772P AD=2.772P PS=8.74U PD=8.74U
M$2 Q A VSS VSS nfet_05v0 L=0.6U W=3.6U AS=2.628P AD=2.628P PS=8.66U PD=8.66U
.ENDS inv_dut_001

.SUBCKT inv_dut_000 Q A VDD VSS
M$1 Q A VDD VDD pfet_05v0 L=0.6U W=1.8U AS=1.386P AD=1.386P PS=5.14U PD=5.14U
M$2 Q A VSS VSS nfet_05v0 L=0.6U W=1.8U AS=1.314P AD=1.314P PS=5.06U PD=5.06U
.ENDS inv_dut_000

.SUBCKT inv_dut_019 Q A VDD VSS
M$1 Q A VDD VDD pfet_03v3 L=0.3U W=1.8U AS=1.17P AD=1.17P PS=4.9U PD=4.9U
M$2 Q A VSS VSS nfet_03v3 L=0.3U W=0.9U AS=0.549P AD=0.549P PS=3.02U PD=3.02U
.ENDS inv_dut_019

.SUBCKT inv_dut_003 Q A VDD VSS
M$1 Q A VDD VDD pfet_05v0 L=0.6U W=3.6U AS=2.772P AD=2.772P PS=8.74U PD=8.74U
M$2 Q A VSS VSS nfet_05v0 L=0.6U W=1.8U AS=1.314P AD=1.314P PS=5.06U PD=5.06U
.ENDS inv_dut_003

.SUBCKT inv_dut_023 Q A VDD VSS
M$1 Q A VDD VDD pfet_03v3 L=0.3U W=5.4U AS=3.51P AD=3.51P PS=12.1U PD=12.1U
M$2 Q A VSS VSS nfet_03v3 L=0.3U W=1.8U AS=1.098P AD=1.098P PS=4.82U PD=4.82U
.ENDS inv_dut_023

.SUBCKT inv_dut_007 Q A VDD VSS
M$1 Q A VDD VDD pfet_05v0 L=0.6U W=10.8U AS=8.316P AD=8.316P PS=23.14U PD=23.14U
M$2 Q A VSS VSS nfet_05v0 L=0.6U W=3.6U AS=2.628P AD=2.628P PS=8.66U PD=8.66U
.ENDS inv_dut_007

.SUBCKT inv_dut_004 Q A VDD VSS
M$1 Q A VDD VDD pfet_05v0 L=0.6U W=7.2U AS=5.544P AD=5.544P PS=15.94U PD=15.94U
M$2 Q A VSS VSS nfet_05v0 L=0.6U W=3.6U AS=2.628P AD=2.628P PS=8.66U PD=8.66U
.ENDS inv_dut_004

.SUBCKT inv_dut_029 Q A VDD VSS
M$1 Q A VDD VDD pfet_03v3 L=0.6U W=5.4U AS=3.51P AD=3.51P PS=12.1U PD=12.1U
M$2 Q A VSS VSS nfet_03v3 L=0.6U W=1.8U AS=1.098P AD=1.098P PS=4.82U PD=4.82U
.ENDS inv_dut_029

.SUBCKT inv_dut_028 Q A VDD VSS
M$1 Q A VDD VDD pfet_03v3 L=0.6U W=2.7U AS=1.755P AD=1.755P PS=6.7U PD=6.7U
M$2 Q A VSS VSS nfet_03v3 L=0.6U W=0.9U AS=0.549P AD=0.549P PS=3.02U PD=3.02U
.ENDS inv_dut_028

.SUBCKT inv_dut_013 Q A VDD VSS
M$1 Q A VDD VDD pfet_05v0 L=1.2U W=10.8U AS=8.316P AD=8.316P PS=23.14U PD=23.14U
M$2 Q A VSS VSS nfet_05v0 L=1.2U W=3.6U AS=2.628P AD=2.628P PS=8.66U PD=8.66U
.ENDS inv_dut_013

.SUBCKT inv_dut_015 Q A VDD VSS
M$1 Q A VDD VDD pfet_05v0 L=1.8U W=16.2U AS=12.474P AD=12.474P PS=33.94U
+ PD=33.94U
M$2 Q A VSS VSS nfet_05v0 L=1.8U W=5.4U AS=3.942P AD=3.942P PS=12.26U PD=12.26U
.ENDS inv_dut_015

.SUBCKT inv_dut_014 Q A VDD VSS
M$1 Q A VDD VDD pfet_05v0 L=1.2U W=16.2U AS=12.474P AD=12.474P PS=33.94U
+ PD=33.94U
M$2 Q A VSS VSS nfet_05v0 L=1.2U W=5.4U AS=3.942P AD=3.942P PS=12.26U PD=12.26U
.ENDS inv_dut_014

.SUBCKT inv_dut_012 Q A VDD VSS
M$1 Q A VDD VDD pfet_05v0 L=1.2U W=5.4U AS=4.158P AD=4.158P PS=12.34U PD=12.34U
M$2 Q A VSS VSS nfet_05v0 L=1.2U W=1.8U AS=1.314P AD=1.314P PS=5.06U PD=5.06U
.ENDS inv_dut_012

.SUBCKT inv_dut_011 Q A VDD VSS
M$1 Q A VDD VDD pfet_05v0 L=1.2U W=10.8U AS=8.316P AD=8.316P PS=23.14U PD=23.14U
M$2 Q A VSS VSS nfet_05v0 L=1.2U W=5.4U AS=3.942P AD=3.942P PS=12.26U PD=12.26U
.ENDS inv_dut_011

.SUBCKT inv_dut_010 Q A VDD VSS
M$1 Q A VDD VDD pfet_05v0 L=1.2U W=7.2U AS=5.544P AD=5.544P PS=15.94U PD=15.94U
M$2 Q A VSS VSS nfet_05v0 L=1.2U W=3.6U AS=2.628P AD=2.628P PS=8.66U PD=8.66U
.ENDS inv_dut_010

.SUBCKT inv_dut_009 Q A VDD VSS
M$1 Q A VDD VDD pfet_05v0 L=1.2U W=3.6U AS=2.772P AD=2.772P PS=8.74U PD=8.74U
M$2 Q A VSS VSS nfet_05v0 L=1.2U W=1.8U AS=1.314P AD=1.314P PS=5.06U PD=5.06U
.ENDS inv_dut_009

.SUBCKT inv_dut_008 Q A VDD VSS
M$1 Q A VDD VDD pfet_05v0 L=0.6U W=16.2U AS=12.474P AD=12.474P PS=33.94U
+ PD=33.94U
M$2 Q A VSS VSS nfet_05v0 L=0.6U W=5.4U AS=3.942P AD=3.942P PS=12.26U PD=12.26U
.ENDS inv_dut_008

.SUBCKT inv_dut_027 Q A VDD VSS
M$1 Q A VDD VDD pfet_03v3 L=0.6U W=5.4U AS=3.51P AD=3.51P PS=12.1U PD=12.1U
M$2 Q A VSS VSS nfet_03v3 L=0.6U W=2.7U AS=1.647P AD=1.647P PS=6.62U PD=6.62U
.ENDS inv_dut_027

.SUBCKT inv_dut_026 Q A VDD VSS
M$1 Q A VDD VDD pfet_03v3 L=0.6U W=3.6U AS=2.34P AD=2.34P PS=8.5U PD=8.5U
M$2 Q A VSS VSS nfet_03v3 L=0.6U W=1.8U AS=1.098P AD=1.098P PS=4.82U PD=4.82U
.ENDS inv_dut_026

.SUBCKT inv_dut_025 Q A VDD VSS
M$1 Q A VDD VDD pfet_03v3 L=0.6U W=1.8U AS=1.17P AD=1.17P PS=4.9U PD=4.9U
M$2 Q A VSS VSS nfet_03v3 L=0.6U W=0.9U AS=0.549P AD=0.549P PS=3.02U PD=3.02U
.ENDS inv_dut_025

.SUBCKT inv_dut_024 Q A VDD VSS
M$1 Q A VDD VDD pfet_03v3 L=0.3U W=8.1U AS=5.265P AD=5.265P PS=17.5U PD=17.5U
M$2 Q A VSS VSS nfet_03v3 L=0.3U W=2.7U AS=1.647P AD=1.647P PS=6.62U PD=6.62U
.ENDS inv_dut_024

.SUBCKT decoder_7to128 dec_out[1] dec_out[4] dec_out[6] dec_out[10] dec_out[13]
+ dec_out[15] dec_out[18] dec_out[22] dec_out[24] dec_out[27] dec_out[30]
+ dec_out[32] dec_out[33] dec_out[37] dec_out[41] dec_out[43] dec_out[44]
+ dec_out[48] dec_out[54] dec_out[55] dec_out[58] dec_out[59] dec_out[61]
+ dec_out[64] dec_out[66] dec_out[68] dec_out[69] dec_out[70] dec_out[71]
+ dec_out[72] dec_out[73] dec_out[74] dec_out[75] dec_out[76] dec_out[77]
+ dec_out[78] dec_out[79] dec_out[80] dec_out[81] dec_out[82] dec_out[83]
+ dec_out[84] dec_out[85] dec_out[86] dec_out[87] dec_out[88] dec_out[89]
+ dec_out[90] dec_out[91] dec_out[92] dec_out[93] dec_out[94] dec_out[95]
+ dec_out[96] dec_out[97] dec_out[98] dec_out[99] dec_out[100] dec_out[101]
+ dec_out[102] dec_out[103] dec_out[104] dec_out[105] dec_out[106] dec_out[107]
+ dec_out[108] dec_out[109] dec_out[110] dec_out[111] dec_out[112] dec_out[113]
+ dec_out[114] dec_out[116] dec_out[117] dec_out[118] dec_out[119] dec_out[120]
+ dec_out[121] dec_out[122] dec_out[125] dec_out[126] dec_out[127] dec_out[11]
+ dec_out[0] dec_out[3] dec_out[5] VDD dec_out[19] dec_out[14] dec_out[28]
+ dec_out[23] dec_out[17] dec_out[21] dec_out[34] dec_out[31] dec_out[29]
+ dec_out[39] dec_out[36] dec_out[35] dec_out[46] dec_out[42] dec_out[40]
+ dec_out[53] dec_out[51] dec_out[50] dec_out[57] dec_out[52] dec_out[62]
+ dec_out[60] dec_out[63] dec_out[65] dec_out[67] dec_out[123] dec_out[124]
+ dec_out[20] dec_out[25] dec_out[38] dec_out[45] dec_out[8] dec_out[56]
+ dec_out[12] dec_out[49] dec_out[9] dec_out[26] dec_out[47] dec_out[7]
+ dec_out[16] dec_out[2] dec_out[115] dec_in[0] dec_in[1] dec_in[2] dec_in[4]
+ dec_in[5] dec_in[3] dec_in[6] VSS
X$1 \$363 VDD VSS dec_out[1] VDD VSS VSS gf180mcu_fd_sc_mcu7t5v0__dlyb_1
X$2 \$424 VDD VSS dec_out[4] VDD VSS VSS gf180mcu_fd_sc_mcu7t5v0__dlyb_1
X$3 \$389 VDD VSS dec_out[6] VDD VSS VSS gf180mcu_fd_sc_mcu7t5v0__dlyb_1
X$4 \$422 VDD VSS dec_out[10] VDD VSS VSS gf180mcu_fd_sc_mcu7t5v0__dlyb_1
X$5 \$388 VDD VSS dec_out[13] VDD VSS VSS gf180mcu_fd_sc_mcu7t5v0__dlyb_1
X$6 \$347 VDD VSS dec_out[15] VDD VSS VSS gf180mcu_fd_sc_mcu7t5v0__dlyb_1
X$7 \$390 VDD VSS dec_out[18] VDD VSS VSS gf180mcu_fd_sc_mcu7t5v0__dlyb_1
X$8 \$392 VDD VSS dec_out[22] VDD VSS VSS gf180mcu_fd_sc_mcu7t5v0__dlyb_1
X$9 \$349 VDD VSS dec_out[24] VDD VSS VSS gf180mcu_fd_sc_mcu7t5v0__dlyb_1
X$10 \$425 VDD VSS dec_out[27] VDD VSS VSS gf180mcu_fd_sc_mcu7t5v0__dlyb_1
X$11 \$393 VDD VSS dec_out[30] VDD VSS VSS gf180mcu_fd_sc_mcu7t5v0__dlyb_1
X$12 \$350 VDD VSS dec_out[32] VDD VSS VSS gf180mcu_fd_sc_mcu7t5v0__dlyb_1
X$13 \$427 VDD VSS dec_out[33] VDD VSS VSS gf180mcu_fd_sc_mcu7t5v0__dlyb_1
X$14 \$395 VDD VSS dec_out[37] VDD VSS VSS gf180mcu_fd_sc_mcu7t5v0__dlyb_1
X$15 \$320 VDD VSS dec_out[41] VDD VSS VSS gf180mcu_fd_sc_mcu7t5v0__dlyb_1
X$16 \$396 VDD VSS dec_out[43] VDD VSS VSS gf180mcu_fd_sc_mcu7t5v0__dlyb_1
X$17 \$273 VDD VSS dec_out[44] VDD VSS VSS gf180mcu_fd_sc_mcu7t5v0__dlyb_1
X$18 \$398 VDD VSS dec_out[48] VDD VSS VSS gf180mcu_fd_sc_mcu7t5v0__dlyb_1
X$19 \$169 VDD VSS dec_out[54] VDD VSS VSS gf180mcu_fd_sc_mcu7t5v0__dlyb_1
X$20 \$275 VDD VSS dec_out[55] VDD VSS VSS gf180mcu_fd_sc_mcu7t5v0__dlyb_1
X$21 \$242 VDD VSS dec_out[58] VDD VSS VSS gf180mcu_fd_sc_mcu7t5v0__dlyb_1
X$22 \$324 VDD VSS dec_out[59] VDD VSS VSS gf180mcu_fd_sc_mcu7t5v0__dlyb_1
X$23 \$284 VDD VSS dec_out[61] VDD VSS VSS gf180mcu_fd_sc_mcu7t5v0__dlyb_1
X$24 \$244 VDD VSS dec_out[64] VDD VSS VSS gf180mcu_fd_sc_mcu7t5v0__dlyb_1
X$25 \$129 VDD VSS dec_out[66] VDD VSS VSS gf180mcu_fd_sc_mcu7t5v0__dlyb_1
X$26 \$245 VDD VSS dec_out[68] VDD VSS VSS gf180mcu_fd_sc_mcu7t5v0__dlyb_1
X$27 \$174 VDD VSS dec_out[69] VDD VSS VSS gf180mcu_fd_sc_mcu7t5v0__dlyb_1
X$28 \$130 VDD VSS dec_out[70] VDD VSS VSS gf180mcu_fd_sc_mcu7t5v0__dlyb_1
X$29 \$173 VDD VSS dec_out[71] VDD VSS VSS gf180mcu_fd_sc_mcu7t5v0__dlyb_1
X$30 \$353 VDD VSS dec_out[72] VDD VSS VSS gf180mcu_fd_sc_mcu7t5v0__dlyb_1
X$31 \$368 VDD VSS dec_out[73] VDD VSS VSS gf180mcu_fd_sc_mcu7t5v0__dlyb_1
X$32 \$277 VDD VSS dec_out[74] VDD VSS VSS gf180mcu_fd_sc_mcu7t5v0__dlyb_1
X$33 \$243 VDD VSS dec_out[75] VDD VSS VSS gf180mcu_fd_sc_mcu7t5v0__dlyb_1
X$34 \$489 VDD VSS dec_out[76] VDD VSS VSS gf180mcu_fd_sc_mcu7t5v0__dlyb_1
X$35 \$176 VDD VSS dec_out[77] VDD VSS VSS gf180mcu_fd_sc_mcu7t5v0__dlyb_1
X$36 \$175 VDD VSS dec_out[78] VDD VSS VSS gf180mcu_fd_sc_mcu7t5v0__dlyb_1
X$37 \$210 VDD VSS dec_out[79] VDD VSS VSS gf180mcu_fd_sc_mcu7t5v0__dlyb_1
X$38 \$287 VDD VSS dec_out[80] VDD VSS VSS gf180mcu_fd_sc_mcu7t5v0__dlyb_1
X$39 \$369 VDD VSS dec_out[81] VDD VSS VSS gf180mcu_fd_sc_mcu7t5v0__dlyb_1
X$40 \$327 VDD VSS dec_out[82] VDD VSS VSS gf180mcu_fd_sc_mcu7t5v0__dlyb_1
X$41 \$373 VDD VSS dec_out[83] VDD VSS VSS gf180mcu_fd_sc_mcu7t5v0__dlyb_1
X$42 \$177 VDD VSS dec_out[84] VDD VSS VSS gf180mcu_fd_sc_mcu7t5v0__dlyb_1
X$43 \$356 VDD VSS dec_out[85] VDD VSS VSS gf180mcu_fd_sc_mcu7t5v0__dlyb_1
X$44 \$246 VDD VSS dec_out[86] VDD VSS VSS gf180mcu_fd_sc_mcu7t5v0__dlyb_1
X$45 \$371 VDD VSS dec_out[87] VDD VSS VSS gf180mcu_fd_sc_mcu7t5v0__dlyb_1
X$46 \$211 VDD VSS dec_out[88] VDD VSS VSS gf180mcu_fd_sc_mcu7t5v0__dlyb_1
X$47 \$132 VDD VSS dec_out[89] VDD VSS VSS gf180mcu_fd_sc_mcu7t5v0__dlyb_1
X$48 \$358 VDD VSS dec_out[90] VDD VSS VSS gf180mcu_fd_sc_mcu7t5v0__dlyb_1
X$49 \$178 VDD VSS dec_out[91] VDD VSS VSS gf180mcu_fd_sc_mcu7t5v0__dlyb_1
X$50 \$247 VDD VSS dec_out[92] VDD VSS VSS gf180mcu_fd_sc_mcu7t5v0__dlyb_1
X$51 \$180 VDD VSS dec_out[93] VDD VSS VSS gf180mcu_fd_sc_mcu7t5v0__dlyb_1
X$52 \$278 VDD VSS dec_out[94] VDD VSS VSS gf180mcu_fd_sc_mcu7t5v0__dlyb_1
X$53 \$548 VDD VSS dec_out[95] VDD VSS VSS gf180mcu_fd_sc_mcu7t5v0__dlyb_1
X$54 \$179 VDD VSS dec_out[96] VDD VSS VSS gf180mcu_fd_sc_mcu7t5v0__dlyb_1
X$55 \$444 VDD VSS dec_out[97] VDD VSS VSS gf180mcu_fd_sc_mcu7t5v0__dlyb_1
X$56 \$372 VDD VSS dec_out[98] VDD VSS VSS gf180mcu_fd_sc_mcu7t5v0__dlyb_1
X$57 \$360 VDD VSS dec_out[99] VDD VSS VSS gf180mcu_fd_sc_mcu7t5v0__dlyb_1
X$58 \$136 VDD VSS dec_out[100] VDD VSS VSS gf180mcu_fd_sc_mcu7t5v0__dlyb_1
X$59 \$131 VDD VSS dec_out[101] VDD VSS VSS gf180mcu_fd_sc_mcu7t5v0__dlyb_1
X$60 \$430 VDD VSS dec_out[102] VDD VSS VSS gf180mcu_fd_sc_mcu7t5v0__dlyb_1
X$61 \$183 VDD VSS dec_out[103] VDD VSS VSS gf180mcu_fd_sc_mcu7t5v0__dlyb_1
X$62 \$288 VDD VSS dec_out[104] VDD VSS VSS gf180mcu_fd_sc_mcu7t5v0__dlyb_1
X$63 \$184 VDD VSS dec_out[105] VDD VSS VSS gf180mcu_fd_sc_mcu7t5v0__dlyb_1
X$64 \$182 VDD VSS dec_out[106] VDD VSS VSS gf180mcu_fd_sc_mcu7t5v0__dlyb_1
X$65 \$181 VDD VSS dec_out[107] VDD VSS VSS gf180mcu_fd_sc_mcu7t5v0__dlyb_1
X$66 \$446 VDD VSS dec_out[108] VDD VSS VSS gf180mcu_fd_sc_mcu7t5v0__dlyb_1
X$67 \$186 VDD VSS dec_out[109] VDD VSS VSS gf180mcu_fd_sc_mcu7t5v0__dlyb_1
X$68 \$279 VDD VSS dec_out[110] VDD VSS VSS gf180mcu_fd_sc_mcu7t5v0__dlyb_1
X$69 \$464 VDD VSS dec_out[111] VDD VSS VSS gf180mcu_fd_sc_mcu7t5v0__dlyb_1
X$70 \$534 VDD VSS dec_out[112] VDD VSS VSS gf180mcu_fd_sc_mcu7t5v0__dlyb_1
X$71 \$185 VDD VSS dec_out[113] VDD VSS VSS gf180mcu_fd_sc_mcu7t5v0__dlyb_1
X$72 \$330 VDD VSS dec_out[114] VDD VSS VSS gf180mcu_fd_sc_mcu7t5v0__dlyb_1
X$73 \$543 VDD VSS dec_out[116] VDD VSS VSS gf180mcu_fd_sc_mcu7t5v0__dlyb_1
X$74 \$553 VDD VSS dec_out[117] VDD VSS VSS gf180mcu_fd_sc_mcu7t5v0__dlyb_1
X$75 \$447 VDD VSS dec_out[118] VDD VSS VSS gf180mcu_fd_sc_mcu7t5v0__dlyb_1
X$76 \$375 VDD VSS dec_out[119] VDD VSS VSS gf180mcu_fd_sc_mcu7t5v0__dlyb_1
X$77 \$445 VDD VSS dec_out[120] VDD VSS VSS gf180mcu_fd_sc_mcu7t5v0__dlyb_1
X$78 \$509 VDD VSS dec_out[121] VDD VSS VSS gf180mcu_fd_sc_mcu7t5v0__dlyb_1
X$79 \$406 VDD VSS dec_out[122] VDD VSS VSS gf180mcu_fd_sc_mcu7t5v0__dlyb_1
X$80 \$491 VDD VSS dec_out[125] VDD VSS VSS gf180mcu_fd_sc_mcu7t5v0__dlyb_1
X$81 \$376 VDD VSS dec_out[126] VDD VSS VSS gf180mcu_fd_sc_mcu7t5v0__dlyb_1
X$82 \$549 VDD VSS dec_out[127] VDD VSS VSS gf180mcu_fd_sc_mcu7t5v0__dlyb_1
X$83 \$116 VDD VSS dec_out[11] VDD VSS VSS gf180mcu_fd_sc_mcu7t5v0__dlyb_1
X$84 \$269 VDD VSS dec_out[0] VDD VSS VSS gf180mcu_fd_sc_mcu7t5v0__dlyb_1
X$85 \$230 VDD VSS dec_out[3] VDD VSS VSS gf180mcu_fd_sc_mcu7t5v0__dlyb_1
X$86 \$156 VDD VSS dec_out[5] VDD VSS VSS gf180mcu_fd_sc_mcu7t5v0__dlyb_1
X$87 VSS VSS VDD VDD VSS gf180mcu_fd_sc_mcu7t5v0__fillcap_64
X$88 VSS VSS VDD VDD VSS gf180mcu_fd_sc_mcu7t5v0__fillcap_32
X$89 VSS VSS VDD VDD VSS gf180mcu_fd_sc_mcu7t5v0__fillcap_32
X$90 VSS VSS VDD VDD VSS gf180mcu_fd_sc_mcu7t5v0__fillcap_32
X$91 VSS VSS VDD VDD VSS gf180mcu_fd_sc_mcu7t5v0__fillcap_32
X$92 \$362 VSS VDD \$426 VDD VSS VSS gf180mcu_fd_sc_mcu7t5v0__buf_2
X$93 \$502 VSS VDD \$366 VDD VSS VSS gf180mcu_fd_sc_mcu7t5v0__buf_2
X$94 \$485 VSS VDD \$391 VDD VSS VSS gf180mcu_fd_sc_mcu7t5v0__buf_2
X$95 \$449 VSS VDD \$276 VDD VSS VSS gf180mcu_fd_sc_mcu7t5v0__buf_2
X$96 \$346 VSS VDD \$323 VDD VSS VSS gf180mcu_fd_sc_mcu7t5v0__buf_2
X$97 \$442 VSS VDD \$352 VDD VSS VSS gf180mcu_fd_sc_mcu7t5v0__buf_2
X$98 \$423 VSS VDD \$319 VDD VSS VSS gf180mcu_fd_sc_mcu7t5v0__buf_2
X$99 VSS VSS VDD VDD VSS gf180mcu_fd_sc_mcu7t5v0__fillcap_16
X$100 VSS VSS VDD VDD VSS gf180mcu_fd_sc_mcu7t5v0__fillcap_16
X$101 VSS VSS VDD VDD VSS gf180mcu_fd_sc_mcu7t5v0__fillcap_16
X$102 VSS VSS VDD VDD VSS gf180mcu_fd_sc_mcu7t5v0__fillcap_16
X$103 VSS VSS VDD VDD VSS gf180mcu_fd_sc_mcu7t5v0__fillcap_16
X$104 VSS VDD VDD VSS VSS gf180mcu_fd_sc_mcu7t5v0__fillcap_8
X$105 VSS VDD VDD VSS VSS gf180mcu_fd_sc_mcu7t5v0__fillcap_8
X$106 VSS VDD VDD VSS VSS gf180mcu_fd_sc_mcu7t5v0__fillcap_8
X$107 VSS VDD VDD VSS VSS gf180mcu_fd_sc_mcu7t5v0__fillcap_8
X$108 VSS VDD VDD VSS VSS gf180mcu_fd_sc_mcu7t5v0__fillcap_8
X$109 VSS VDD VDD VSS VSS gf180mcu_fd_sc_mcu7t5v0__fillcap_8
X$110 VSS VDD VDD VSS VSS gf180mcu_fd_sc_mcu7t5v0__fillcap_8
X$111 VSS VDD VDD VSS VSS gf180mcu_fd_sc_mcu7t5v0__fillcap_8
X$112 VSS VDD VDD VSS VSS gf180mcu_fd_sc_mcu7t5v0__fillcap_8
X$113 VSS VDD \$523 \$448 \$312 VDD VSS VSS gf180mcu_fd_sc_mcu7t5v0__nand2_1
X$114 VSS VDD \$488 \$325 \$490 VDD VSS VSS gf180mcu_fd_sc_mcu7t5v0__nand2_1
X$115 VSS VDD \$533 \$506 \$527 VDD VSS VSS gf180mcu_fd_sc_mcu7t5v0__nand2_1
X$116 VSS VDD \$488 \$443 \$403 \$405 VDD VSS VSS
+ gf180mcu_fd_sc_mcu7t5v0__nand3_1
X$117 VSS VDD \$454 \$458 \$456 \$505 VDD VSS VSS
+ gf180mcu_fd_sc_mcu7t5v0__nand3_1
X$118 VSS VDD \$475 \$504 \$441 \$474 VDD VSS VSS
+ gf180mcu_fd_sc_mcu7t5v0__nand3_1
X$119 VSS VDD \$533 \$459 \$325 \$506 VDD VSS VSS
+ gf180mcu_fd_sc_mcu7t5v0__nand3_1
X$120 VSS VDD \$486 \$524 \$365 \$448 \$483 VDD VSS VSS
+ gf180mcu_fd_sc_mcu7t5v0__nand4_1
X$121 VSS VDD \$477 \$560 \$365 \$448 \$475 VDD VSS VSS
+ gf180mcu_fd_sc_mcu7t5v0__nand4_1
X$122 VSS VDD \$448 \$362 \$475 \$441 \$421 VDD VSS VSS
+ gf180mcu_fd_sc_mcu7t5v0__nand4_1
X$123 VSS VDD \$501 \$502 \$475 \$441 \$421 VDD VSS VSS
+ gf180mcu_fd_sc_mcu7t5v0__nand4_1
X$124 VSS VDD \$486 \$348 \$479 \$448 \$483 VDD VSS VSS
+ gf180mcu_fd_sc_mcu7t5v0__nand4_1
X$125 VSS VDD \$448 \$449 \$475 \$420 \$474 VDD VSS VSS
+ gf180mcu_fd_sc_mcu7t5v0__nand4_1
X$126 VSS VDD \$533 \$400 \$326 \$401 \$506 VDD VSS VSS
+ gf180mcu_fd_sc_mcu7t5v0__nand4_1
X$127 VSS VDD \$477 \$530 \$365 \$501 \$544 VDD VSS VSS
+ gf180mcu_fd_sc_mcu7t5v0__nand4_1
X$128 VSS VDD \$448 \$346 \$483 \$441 \$421 VDD VSS VSS
+ gf180mcu_fd_sc_mcu7t5v0__nand4_1
X$129 VSS VDD \$486 \$556 \$365 \$501 \$483 VDD VSS VSS
+ gf180mcu_fd_sc_mcu7t5v0__nand4_1
X$130 VSS VDD \$501 \$485 \$483 \$420 \$474 VDD VSS VSS
+ gf180mcu_fd_sc_mcu7t5v0__nand4_1
X$131 VSS VDD \$477 \$555 \$479 \$448 \$544 VDD VSS VSS
+ gf180mcu_fd_sc_mcu7t5v0__nand4_1
X$132 VSS VDD \$533 \$528 \$326 \$283 \$506 VDD VSS VSS
+ gf180mcu_fd_sc_mcu7t5v0__nand4_1
X$133 VSS VDD \$477 \$394 \$479 \$501 \$544 VDD VSS VSS
+ gf180mcu_fd_sc_mcu7t5v0__nand4_1
X$134 VSS VDD \$486 \$531 \$479 \$501 \$483 VDD VSS VSS
+ gf180mcu_fd_sc_mcu7t5v0__nand4_1
X$135 VSS VDD \$448 \$484 \$483 \$420 \$474 VDD VSS VSS
+ gf180mcu_fd_sc_mcu7t5v0__nand4_1
X$136 VSS VDD \$501 \$442 \$475 \$420 \$474 VDD VSS VSS
+ gf180mcu_fd_sc_mcu7t5v0__nand4_1
X$137 VSS VDD \$475 \$483 VDD VSS VSS gf180mcu_fd_sc_mcu7t5v0__clkinv_1
X$138 VSS VDD \$351 \$289 VDD VSS VSS gf180mcu_fd_sc_mcu7t5v0__clkinv_1
X$139 VSS VDD \$405 \$508 VDD VSS VSS gf180mcu_fd_sc_mcu7t5v0__clkinv_1
X$140 VSS VDD \$355 \$428 VDD VSS VSS gf180mcu_fd_sc_mcu7t5v0__clkinv_1
X$141 VSS VDD \$501 \$448 VDD VSS VSS gf180mcu_fd_sc_mcu7t5v0__clkinv_1
X$142 VSS VDD \$474 \$421 VDD VSS VSS gf180mcu_fd_sc_mcu7t5v0__clkinv_1
X$143 VDD \$457 \$505 \$456 \$455 VSS \$275 VDD VSS VSS
+ gf180mcu_fd_sc_mcu7t5v0__and4_1
X$144 VDD \$461 \$292 \$403 \$455 VSS \$183 VDD VSS VSS
+ gf180mcu_fd_sc_mcu7t5v0__and4_1
X$145 VDD \$351 \$401 \$404 \$455 VSS \$371 VDD VSS VSS
+ gf180mcu_fd_sc_mcu7t5v0__and4_1
X$146 VDD \$457 \$283 \$456 \$455 VSS \$121 VDD VSS VSS
+ gf180mcu_fd_sc_mcu7t5v0__and4_1
X$147 VDD \$457 \$452 \$317 \$455 VSS \$159 VDD VSS VSS
+ gf180mcu_fd_sc_mcu7t5v0__and4_1
X$148 VDD \$476 \$487 \$544 \$506 VSS \$488 VDD VSS VSS
+ gf180mcu_fd_sc_mcu7t5v0__and4_1
X$149 VSS VDD \$546 \$450 \$270 VDD VSS VSS gf180mcu_fd_sc_mcu7t5v0__nor2_1
X$150 VSS VDD \$400 \$351 \$168 VDD VSS VSS gf180mcu_fd_sc_mcu7t5v0__nor2_1
X$151 VSS VDD \$443 \$461 \$170 VDD VSS VSS gf180mcu_fd_sc_mcu7t5v0__nor2_1
X$152 VSS VDD \$441 \$474 \$477 VDD VSS VSS gf180mcu_fd_sc_mcu7t5v0__nor2_1
X$153 VSS VDD \$443 \$249 \$549 VDD VSS VSS gf180mcu_fd_sc_mcu7t5v0__nor2_1
X$154 VSS VDD \$528 \$397 \$238 VDD VSS VSS gf180mcu_fd_sc_mcu7t5v0__nor2_1
X$155 VSS VDD \$504 \$506 \$455 VDD VSS VSS gf180mcu_fd_sc_mcu7t5v0__nor2_1
X$156 VSS VDD \$458 \$397 \$398 VDD VSS VSS gf180mcu_fd_sc_mcu7t5v0__nor2_1
X$157 VSS VDD \$546 \$367 \$173 VDD VSS VSS gf180mcu_fd_sc_mcu7t5v0__nor2_1
X$158 VSS VDD \$458 \$249 \$534 VDD VSS VSS gf180mcu_fd_sc_mcu7t5v0__nor2_1
X$159 VSS VDD \$400 \$249 \$445 VDD VSS VSS gf180mcu_fd_sc_mcu7t5v0__nor2_1
X$160 VSS VDD \$276 \$174 \$286 \$325 \$285 VDD VSS VSS
+ gf180mcu_fd_sc_mcu7t5v0__nor4_1
X$161 VSS VDD \$426 \$163 \$317 \$452 \$480 VDD VSS VSS
+ gf180mcu_fd_sc_mcu7t5v0__nor4_1
X$162 VSS VDD \$366 \$123 \$317 \$505 \$397 VDD VSS VSS
+ gf180mcu_fd_sc_mcu7t5v0__nor4_1
X$163 VSS VDD \$323 \$274 \$321 \$283 \$318 VDD VSS VSS
+ gf180mcu_fd_sc_mcu7t5v0__nor4_1
X$164 VSS VDD \$485 \$231 \$310 \$364 \$309 VDD VSS VSS
+ gf180mcu_fd_sc_mcu7t5v0__nor4_1
X$165 VSS VDD \$352 \$491 \$290 \$292 \$291 VDD VSS VSS
+ gf180mcu_fd_sc_mcu7t5v0__nor4_1
X$166 VSS VDD \$481 \$167 \$545 \$283 \$318 VDD VSS VSS
+ gf180mcu_fd_sc_mcu7t5v0__nor4_1
X$167 VSS VSS VDD VDD VSS gf180mcu_fd_sc_mcu7t5v0__fillcap_64
X$168 VSS VDD \$366 \$128 \$321 \$322 \$351 VDD VSS VSS
+ gf180mcu_fd_sc_mcu7t5v0__nor4_1
X$169 VSS VDD \$423 \$422 \$313 \$364 \$315 VDD VSS VSS
+ gf180mcu_fd_sc_mcu7t5v0__nor4_1
X$170 VSS VDD \$478 \$239 \$317 \$505 \$397 VDD VSS VSS
+ gf180mcu_fd_sc_mcu7t5v0__nor4_1
X$171 VSS VDD \$346 \$311 \$310 \$364 \$309 VDD VSS VSS
+ gf180mcu_fd_sc_mcu7t5v0__nor4_1
X$172 VSS VDD \$391 \$127 \$321 \$283 \$397 VDD VSS VSS
+ gf180mcu_fd_sc_mcu7t5v0__nor4_1
X$173 VSS VDD \$426 \$169 \$321 \$283 \$318 VDD VSS VSS
+ gf180mcu_fd_sc_mcu7t5v0__nor4_1
X$174 VSS VDD \$366 \$376 \$329 \$357 \$249 VDD VSS VSS
+ gf180mcu_fd_sc_mcu7t5v0__nor4_1
X$175 VSS VDD \$527 \$399 \$326 \$325 \$351 VDD VSS VSS
+ gf180mcu_fd_sc_mcu7t5v0__nor4_1
X$176 VSS VDD \$502 \$158 \$313 \$364 \$315 VDD VSS VSS
+ gf180mcu_fd_sc_mcu7t5v0__nor4_1
X$177 VSS VDD \$481 \$369 \$326 \$357 \$354 VDD VSS VSS
+ gf180mcu_fd_sc_mcu7t5v0__nor4_1
X$178 VSS VDD \$276 \$395 \$545 \$452 \$480 VDD VSS VSS
+ gf180mcu_fd_sc_mcu7t5v0__nor4_1
X$179 VSS VDD \$366 \$279 \$329 \$460 \$249 VDD VSS VSS
+ gf180mcu_fd_sc_mcu7t5v0__nor4_1
X$180 VSS VDD \$478 \$464 \$329 \$460 \$249 VDD VSS VSS
+ gf180mcu_fd_sc_mcu7t5v0__nor4_1
X$181 VSS VDD \$362 \$389 \$310 \$364 \$315 VDD VSS VSS
+ gf180mcu_fd_sc_mcu7t5v0__nor4_1
X$182 VSS VDD \$346 \$390 \$313 \$365 \$315 VDD VSS VSS
+ gf180mcu_fd_sc_mcu7t5v0__nor4_1
X$183 VSS VDD \$352 \$176 \$326 \$325 \$285 VDD VSS VSS
+ gf180mcu_fd_sc_mcu7t5v0__nor4_1
X$184 VSS VDD \$323 \$330 \$250 \$292 \$248 VDD VSS VSS
+ gf180mcu_fd_sc_mcu7t5v0__nor4_1
X$185 VSS VDD \$319 \$358 \$403 \$357 \$328 VDD VSS VSS
+ gf180mcu_fd_sc_mcu7t5v0__nor4_1
X$186 VSS VDD \$391 \$368 \$286 \$325 \$285 VDD VSS VSS
+ gf180mcu_fd_sc_mcu7t5v0__nor4_1
X$187 VSS VDD \$352 \$186 \$250 \$405 \$248 VDD VSS VSS
+ gf180mcu_fd_sc_mcu7t5v0__nor4_1
X$188 VSS VDD \$352 \$284 \$321 \$322 \$351 VDD VSS VSS
+ gf180mcu_fd_sc_mcu7t5v0__nor4_1
X$189 VSS VDD \$276 \$131 \$250 \$405 \$248 VDD VSS VSS
+ gf180mcu_fd_sc_mcu7t5v0__nor4_1
X$190 VSS VDD \$481 \$171 \$286 \$325 \$285 VDD VSS VSS
+ gf180mcu_fd_sc_mcu7t5v0__nor4_1
X$191 VSS VDD \$312 \$179 \$404 \$405 \$328 VDD VSS VSS
+ gf180mcu_fd_sc_mcu7t5v0__nor4_1
X$192 VSS VDD \$391 \$320 \$545 \$452 \$480 VDD VSS VSS
+ gf180mcu_fd_sc_mcu7t5v0__nor4_1
X$193 VSS VDD \$323 \$119 \$545 \$452 \$480 VDD VSS VSS
+ gf180mcu_fd_sc_mcu7t5v0__nor4_1
X$194 VSS VDD \$449 \$156 \$310 \$364 \$309 VDD VSS VSS
+ gf180mcu_fd_sc_mcu7t5v0__nor4_1
X$195 VSS VDD \$312 \$269 \$310 \$364 \$309 VDD VSS VSS
+ gf180mcu_fd_sc_mcu7t5v0__nor4_1
X$196 VSS VDD \$319 \$242 \$321 \$322 \$397 VDD VSS VSS
+ gf180mcu_fd_sc_mcu7t5v0__nor4_1
X$197 VSS VDD \$319 \$164 \$317 \$452 \$318 VDD VSS VSS
+ gf180mcu_fd_sc_mcu7t5v0__nor4_1
X$198 VSS VDD \$312 \$350 \$317 \$505 \$397 VDD VSS VSS
+ gf180mcu_fd_sc_mcu7t5v0__nor4_1
X$199 VSS VDD \$323 \$129 \$286 \$325 \$285 VDD VSS VSS
+ gf180mcu_fd_sc_mcu7t5v0__nor4_1
X$200 VSS VDD \$423 \$234 \$451 \$365 \$450 VDD VSS VSS
+ gf180mcu_fd_sc_mcu7t5v0__nor4_1
X$201 VSS VDD \$391 \$272 \$451 \$365 \$450 VDD VSS VSS
+ gf180mcu_fd_sc_mcu7t5v0__nor4_1
X$202 VSS VDD \$484 \$363 \$310 \$364 \$309 VDD VSS VSS
+ gf180mcu_fd_sc_mcu7t5v0__nor4_1
X$203 VSS VDD \$478 \$347 \$451 \$364 \$450 VDD VSS VSS
+ gf180mcu_fd_sc_mcu7t5v0__nor4_1
X$204 VSS VDD \$352 \$165 \$545 \$452 \$318 VDD VSS VSS
+ gf180mcu_fd_sc_mcu7t5v0__nor4_1
X$205 VSS VDD \$442 \$162 \$451 \$283 \$480 VDD VSS VSS
+ gf180mcu_fd_sc_mcu7t5v0__nor4_1
X$206 VSS VDD \$312 \$244 \$326 \$401 \$285 VDD VSS VSS
+ gf180mcu_fd_sc_mcu7t5v0__nor4_1
X$207 VSS VDD \$319 \$406 \$290 \$292 \$291 VDD VSS VSS
+ gf180mcu_fd_sc_mcu7t5v0__nor4_1
X$208 VSS VDD \$366 \$278 \$403 \$292 \$328 VDD VSS VSS
+ gf180mcu_fd_sc_mcu7t5v0__nor4_1
X$209 VSS VDD \$481 \$427 \$545 \$452 \$480 VDD VSS VSS
+ gf180mcu_fd_sc_mcu7t5v0__nor4_1
X$210 VSS VDD \$323 \$372 \$404 \$405 \$328 VDD VSS VSS
+ gf180mcu_fd_sc_mcu7t5v0__nor4_1
X$211 VSS VDD \$426 \$447 \$329 \$292 \$291 VDD VSS VSS
+ gf180mcu_fd_sc_mcu7t5v0__nor4_1
X$212 VSS VDD \$391 \$184 \$250 \$405 \$248 VDD VSS VSS
+ gf180mcu_fd_sc_mcu7t5v0__nor4_1
X$213 VSS VDD \$527 \$353 \$326 \$401 \$367 VDD VSS VSS
+ gf180mcu_fd_sc_mcu7t5v0__nor4_1
X$214 VSS VDD \$276 \$126 \$317 \$283 \$318 VDD VSS VSS
+ gf180mcu_fd_sc_mcu7t5v0__nor4_1
X$215 VSS VDD \$478 \$210 \$429 \$401 \$367 VDD VSS VSS
+ gf180mcu_fd_sc_mcu7t5v0__nor4_1
X$216 VSS VDD \$426 \$246 \$355 \$357 \$354 VDD VSS VSS
+ gf180mcu_fd_sc_mcu7t5v0__nor4_1
X$217 VSS VDD \$481 \$444 \$404 \$405 \$328 VDD VSS VSS
+ gf180mcu_fd_sc_mcu7t5v0__nor4_1
X$218 VSS VDD \$366 \$393 \$451 \$283 \$397 VDD VSS VSS
+ gf180mcu_fd_sc_mcu7t5v0__nor4_1
X$219 VSS VDD \$426 \$430 \$250 \$405 \$248 VDD VSS VSS
+ gf180mcu_fd_sc_mcu7t5v0__nor4_1
X$220 VSS VDD \$391 \$132 \$355 \$357 \$354 VDD VSS VSS
+ gf180mcu_fd_sc_mcu7t5v0__nor4_1
X$221 VSS VDD \$352 \$180 \$355 \$292 \$354 VDD VSS VSS
+ gf180mcu_fd_sc_mcu7t5v0__nor4_1
X$222 VSS VDD \$323 \$327 \$326 \$357 \$354 VDD VSS VSS
+ gf180mcu_fd_sc_mcu7t5v0__nor4_1
X$223 VSS VDD \$276 \$356 \$355 \$357 \$354 VDD VSS VSS
+ gf180mcu_fd_sc_mcu7t5v0__nor4_1
X$224 VSS VDD \$319 \$277 \$286 \$325 \$367 VDD VSS VSS
+ gf180mcu_fd_sc_mcu7t5v0__nor4_1
X$225 VSS VDD \$426 \$130 \$286 \$325 \$367 VDD VSS VSS
+ gf180mcu_fd_sc_mcu7t5v0__nor4_1
X$226 VSS VDD \$484 \$233 \$310 \$365 \$309 VDD VSS VSS
+ gf180mcu_fd_sc_mcu7t5v0__nor4_1
X$227 VSS VDD \$486 \$478 \$501 \$475 VDD VSS VSS
+ gf180mcu_fd_sc_mcu7t5v0__nand3_1
X$228 VSS VDD \$319 \$182 \$329 \$405 \$248 VDD VSS VSS
+ gf180mcu_fd_sc_mcu7t5v0__nor4_1
X$229 VSS VDD \$442 \$388 \$310 \$364 \$309 VDD VSS VSS
+ gf180mcu_fd_sc_mcu7t5v0__nor4_1
X$230 VSS VDD \$506 \$454 \$475 \$441 \$474 VDD VSS VSS
+ gf180mcu_fd_sc_mcu7t5v0__nor4_1
X$231 VSS VDD \$449 \$160 \$313 \$365 \$315 VDD VSS VSS
+ gf180mcu_fd_sc_mcu7t5v0__nor4_1
X$232 VSS VDD \$362 \$392 \$313 \$365 \$315 VDD VSS VSS
+ gf180mcu_fd_sc_mcu7t5v0__nor4_1
X$233 VSS VDD \$276 \$553 \$290 \$292 \$291 VDD VSS VSS
+ gf180mcu_fd_sc_mcu7t5v0__nor4_1
X$234 VSS VDD \$366 \$175 \$429 \$401 \$367 VDD VSS VSS
+ gf180mcu_fd_sc_mcu7t5v0__nor4_1
X$235 VSS VDD \$391 \$509 \$290 \$292 \$291 VDD VSS VSS
+ gf180mcu_fd_sc_mcu7t5v0__nor4_1
X$236 VSS \$506 \$452 \$451 \$504 VDD \$546 VDD VSS VSS
+ gf180mcu_fd_sc_mcu7t5v0__or4_1
X$237 VSS VDD \$555 \$316 \$313 \$315 VDD VSS VSS
+ gf180mcu_fd_sc_mcu7t5v0__nor3_1
X$238 VSS VDD \$490 \$161 \$355 \$351 VDD VSS VSS
+ gf180mcu_fd_sc_mcu7t5v0__nor3_1
X$239 VSS VDD \$394 \$247 \$355 \$354 VDD VSS VSS
+ gf180mcu_fd_sc_mcu7t5v0__nor3_1
X$240 VSS VDD \$503 \$271 \$451 \$450 VDD VSS VSS
+ gf180mcu_fd_sc_mcu7t5v0__nor3_1
X$241 VSS VDD \$555 \$241 \$317 \$318 VDD VSS VSS
+ gf180mcu_fd_sc_mcu7t5v0__nor3_1
X$242 VSS VDD \$524 \$230 \$310 \$309 VDD VSS VSS
+ gf180mcu_fd_sc_mcu7t5v0__nor3_1
X$243 VSS VDD \$560 \$155 \$545 \$480 VDD VSS VSS
+ gf180mcu_fd_sc_mcu7t5v0__nor3_1
X$244 VSS VDD \$556 \$396 \$545 \$480 VDD VSS VSS
+ gf180mcu_fd_sc_mcu7t5v0__nor3_1
X$245 VSS VDD \$394 \$118 \$451 \$480 VDD VSS VSS
+ gf180mcu_fd_sc_mcu7t5v0__nor3_1
X$246 VSS VDD \$530 \$157 \$313 \$315 VDD VSS VSS
+ gf180mcu_fd_sc_mcu7t5v0__nor3_1
X$247 VSS VDD \$531 \$324 \$321 \$351 VDD VSS VSS
+ gf180mcu_fd_sc_mcu7t5v0__nor3_1
X$248 VSS VDD \$348 \$236 \$317 \$318 VDD VSS VSS
+ gf180mcu_fd_sc_mcu7t5v0__nor3_1
X$249 VSS VDD \$348 \$373 \$355 \$354 VDD VSS VSS
+ gf180mcu_fd_sc_mcu7t5v0__nor3_1
X$250 VSS VDD \$530 \$446 \$250 \$248 VDD VSS VSS
+ gf180mcu_fd_sc_mcu7t5v0__nor3_1
X$251 VSS VDD \$490 \$548 \$403 \$328 VDD VSS VSS
+ gf180mcu_fd_sc_mcu7t5v0__nor3_1
X$252 VSS VDD \$524 \$360 \$404 \$328 VDD VSS VSS
+ gf180mcu_fd_sc_mcu7t5v0__nor3_1
X$253 VSS VDD \$459 \$211 \$403 \$328 VDD VSS VSS
+ gf180mcu_fd_sc_mcu7t5v0__nor3_1
X$254 VSS VDD \$503 \$287 \$429 \$367 VDD VSS VSS
+ gf180mcu_fd_sc_mcu7t5v0__nor3_1
X$255 VSS VDD \$560 \$424 \$310 \$309 VDD VSS VSS
+ gf180mcu_fd_sc_mcu7t5v0__nor3_1
X$256 VSS VDD \$556 \$116 \$313 \$309 VDD VSS VSS
+ gf180mcu_fd_sc_mcu7t5v0__nor3_1
X$257 VSS VDD \$531 \$425 \$451 \$450 VDD VSS VSS
+ gf180mcu_fd_sc_mcu7t5v0__nor3_1
X$258 VSS VDD \$524 \$172 \$286 \$285 VDD VSS VSS
+ gf180mcu_fd_sc_mcu7t5v0__nor3_1
X$259 VSS VDD \$348 \$117 \$313 \$315 VDD VSS VSS
+ gf180mcu_fd_sc_mcu7t5v0__nor3_1
X$260 VDD \$474 \$441 VSS \$486 VDD VSS VSS gf180mcu_fd_sc_mcu7t5v0__and2_1
X$261 VSS VDD \$459 \$349 \$326 \$351 VDD VSS VSS
+ gf180mcu_fd_sc_mcu7t5v0__nor3_1
X$262 VSS VDD \$530 \$273 \$545 \$318 VDD VSS VSS
+ gf180mcu_fd_sc_mcu7t5v0__nor3_1
X$263 VSS VDD \$524 \$237 \$545 \$480 VDD VSS VSS
+ gf180mcu_fd_sc_mcu7t5v0__nor3_1
X$264 VSS VDD \$475 \$523 \$441 \$474 VDD VSS VSS
+ gf180mcu_fd_sc_mcu7t5v0__nor3_1
X$265 VSS VDD \$531 \$535 \$290 \$291 VDD VSS VSS
+ gf180mcu_fd_sc_mcu7t5v0__nor3_1
X$266 VSS VDD \$555 \$177 \$355 \$354 VDD VSS VSS
+ gf180mcu_fd_sc_mcu7t5v0__nor3_1
X$267 VSS VDD \$530 \$489 \$286 \$285 VDD VSS VSS
+ gf180mcu_fd_sc_mcu7t5v0__nor3_1
X$268 VSS VDD \$348 \$359 \$250 \$248 VDD VSS VSS
+ gf180mcu_fd_sc_mcu7t5v0__nor3_1
X$269 VSS VDD \$394 \$166 \$321 \$351 VDD VSS VSS
+ gf180mcu_fd_sc_mcu7t5v0__nor3_1
X$270 VSS VDD \$560 \$136 \$404 \$328 VDD VSS VSS
+ gf180mcu_fd_sc_mcu7t5v0__nor3_1
X$271 VSS VDD \$531 \$178 \$355 \$354 VDD VSS VSS
+ gf180mcu_fd_sc_mcu7t5v0__nor3_1
X$272 VSS VDD \$556 \$181 \$250 \$248 VDD VSS VSS
+ gf180mcu_fd_sc_mcu7t5v0__nor3_1
X$273 VSS VDD \$394 \$492 \$290 \$291 VDD VSS VSS
+ gf180mcu_fd_sc_mcu7t5v0__nor3_1
X$274 VSS VDD \$556 \$243 \$286 \$285 VDD VSS VSS
+ gf180mcu_fd_sc_mcu7t5v0__nor3_1
X$275 VSS VDD \$555 \$543 \$250 \$291 VDD VSS VSS
+ gf180mcu_fd_sc_mcu7t5v0__nor3_1
X$276 VDD VSS VDD VSS gf180mcu_fd_sc_mcu7t5v0__fill_1
X$277 VDD VSS VDD VSS gf180mcu_fd_sc_mcu7t5v0__fill_1
X$278 VDD VSS VDD VSS gf180mcu_fd_sc_mcu7t5v0__fill_1
X$279 VDD VSS VDD VSS gf180mcu_fd_sc_mcu7t5v0__fill_1
X$280 VDD VSS VDD VSS gf180mcu_fd_sc_mcu7t5v0__fill_1
X$281 VDD VSS VDD VSS gf180mcu_fd_sc_mcu7t5v0__fill_1
X$282 VDD VSS VDD VSS gf180mcu_fd_sc_mcu7t5v0__fill_1
X$283 VDD VSS VDD VSS gf180mcu_fd_sc_mcu7t5v0__fill_1
X$284 VDD VSS VDD VSS gf180mcu_fd_sc_mcu7t5v0__fill_1
X$285 VDD VSS VDD VSS gf180mcu_fd_sc_mcu7t5v0__fill_1
X$286 VDD VSS VDD VSS gf180mcu_fd_sc_mcu7t5v0__fill_1
X$287 VDD VSS VDD VSS gf180mcu_fd_sc_mcu7t5v0__fill_1
X$288 VDD VSS VDD VSS gf180mcu_fd_sc_mcu7t5v0__fill_1
X$289 VDD VSS VDD VSS gf180mcu_fd_sc_mcu7t5v0__fill_1
X$290 VDD VSS VDD VSS gf180mcu_fd_sc_mcu7t5v0__fill_1
X$291 VDD VSS VDD VSS gf180mcu_fd_sc_mcu7t5v0__fill_1
X$292 VDD VSS VDD VSS gf180mcu_fd_sc_mcu7t5v0__fill_1
X$293 VDD VSS VDD VSS gf180mcu_fd_sc_mcu7t5v0__fill_1
X$294 VDD VSS VDD VSS gf180mcu_fd_sc_mcu7t5v0__fill_1
X$295 VDD VSS VDD VSS gf180mcu_fd_sc_mcu7t5v0__fill_1
X$296 VDD VSS VDD VSS gf180mcu_fd_sc_mcu7t5v0__fill_1
X$297 VDD VSS VDD VSS gf180mcu_fd_sc_mcu7t5v0__fill_1
X$298 VDD VSS VDD VSS gf180mcu_fd_sc_mcu7t5v0__fill_1
X$299 VDD VSS VDD VSS gf180mcu_fd_sc_mcu7t5v0__fill_1
X$300 VDD VSS VDD VSS gf180mcu_fd_sc_mcu7t5v0__fill_1
X$301 VDD VSS VDD VSS gf180mcu_fd_sc_mcu7t5v0__fill_1
X$302 VDD VSS VDD VSS gf180mcu_fd_sc_mcu7t5v0__fill_1
X$303 VDD VSS VDD VSS gf180mcu_fd_sc_mcu7t5v0__fill_1
X$304 VDD VSS VDD VSS gf180mcu_fd_sc_mcu7t5v0__fill_1
X$305 VDD VSS VDD VSS gf180mcu_fd_sc_mcu7t5v0__fill_1
X$306 VDD VSS VDD VSS gf180mcu_fd_sc_mcu7t5v0__fill_1
X$307 VDD VSS VDD VSS gf180mcu_fd_sc_mcu7t5v0__fill_1
X$308 VDD VSS VDD VSS gf180mcu_fd_sc_mcu7t5v0__fill_1
X$309 VDD VSS VDD VSS gf180mcu_fd_sc_mcu7t5v0__fill_1
X$310 VDD VSS VDD VSS gf180mcu_fd_sc_mcu7t5v0__fill_1
X$311 VDD VSS VDD VSS gf180mcu_fd_sc_mcu7t5v0__fill_1
X$312 VDD VSS VDD VSS gf180mcu_fd_sc_mcu7t5v0__fill_1
X$313 VDD VSS VDD VSS gf180mcu_fd_sc_mcu7t5v0__fill_1
X$314 VDD VSS VDD VSS gf180mcu_fd_sc_mcu7t5v0__fill_1
X$315 VDD VSS VDD VSS gf180mcu_fd_sc_mcu7t5v0__fill_1
X$316 VDD VSS VDD VSS gf180mcu_fd_sc_mcu7t5v0__fill_1
X$317 VDD VSS VDD VSS gf180mcu_fd_sc_mcu7t5v0__fill_1
X$318 VDD VSS VDD VSS gf180mcu_fd_sc_mcu7t5v0__fill_1
X$319 VDD VSS VDD VSS gf180mcu_fd_sc_mcu7t5v0__fill_1
X$320 VDD VSS VDD VSS gf180mcu_fd_sc_mcu7t5v0__fill_1
X$321 VDD VSS VDD VSS gf180mcu_fd_sc_mcu7t5v0__fill_1
X$322 VDD VSS VDD VSS gf180mcu_fd_sc_mcu7t5v0__fill_1
X$323 VDD VSS VDD VSS gf180mcu_fd_sc_mcu7t5v0__fill_1
X$324 VDD VSS VDD VSS gf180mcu_fd_sc_mcu7t5v0__fill_1
X$325 VDD VSS VDD VSS gf180mcu_fd_sc_mcu7t5v0__fill_1
X$326 VDD VSS VDD VSS gf180mcu_fd_sc_mcu7t5v0__fill_1
X$327 VDD VSS VDD VSS gf180mcu_fd_sc_mcu7t5v0__fill_1
X$328 VDD VSS VDD VSS gf180mcu_fd_sc_mcu7t5v0__fill_1
X$329 VDD VSS VDD VSS gf180mcu_fd_sc_mcu7t5v0__fill_1
X$330 VDD VSS VDD VSS gf180mcu_fd_sc_mcu7t5v0__fill_1
X$331 VDD VSS VDD VSS gf180mcu_fd_sc_mcu7t5v0__fill_1
X$332 VDD VSS VDD VSS gf180mcu_fd_sc_mcu7t5v0__fill_1
X$333 VDD VSS VDD VSS gf180mcu_fd_sc_mcu7t5v0__fill_1
X$334 VDD VSS VDD VSS gf180mcu_fd_sc_mcu7t5v0__fill_1
X$335 VDD VSS VDD VSS gf180mcu_fd_sc_mcu7t5v0__fill_1
X$336 VDD VSS VDD VSS gf180mcu_fd_sc_mcu7t5v0__fill_1
X$337 VDD VSS VDD VSS gf180mcu_fd_sc_mcu7t5v0__fill_1
X$338 VDD VSS VDD VSS gf180mcu_fd_sc_mcu7t5v0__fill_1
X$339 VDD VSS VDD VSS gf180mcu_fd_sc_mcu7t5v0__fill_1
X$340 VDD VSS VDD VSS gf180mcu_fd_sc_mcu7t5v0__fill_1
X$341 VDD VSS VDD VSS gf180mcu_fd_sc_mcu7t5v0__fill_1
X$342 VDD VSS VDD VSS gf180mcu_fd_sc_mcu7t5v0__fill_1
X$343 VDD VSS VDD VSS gf180mcu_fd_sc_mcu7t5v0__fill_1
X$344 VDD VSS VDD VSS gf180mcu_fd_sc_mcu7t5v0__fill_1
X$345 VDD VSS VDD VSS gf180mcu_fd_sc_mcu7t5v0__fill_1
X$346 VDD VSS VDD VSS gf180mcu_fd_sc_mcu7t5v0__fill_1
X$347 VDD VSS VDD VSS gf180mcu_fd_sc_mcu7t5v0__fill_1
X$348 VDD VSS VDD VSS gf180mcu_fd_sc_mcu7t5v0__fill_1
X$349 VDD VSS VDD VSS gf180mcu_fd_sc_mcu7t5v0__fill_1
X$350 VDD VSS VDD VSS gf180mcu_fd_sc_mcu7t5v0__fill_1
X$351 VDD VSS VDD VSS gf180mcu_fd_sc_mcu7t5v0__fill_1
X$352 VDD VSS VDD VSS gf180mcu_fd_sc_mcu7t5v0__fill_1
X$353 VDD VSS VDD VSS gf180mcu_fd_sc_mcu7t5v0__fill_1
X$354 \$523 VSS VDD \$533 VDD VSS VSS gf180mcu_fd_sc_mcu7t5v0__buf_1
X$355 VDD VSS VDD VSS gf180mcu_fd_sc_mcu7t5v0__fill_2
X$356 VDD VSS VDD VSS gf180mcu_fd_sc_mcu7t5v0__fill_2
X$357 VDD VSS VDD VSS gf180mcu_fd_sc_mcu7t5v0__fill_2
X$358 VDD VSS VDD VSS gf180mcu_fd_sc_mcu7t5v0__fill_2
X$359 VDD VSS VDD VSS gf180mcu_fd_sc_mcu7t5v0__fill_2
X$360 VDD VSS VDD VSS gf180mcu_fd_sc_mcu7t5v0__fill_2
X$361 VDD VSS VDD VSS gf180mcu_fd_sc_mcu7t5v0__fill_2
X$362 \$484 VSS VDD \$481 VDD VSS VSS gf180mcu_fd_sc_mcu7t5v0__buf_2
X$363 VDD VSS VDD VSS gf180mcu_fd_sc_mcu7t5v0__fill_2
X$364 VDD VSS VDD VSS gf180mcu_fd_sc_mcu7t5v0__fill_2
X$365 VDD VSS VDD VSS gf180mcu_fd_sc_mcu7t5v0__fill_2
X$366 VDD VSS VDD VSS gf180mcu_fd_sc_mcu7t5v0__fill_2
X$367 VDD VSS VDD VSS gf180mcu_fd_sc_mcu7t5v0__fill_2
X$368 VDD VSS VDD VSS gf180mcu_fd_sc_mcu7t5v0__fill_2
X$369 VDD VSS VDD VSS gf180mcu_fd_sc_mcu7t5v0__fill_2
X$370 VDD VSS VDD VSS gf180mcu_fd_sc_mcu7t5v0__fill_2
X$371 VDD VSS VDD VSS gf180mcu_fd_sc_mcu7t5v0__fill_2
X$372 VDD VSS VDD VSS gf180mcu_fd_sc_mcu7t5v0__fill_2
X$373 VDD VSS VDD VSS gf180mcu_fd_sc_mcu7t5v0__fill_2
X$374 VDD VSS VDD VSS gf180mcu_fd_sc_mcu7t5v0__fill_2
X$375 VDD VSS VDD VSS gf180mcu_fd_sc_mcu7t5v0__fill_2
X$376 VDD VSS VDD VSS gf180mcu_fd_sc_mcu7t5v0__fill_2
X$377 VDD VSS VDD VSS gf180mcu_fd_sc_mcu7t5v0__fill_2
X$378 VDD VSS VDD VSS gf180mcu_fd_sc_mcu7t5v0__fill_2
X$379 VDD VSS VDD VSS gf180mcu_fd_sc_mcu7t5v0__fill_2
X$380 VDD VSS VDD VSS gf180mcu_fd_sc_mcu7t5v0__fill_2
X$381 VDD VSS VDD VSS gf180mcu_fd_sc_mcu7t5v0__fill_2
X$382 VDD VSS VDD VSS gf180mcu_fd_sc_mcu7t5v0__fill_2
X$383 VDD VSS VDD VSS gf180mcu_fd_sc_mcu7t5v0__fill_2
X$384 VDD VSS VDD VSS gf180mcu_fd_sc_mcu7t5v0__fill_2
X$385 VDD VSS VDD VSS gf180mcu_fd_sc_mcu7t5v0__fill_2
X$386 VDD VSS VDD VSS gf180mcu_fd_sc_mcu7t5v0__fill_2
X$387 VDD VSS VDD VSS gf180mcu_fd_sc_mcu7t5v0__fill_2
X$388 VDD VSS VDD VSS gf180mcu_fd_sc_mcu7t5v0__fill_2
X$389 VDD VSS VDD VSS gf180mcu_fd_sc_mcu7t5v0__fill_2
X$390 VDD VSS VDD VSS gf180mcu_fd_sc_mcu7t5v0__fill_2
X$391 VDD VSS VDD VSS gf180mcu_fd_sc_mcu7t5v0__fill_2
X$392 VDD VSS VDD VSS gf180mcu_fd_sc_mcu7t5v0__fill_2
X$393 VDD VSS VDD VSS gf180mcu_fd_sc_mcu7t5v0__fill_2
X$394 VDD VSS VDD VSS gf180mcu_fd_sc_mcu7t5v0__fill_2
X$395 VDD VSS VDD VSS gf180mcu_fd_sc_mcu7t5v0__fill_2
X$396 VDD VSS VDD VSS gf180mcu_fd_sc_mcu7t5v0__fill_2
X$397 VDD VSS VDD VSS gf180mcu_fd_sc_mcu7t5v0__fill_2
X$398 VDD VSS VDD VSS gf180mcu_fd_sc_mcu7t5v0__fill_2
X$399 VDD VSS VDD VSS gf180mcu_fd_sc_mcu7t5v0__fill_2
X$400 VDD VSS VDD VSS gf180mcu_fd_sc_mcu7t5v0__fill_2
X$401 VDD VSS VDD VSS gf180mcu_fd_sc_mcu7t5v0__fill_2
X$402 VDD VSS VDD VSS gf180mcu_fd_sc_mcu7t5v0__fill_2
X$403 VDD VSS VDD VSS gf180mcu_fd_sc_mcu7t5v0__fill_2
X$404 VDD VSS VDD VSS gf180mcu_fd_sc_mcu7t5v0__fill_2
X$405 VDD VSS VDD VSS gf180mcu_fd_sc_mcu7t5v0__fill_2
X$406 VDD VSS VDD VSS gf180mcu_fd_sc_mcu7t5v0__fill_2
X$407 VDD VSS VDD VSS gf180mcu_fd_sc_mcu7t5v0__fill_2
X$408 VDD VSS VDD VSS gf180mcu_fd_sc_mcu7t5v0__fill_2
X$409 VDD VSS VDD VSS gf180mcu_fd_sc_mcu7t5v0__fill_2
X$410 VDD VSS VDD VSS gf180mcu_fd_sc_mcu7t5v0__fill_2
X$411 VDD VSS VDD VSS gf180mcu_fd_sc_mcu7t5v0__fill_2
X$412 VDD VSS VDD VSS gf180mcu_fd_sc_mcu7t5v0__fill_2
X$413 VSS VDD VDD VSS VSS gf180mcu_fd_sc_mcu7t5v0__fillcap_4
X$414 VSS VDD VDD VSS VSS gf180mcu_fd_sc_mcu7t5v0__fillcap_4
X$415 VSS VDD VDD VSS VSS gf180mcu_fd_sc_mcu7t5v0__fillcap_4
X$416 VSS VDD VDD VSS VSS gf180mcu_fd_sc_mcu7t5v0__fillcap_4
X$417 VSS VDD VDD VSS VSS gf180mcu_fd_sc_mcu7t5v0__fillcap_4
X$418 VSS VDD VDD VSS VSS gf180mcu_fd_sc_mcu7t5v0__fillcap_4
X$419 VSS VDD VDD VSS VSS gf180mcu_fd_sc_mcu7t5v0__fillcap_4
X$420 VSS VDD VDD VSS VSS gf180mcu_fd_sc_mcu7t5v0__fillcap_4
X$421 VSS VDD VDD VSS VSS gf180mcu_fd_sc_mcu7t5v0__fillcap_4
X$422 VSS VDD VDD VSS VSS gf180mcu_fd_sc_mcu7t5v0__fillcap_4
X$423 VSS VDD VDD VSS VSS gf180mcu_fd_sc_mcu7t5v0__fillcap_4
X$424 VSS VDD VDD VSS VSS gf180mcu_fd_sc_mcu7t5v0__fillcap_4
X$425 VSS VDD VDD VSS VSS gf180mcu_fd_sc_mcu7t5v0__fillcap_4
X$426 VSS VDD VDD VSS VSS gf180mcu_fd_sc_mcu7t5v0__fillcap_4
X$427 VSS VDD VDD VSS VSS gf180mcu_fd_sc_mcu7t5v0__fillcap_4
X$428 VSS VDD VDD VSS VSS gf180mcu_fd_sc_mcu7t5v0__fillcap_4
X$429 VSS VDD VDD VSS VSS gf180mcu_fd_sc_mcu7t5v0__fillcap_4
X$430 VSS VDD VDD VSS VSS gf180mcu_fd_sc_mcu7t5v0__fillcap_4
X$431 VSS VDD VDD VSS VSS gf180mcu_fd_sc_mcu7t5v0__fillcap_4
X$432 VSS VDD VDD VSS VSS gf180mcu_fd_sc_mcu7t5v0__fillcap_4
X$433 VSS VDD VDD VSS VSS gf180mcu_fd_sc_mcu7t5v0__fillcap_4
X$434 VSS VDD VDD VSS VSS gf180mcu_fd_sc_mcu7t5v0__fillcap_4
X$435 VSS VDD VDD VSS VSS gf180mcu_fd_sc_mcu7t5v0__fillcap_4
X$436 VSS VDD VDD VSS VSS gf180mcu_fd_sc_mcu7t5v0__fillcap_4
X$437 VSS VDD VDD VSS VSS gf180mcu_fd_sc_mcu7t5v0__fillcap_4
X$438 VSS VDD VDD VSS VSS gf180mcu_fd_sc_mcu7t5v0__fillcap_4
X$439 VSS VDD VDD VSS VSS gf180mcu_fd_sc_mcu7t5v0__fillcap_4
X$440 VSS VDD VDD VSS VSS gf180mcu_fd_sc_mcu7t5v0__fillcap_4
X$441 VSS VDD VDD VSS VSS gf180mcu_fd_sc_mcu7t5v0__fillcap_4
X$442 VSS VDD VDD VSS VSS gf180mcu_fd_sc_mcu7t5v0__fillcap_4
X$443 VSS VDD VDD VSS VSS gf180mcu_fd_sc_mcu7t5v0__fillcap_4
X$444 VSS VDD VDD VSS VSS gf180mcu_fd_sc_mcu7t5v0__fillcap_4
X$445 VSS VDD VDD VSS VSS gf180mcu_fd_sc_mcu7t5v0__fillcap_4
X$446 VSS VDD VDD VSS VSS gf180mcu_fd_sc_mcu7t5v0__fillcap_4
X$447 VSS VDD VDD VSS VSS gf180mcu_fd_sc_mcu7t5v0__fillcap_4
X$448 VSS VDD VDD VSS VSS gf180mcu_fd_sc_mcu7t5v0__fillcap_4
X$449 VSS VDD VDD VSS VSS gf180mcu_fd_sc_mcu7t5v0__fillcap_4
X$450 VSS VDD VDD VSS VSS gf180mcu_fd_sc_mcu7t5v0__fillcap_4
X$451 VSS VDD VDD VSS VSS gf180mcu_fd_sc_mcu7t5v0__fillcap_4
X$452 VSS VDD VDD VSS VSS gf180mcu_fd_sc_mcu7t5v0__fillcap_4
X$453 VSS VDD VDD VSS VSS gf180mcu_fd_sc_mcu7t5v0__fillcap_4
X$454 VSS VDD VDD VSS VSS gf180mcu_fd_sc_mcu7t5v0__fillcap_4
X$455 VSS VDD VDD VSS VSS gf180mcu_fd_sc_mcu7t5v0__fillcap_4
X$456 VSS VDD VDD VSS VSS gf180mcu_fd_sc_mcu7t5v0__fillcap_4
X$457 VSS VDD VDD VSS VSS gf180mcu_fd_sc_mcu7t5v0__fillcap_4
X$458 VSS VDD VDD VSS VSS gf180mcu_fd_sc_mcu7t5v0__fillcap_4
X$459 VSS VDD VDD VSS VSS gf180mcu_fd_sc_mcu7t5v0__fillcap_4
X$460 VSS VDD VDD VSS VSS gf180mcu_fd_sc_mcu7t5v0__fillcap_4
X$461 VSS VDD VDD VSS VSS gf180mcu_fd_sc_mcu7t5v0__fillcap_4
X$462 VSS VDD VDD VSS VSS gf180mcu_fd_sc_mcu7t5v0__fillcap_4
X$463 VSS VDD VDD VSS VSS gf180mcu_fd_sc_mcu7t5v0__fillcap_4
X$464 VSS VDD VDD VSS VSS gf180mcu_fd_sc_mcu7t5v0__fillcap_4
X$465 VSS VDD VDD VSS VSS gf180mcu_fd_sc_mcu7t5v0__fillcap_4
X$466 VSS VDD VDD VSS VSS gf180mcu_fd_sc_mcu7t5v0__fillcap_4
X$467 VSS VDD VDD VSS VSS gf180mcu_fd_sc_mcu7t5v0__fillcap_4
X$468 VSS VDD VDD VSS VSS gf180mcu_fd_sc_mcu7t5v0__fillcap_4
X$469 VSS VDD VDD VSS VSS gf180mcu_fd_sc_mcu7t5v0__fillcap_4
X$470 VSS VDD VDD VSS VSS gf180mcu_fd_sc_mcu7t5v0__fillcap_4
X$471 VSS VDD VDD VSS VSS gf180mcu_fd_sc_mcu7t5v0__fillcap_4
X$472 VSS VDD VDD VSS VSS gf180mcu_fd_sc_mcu7t5v0__fillcap_4
X$473 VSS VDD VDD VSS VSS gf180mcu_fd_sc_mcu7t5v0__fillcap_4
X$474 VSS VDD VDD VSS VSS gf180mcu_fd_sc_mcu7t5v0__fillcap_4
X$475 VDD VSS gf180mcu_fd_sc_mcu7t5v0__filltie
X$476 VDD VSS gf180mcu_fd_sc_mcu7t5v0__filltie
X$477 VDD VSS gf180mcu_fd_sc_mcu7t5v0__filltie
X$478 VDD VSS gf180mcu_fd_sc_mcu7t5v0__filltie
X$479 VDD VSS gf180mcu_fd_sc_mcu7t5v0__filltie
X$480 VDD VSS gf180mcu_fd_sc_mcu7t5v0__filltie
X$481 VDD VSS gf180mcu_fd_sc_mcu7t5v0__filltie
X$482 VDD VSS gf180mcu_fd_sc_mcu7t5v0__filltie
X$483 VDD VSS gf180mcu_fd_sc_mcu7t5v0__filltie
X$484 VDD VSS gf180mcu_fd_sc_mcu7t5v0__filltie
X$485 VDD VSS gf180mcu_fd_sc_mcu7t5v0__filltie
X$486 VDD VSS gf180mcu_fd_sc_mcu7t5v0__filltie
X$487 VDD VSS gf180mcu_fd_sc_mcu7t5v0__filltie
X$488 VDD VSS gf180mcu_fd_sc_mcu7t5v0__filltie
X$489 VDD VSS gf180mcu_fd_sc_mcu7t5v0__filltie
X$490 VDD VSS gf180mcu_fd_sc_mcu7t5v0__filltie
X$491 VDD VSS gf180mcu_fd_sc_mcu7t5v0__filltie
X$492 VDD VSS gf180mcu_fd_sc_mcu7t5v0__filltie
X$493 VDD VSS gf180mcu_fd_sc_mcu7t5v0__filltie
X$494 VDD VSS gf180mcu_fd_sc_mcu7t5v0__filltie
X$495 VDD VSS gf180mcu_fd_sc_mcu7t5v0__filltie
X$496 VDD VSS gf180mcu_fd_sc_mcu7t5v0__filltie
X$497 VDD VSS gf180mcu_fd_sc_mcu7t5v0__filltie
X$498 VDD VSS gf180mcu_fd_sc_mcu7t5v0__filltie
X$499 VDD VSS gf180mcu_fd_sc_mcu7t5v0__filltie
X$500 VDD VSS gf180mcu_fd_sc_mcu7t5v0__filltie
X$501 VDD VSS gf180mcu_fd_sc_mcu7t5v0__filltie
X$502 VDD VSS gf180mcu_fd_sc_mcu7t5v0__filltie
X$503 VDD VSS gf180mcu_fd_sc_mcu7t5v0__filltie
X$504 VDD VSS gf180mcu_fd_sc_mcu7t5v0__filltie
X$505 VDD VSS gf180mcu_fd_sc_mcu7t5v0__filltie
X$506 VDD VSS gf180mcu_fd_sc_mcu7t5v0__filltie
X$507 VDD VSS gf180mcu_fd_sc_mcu7t5v0__filltie
X$508 VDD VSS gf180mcu_fd_sc_mcu7t5v0__filltie
X$509 VDD VSS gf180mcu_fd_sc_mcu7t5v0__filltie
X$510 VDD VSS gf180mcu_fd_sc_mcu7t5v0__filltie
X$511 VDD VSS gf180mcu_fd_sc_mcu7t5v0__filltie
X$512 VDD VSS gf180mcu_fd_sc_mcu7t5v0__filltie
X$513 VDD VSS gf180mcu_fd_sc_mcu7t5v0__filltie
X$514 VSS VSS VDD VDD VSS gf180mcu_fd_sc_mcu7t5v0__fillcap_32
X$515 VDD VSS gf180mcu_fd_sc_mcu7t5v0__filltie
X$516 VDD VSS gf180mcu_fd_sc_mcu7t5v0__filltie
X$517 VDD VSS gf180mcu_fd_sc_mcu7t5v0__filltie
X$518 VSS VDD \$481 \$185 \$250 \$292 \$248 VDD VSS VSS
+ gf180mcu_fd_sc_mcu7t5v0__nor4_1
X$519 VDD VSS gf180mcu_fd_sc_mcu7t5v0__filltie
X$520 VDD VSS gf180mcu_fd_sc_mcu7t5v0__filltie
X$521 VDD VSS gf180mcu_fd_sc_mcu7t5v0__filltie
X$522 VDD VSS gf180mcu_fd_sc_mcu7t5v0__filltie
X$523 VDD VSS gf180mcu_fd_sc_mcu7t5v0__filltie
X$524 VDD VSS gf180mcu_fd_sc_mcu7t5v0__filltie
X$525 VDD VSS gf180mcu_fd_sc_mcu7t5v0__filltie
X$526 VDD VSS gf180mcu_fd_sc_mcu7t5v0__filltie
X$527 VDD VSS gf180mcu_fd_sc_mcu7t5v0__filltie
X$528 VDD VSS gf180mcu_fd_sc_mcu7t5v0__filltie
X$529 VDD VSS gf180mcu_fd_sc_mcu7t5v0__filltie
X$530 VDD VSS gf180mcu_fd_sc_mcu7t5v0__filltie
X$531 VDD VSS gf180mcu_fd_sc_mcu7t5v0__filltie
X$532 VDD VSS gf180mcu_fd_sc_mcu7t5v0__filltie
X$533 VDD VSS gf180mcu_fd_sc_mcu7t5v0__filltie
X$534 VDD VSS gf180mcu_fd_sc_mcu7t5v0__filltie
X$535 VDD VSS gf180mcu_fd_sc_mcu7t5v0__filltie
X$536 VDD VSS gf180mcu_fd_sc_mcu7t5v0__filltie
X$537 VDD VSS gf180mcu_fd_sc_mcu7t5v0__filltie
X$538 VDD VSS gf180mcu_fd_sc_mcu7t5v0__filltie
X$539 VDD VSS gf180mcu_fd_sc_mcu7t5v0__filltie
X$540 VDD VSS gf180mcu_fd_sc_mcu7t5v0__filltie
X$541 VDD VSS gf180mcu_fd_sc_mcu7t5v0__filltie
X$542 VDD VSS gf180mcu_fd_sc_mcu7t5v0__filltie
X$543 VDD VSS gf180mcu_fd_sc_mcu7t5v0__filltie
X$544 VSS VDD VDD VSS VSS gf180mcu_fd_sc_mcu7t5v0__fillcap_4
X$545 VDD VSS VDD VSS gf180mcu_fd_sc_mcu7t5v0__fill_2
X$546 VDD VSS VDD VSS gf180mcu_fd_sc_mcu7t5v0__fill_1
X$547 VDD VSS gf180mcu_fd_sc_mcu7t5v0__filltie
X$548 VDD VSS gf180mcu_fd_sc_mcu7t5v0__filltie
X$549 VDD VSS gf180mcu_fd_sc_mcu7t5v0__filltie
X$550 VDD VSS gf180mcu_fd_sc_mcu7t5v0__filltie
X$551 VDD VSS gf180mcu_fd_sc_mcu7t5v0__filltie
X$552 VDD VSS gf180mcu_fd_sc_mcu7t5v0__filltie
X$553 VDD VSS gf180mcu_fd_sc_mcu7t5v0__filltie
X$554 VDD VSS gf180mcu_fd_sc_mcu7t5v0__filltie
X$555 VDD VSS gf180mcu_fd_sc_mcu7t5v0__filltie
X$556 VDD VSS gf180mcu_fd_sc_mcu7t5v0__filltie
X$557 VDD VSS gf180mcu_fd_sc_mcu7t5v0__filltie
X$558 VDD VSS gf180mcu_fd_sc_mcu7t5v0__filltie
X$559 VDD VSS gf180mcu_fd_sc_mcu7t5v0__filltie
X$560 VDD VSS gf180mcu_fd_sc_mcu7t5v0__filltie
X$561 VDD VSS gf180mcu_fd_sc_mcu7t5v0__filltie
X$562 VDD VSS gf180mcu_fd_sc_mcu7t5v0__filltie
X$563 VDD VSS gf180mcu_fd_sc_mcu7t5v0__filltie
X$564 \$428 VDD VSS \$321 VDD VSS VSS gf180mcu_fd_sc_mcu7t5v0__dlyb_1
X$565 \$315 VDD VSS \$309 VDD VSS VSS gf180mcu_fd_sc_mcu7t5v0__dlyb_1
X$566 VSS VDD \$454 \$452 \$503 VDD VSS VSS gf180mcu_fd_sc_mcu7t5v0__nand2_1
X$567 dec_in[6] VDD VSS \$465 VDD VSS VSS gf180mcu_fd_sc_mcu7t5v0__dlyb_1
X$568 dec_in[2] VDD VSS \$544 VDD VSS VSS gf180mcu_fd_sc_mcu7t5v0__dlyb_1
X$569 VSS VDD \$528 \$289 \$288 VDD VSS VSS gf180mcu_fd_sc_mcu7t5v0__nor2_1
X$570 \$329 VDD VSS \$290 VDD VSS VSS gf180mcu_fd_sc_mcu7t5v0__dlyb_1
X$571 \$529 VDD VSS \$456 VDD VSS VSS gf180mcu_fd_sc_mcu7t5v0__dlyb_1
X$572 \$322 VDD VSS \$283 VDD VSS VSS gf180mcu_fd_sc_mcu7t5v0__dlyb_1
X$573 \$526 VDD VSS \$479 VDD VSS VSS gf180mcu_fd_sc_mcu7t5v0__dlyb_1
X$574 \$171 VDD VSS dec_out[65] VDD VSS VSS gf180mcu_fd_sc_mcu7t5v0__dlyb_1
X$575 \$479 VDD VSS \$364 VDD VSS VSS gf180mcu_fd_sc_mcu7t5v0__dlyb_1
X$576 \$461 VDD VSS \$351 VDD VSS VSS gf180mcu_fd_sc_mcu7t5v0__dlyb_1
X$577 \$479 VDD VSS \$452 VDD VSS VSS gf180mcu_fd_sc_mcu7t5v0__dlyb_1
X$578 \$457 VDD VSS \$367 VDD VSS VSS gf180mcu_fd_sc_mcu7t5v0__dlyb_1
X$579 VSS VDD \$560 \$245 \$286 \$285 VDD VSS VSS
+ gf180mcu_fd_sc_mcu7t5v0__nor3_1
X$580 \$451 VDD VSS \$313 VDD VSS VSS gf180mcu_fd_sc_mcu7t5v0__dlyb_1
X$581 VDD \$461 \$460 \$403 \$455 VSS \$375 VDD VSS VSS
+ gf180mcu_fd_sc_mcu7t5v0__and4_1
X$582 \$456 VDD VSS \$429 VDD VSS VSS gf180mcu_fd_sc_mcu7t5v0__dlyb_1
X$583 \$289 VDD VSS \$457 VDD VSS VSS gf180mcu_fd_sc_mcu7t5v0__dlyb_1
X$584 \$321 VDD VSS \$317 VDD VSS VSS gf180mcu_fd_sc_mcu7t5v0__dlyb_1
X$585 \$318 VDD VSS \$480 VDD VSS VSS gf180mcu_fd_sc_mcu7t5v0__dlyb_1
X$586 \$399 VSS VDD \$207 VDD VSS VSS gf180mcu_fd_sc_mcu7t5v0__clkbuf_1
X$587 \$274 VDD VSS dec_out[50] VDD VSS VSS gf180mcu_fd_sc_mcu7t5v0__dlyb_1
X$588 \$429 VDD VSS \$355 VDD VSS VSS gf180mcu_fd_sc_mcu7t5v0__dlyb_1
X$589 dec_in[3] VDD VSS \$453 VDD VSS VSS gf180mcu_fd_sc_mcu7t5v0__dlyb_1
X$590 \$322 VDD VSS \$357 VDD VSS VSS gf180mcu_fd_sc_mcu7t5v0__dlyb_1
X$591 \$329 VDD VSS \$250 VDD VSS VSS gf180mcu_fd_sc_mcu7t5v0__dlyb_1
X$592 \$168 VDD VSS dec_out[56] VDD VSS VSS gf180mcu_fd_sc_mcu7t5v0__dlyb_1
X$593 \$170 VDD VSS dec_out[63] VDD VSS VSS gf180mcu_fd_sc_mcu7t5v0__dlyb_1
X$594 \$239 VDD VSS dec_out[47] VDD VSS VSS gf180mcu_fd_sc_mcu7t5v0__dlyb_1
X$595 \$359 VDD VSS dec_out[115] VDD VSS VSS gf180mcu_fd_sc_mcu7t5v0__dlyb_1
X$596 \$241 VDD VSS dec_out[52] VDD VSS VSS gf180mcu_fd_sc_mcu7t5v0__dlyb_1
X$597 \$165 VDD VSS dec_out[45] VDD VSS VSS gf180mcu_fd_sc_mcu7t5v0__dlyb_1
X$598 \$158 VDD VSS dec_out[14] VDD VSS VSS gf180mcu_fd_sc_mcu7t5v0__dlyb_1
X$599 \$479 VDD VSS \$505 VDD VSS VSS gf180mcu_fd_sc_mcu7t5v0__dlyb_1
X$600 \$234 VDD VSS dec_out[26] VDD VSS VSS gf180mcu_fd_sc_mcu7t5v0__dlyb_1
X$601 \$233 VDD VSS dec_out[17] VDD VSS VSS gf180mcu_fd_sc_mcu7t5v0__dlyb_1
X$602 \$231 VDD VSS dec_out[9] VDD VSS VSS gf180mcu_fd_sc_mcu7t5v0__dlyb_1
X$603 \$316 VDD VSS dec_out[20] VDD VSS VSS gf180mcu_fd_sc_mcu7t5v0__dlyb_1
X$604 \$207 VDD VSS dec_out[8] VDD VSS VSS gf180mcu_fd_sc_mcu7t5v0__dlyb_1
X$605 \$163 VDD VSS dec_out[38] VDD VSS VSS gf180mcu_fd_sc_mcu7t5v0__dlyb_1
X$606 \$237 VDD VSS dec_out[35] VDD VSS VSS gf180mcu_fd_sc_mcu7t5v0__dlyb_1
X$607 \$526 VDD VSS \$460 VDD VSS VSS gf180mcu_fd_sc_mcu7t5v0__dlyb_1
X$608 \$311 VDD VSS dec_out[2] VDD VSS VSS gf180mcu_fd_sc_mcu7t5v0__dlyb_1
X$609 \$236 VDD VSS dec_out[51] VDD VSS VSS gf180mcu_fd_sc_mcu7t5v0__dlyb_1
X$610 \$238 VDD VSS dec_out[40] VDD VSS VSS gf180mcu_fd_sc_mcu7t5v0__dlyb_1
X$611 \$159 VDD VSS dec_out[23] VDD VSS VSS gf180mcu_fd_sc_mcu7t5v0__dlyb_1
X$612 \$161 VDD VSS dec_out[31] VDD VSS VSS gf180mcu_fd_sc_mcu7t5v0__dlyb_1
X$613 \$453 VDD VSS \$506 VDD VSS VSS gf180mcu_fd_sc_mcu7t5v0__dlyb_1
X$614 \$460 VDD VSS \$401 VDD VSS VSS gf180mcu_fd_sc_mcu7t5v0__dlyb_1
X$615 \$457 VDD VSS \$285 VDD VSS VSS gf180mcu_fd_sc_mcu7t5v0__dlyb_1
X$616 \$172 VDD VSS dec_out[67] VDD VSS VSS gf180mcu_fd_sc_mcu7t5v0__dlyb_1
X$617 \$429 VDD VSS \$326 VDD VSS VSS gf180mcu_fd_sc_mcu7t5v0__dlyb_1
X$618 \$460 VDD VSS \$325 VDD VSS VSS gf180mcu_fd_sc_mcu7t5v0__dlyb_1
X$619 \$326 VDD VSS \$286 VDD VSS VSS gf180mcu_fd_sc_mcu7t5v0__dlyb_1
X$620 \$476 VDD VSS \$474 VDD VSS VSS gf180mcu_fd_sc_mcu7t5v0__dlyb_1
X$621 \$465 VDD VSS \$461 VDD VSS VSS gf180mcu_fd_sc_mcu7t5v0__dlyb_1
X$622 \$453 VDD VSS \$501 VDD VSS VSS gf180mcu_fd_sc_mcu7t5v0__dlyb_1
X$623 \$461 VDD VSS \$397 VDD VSS VSS gf180mcu_fd_sc_mcu7t5v0__dlyb_1
X$624 \$492 VDD VSS dec_out[124] VDD VSS VSS gf180mcu_fd_sc_mcu7t5v0__dlyb_1
X$625 \$456 VDD VSS \$451 VDD VSS VSS gf180mcu_fd_sc_mcu7t5v0__dlyb_1
X$626 \$428 VDD VSS \$404 VDD VSS VSS gf180mcu_fd_sc_mcu7t5v0__dlyb_1
X$627 \$283 VDD VSS \$365 VDD VSS VSS gf180mcu_fd_sc_mcu7t5v0__dlyb_1
X$628 \$461 VDD VSS \$450 VDD VSS VSS gf180mcu_fd_sc_mcu7t5v0__dlyb_1
X$629 \$249 VDD VSS \$248 VDD VSS VSS gf180mcu_fd_sc_mcu7t5v0__dlyb_1
X$630 \$535 VDD VSS dec_out[123] VDD VSS VSS gf180mcu_fd_sc_mcu7t5v0__dlyb_1
X$631 \$313 VDD VSS \$310 VDD VSS VSS gf180mcu_fd_sc_mcu7t5v0__dlyb_1
X$632 \$289 VDD VSS \$328 VDD VSS VSS gf180mcu_fd_sc_mcu7t5v0__dlyb_1
X$633 \$317 VDD VSS \$545 VDD VSS VSS gf180mcu_fd_sc_mcu7t5v0__dlyb_1
X$634 \$328 VDD VSS \$354 VDD VSS VSS gf180mcu_fd_sc_mcu7t5v0__dlyb_1
X$635 \$450 VDD VSS \$315 VDD VSS VSS gf180mcu_fd_sc_mcu7t5v0__dlyb_1
X$636 \$397 VDD VSS \$318 VDD VSS VSS gf180mcu_fd_sc_mcu7t5v0__dlyb_1
X$637 \$429 VDD VSS \$403 VDD VSS VSS gf180mcu_fd_sc_mcu7t5v0__dlyb_1
X$638 \$508 VDD VSS \$322 VDD VSS VSS gf180mcu_fd_sc_mcu7t5v0__dlyb_1
X$639 \$404 VDD VSS \$329 VDD VSS VSS gf180mcu_fd_sc_mcu7t5v0__dlyb_1
X$640 \$119 VDD VSS dec_out[34] VDD VSS VSS gf180mcu_fd_sc_mcu7t5v0__dlyb_1
X$641 \$162 VDD VSS dec_out[29] VDD VSS VSS gf180mcu_fd_sc_mcu7t5v0__dlyb_1
X$642 dec_in[0] VDD VSS \$476 VDD VSS VSS gf180mcu_fd_sc_mcu7t5v0__dlyb_1
X$643 \$127 VDD VSS dec_out[57] VDD VSS VSS gf180mcu_fd_sc_mcu7t5v0__dlyb_1
X$644 dec_in[5] VDD VSS \$529 VDD VSS VSS gf180mcu_fd_sc_mcu7t5v0__dlyb_1
X$645 \$544 VDD VSS \$475 VDD VSS VSS gf180mcu_fd_sc_mcu7t5v0__dlyb_1
X$646 \$121 VDD VSS dec_out[39] VDD VSS VSS gf180mcu_fd_sc_mcu7t5v0__dlyb_1
X$647 \$166 VDD VSS dec_out[60] VDD VSS VSS gf180mcu_fd_sc_mcu7t5v0__dlyb_1
X$648 \$167 VDD VSS dec_out[49] VDD VSS VSS gf180mcu_fd_sc_mcu7t5v0__dlyb_1
X$649 dec_in[1] VDD VSS \$487 VDD VSS VSS gf180mcu_fd_sc_mcu7t5v0__dlyb_1
X$650 \$164 VDD VSS dec_out[42] VDD VSS VSS gf180mcu_fd_sc_mcu7t5v0__dlyb_1
X$651 \$128 VDD VSS dec_out[62] VDD VSS VSS gf180mcu_fd_sc_mcu7t5v0__dlyb_1
X$652 \$123 VDD VSS dec_out[46] VDD VSS VSS gf180mcu_fd_sc_mcu7t5v0__dlyb_1
X$653 \$289 VDD VSS \$249 VDD VSS VSS gf180mcu_fd_sc_mcu7t5v0__dlyb_1
X$654 \$487 VDD VSS \$441 VDD VSS VSS gf180mcu_fd_sc_mcu7t5v0__dlyb_1
X$655 \$155 VDD VSS dec_out[36] VDD VSS VSS gf180mcu_fd_sc_mcu7t5v0__dlyb_1
X$656 \$271 VDD VSS dec_out[16] VDD VSS VSS gf180mcu_fd_sc_mcu7t5v0__dlyb_1
X$657 \$249 VDD VSS \$291 VDD VSS VSS gf180mcu_fd_sc_mcu7t5v0__dlyb_1
X$658 \$357 VDD VSS \$292 VDD VSS VSS gf180mcu_fd_sc_mcu7t5v0__dlyb_1
X$659 \$272 VDD VSS dec_out[25] VDD VSS VSS gf180mcu_fd_sc_mcu7t5v0__dlyb_1
X$660 \$270 VDD VSS dec_out[7] VDD VSS VSS gf180mcu_fd_sc_mcu7t5v0__dlyb_1
X$661 \$460 VDD VSS \$405 VDD VSS VSS gf180mcu_fd_sc_mcu7t5v0__dlyb_1
X$662 \$157 VDD VSS dec_out[12] VDD VSS VSS gf180mcu_fd_sc_mcu7t5v0__dlyb_1
X$663 \$118 VDD VSS dec_out[28] VDD VSS VSS gf180mcu_fd_sc_mcu7t5v0__dlyb_1
X$664 \$160 VDD VSS dec_out[21] VDD VSS VSS gf180mcu_fd_sc_mcu7t5v0__dlyb_1
X$665 \$117 VDD VSS dec_out[19] VDD VSS VSS gf180mcu_fd_sc_mcu7t5v0__dlyb_1
X$666 \$126 VDD VSS dec_out[53] VDD VSS VSS gf180mcu_fd_sc_mcu7t5v0__dlyb_1
X$667 dec_in[4] VDD VSS \$526 VDD VSS VSS gf180mcu_fd_sc_mcu7t5v0__dlyb_1
X$668 VDD VSS gf180mcu_fd_sc_mcu7t5v0__endcap
X$669 VDD VSS gf180mcu_fd_sc_mcu7t5v0__endcap
X$670 VDD VSS gf180mcu_fd_sc_mcu7t5v0__endcap
X$671 VDD VSS gf180mcu_fd_sc_mcu7t5v0__endcap
X$672 VDD VSS gf180mcu_fd_sc_mcu7t5v0__endcap
X$673 VDD VSS gf180mcu_fd_sc_mcu7t5v0__endcap
X$674 VDD VSS gf180mcu_fd_sc_mcu7t5v0__endcap
X$675 VDD VSS gf180mcu_fd_sc_mcu7t5v0__endcap
X$676 VDD VSS gf180mcu_fd_sc_mcu7t5v0__endcap
X$677 VDD VSS gf180mcu_fd_sc_mcu7t5v0__endcap
X$678 VDD VSS gf180mcu_fd_sc_mcu7t5v0__endcap
X$679 VDD VSS gf180mcu_fd_sc_mcu7t5v0__endcap
X$680 VDD VSS gf180mcu_fd_sc_mcu7t5v0__endcap
X$681 VDD VSS gf180mcu_fd_sc_mcu7t5v0__endcap
X$682 VDD VSS gf180mcu_fd_sc_mcu7t5v0__endcap
X$683 VDD VSS gf180mcu_fd_sc_mcu7t5v0__endcap
X$684 VDD VSS gf180mcu_fd_sc_mcu7t5v0__endcap
X$685 VDD VSS gf180mcu_fd_sc_mcu7t5v0__endcap
X$686 VSS VDD VDD VSS VSS gf180mcu_fd_sc_mcu7t5v0__fillcap_8
X$687 VDD VSS gf180mcu_fd_sc_mcu7t5v0__endcap
X$688 VDD VSS gf180mcu_fd_sc_mcu7t5v0__endcap
X$689 VDD VSS gf180mcu_fd_sc_mcu7t5v0__endcap
X$690 VDD VSS gf180mcu_fd_sc_mcu7t5v0__endcap
X$691 VDD VSS gf180mcu_fd_sc_mcu7t5v0__endcap
X$692 VDD VSS gf180mcu_fd_sc_mcu7t5v0__endcap
X$693 VDD VSS gf180mcu_fd_sc_mcu7t5v0__endcap
X$694 VDD VSS gf180mcu_fd_sc_mcu7t5v0__endcap
X$695 VDD VSS gf180mcu_fd_sc_mcu7t5v0__endcap
X$696 VDD VSS gf180mcu_fd_sc_mcu7t5v0__endcap
X$697 VDD VSS gf180mcu_fd_sc_mcu7t5v0__endcap
X$698 VDD VSS gf180mcu_fd_sc_mcu7t5v0__endcap
X$699 VSS VDD \$441 \$420 VDD VSS VSS gf180mcu_fd_sc_mcu7t5v0__clkinv_1
X$700 VSS VDD \$501 \$423 \$483 \$441 \$421 VDD VSS VSS
+ gf180mcu_fd_sc_mcu7t5v0__nand4_1
X$701 VDD VSS gf180mcu_fd_sc_mcu7t5v0__endcap
X$702 VDD VSS gf180mcu_fd_sc_mcu7t5v0__endcap
X$703 VDD VSS gf180mcu_fd_sc_mcu7t5v0__endcap
X$704 VSS VSS VDD VDD VSS gf180mcu_fd_sc_mcu7t5v0__fillcap_16
X$705 VDD VSS gf180mcu_fd_sc_mcu7t5v0__endcap
X$706 VDD VSS gf180mcu_fd_sc_mcu7t5v0__filltie
.ENDS decoder_7to128

.SUBCKT inv_dut_031 Q A VDD VSS
M$1 Q A VDD VDD pfet_03v3 L=0.9U W=8.1U AS=5.265P AD=5.265P PS=17.5U PD=17.5U
M$2 Q A VSS VSS nfet_03v3 L=0.9U W=2.7U AS=1.647P AD=1.647P PS=6.62U PD=6.62U
.ENDS inv_dut_031

.SUBCKT inv_dut_030 Q A VDD VSS
M$1 Q A VDD VDD pfet_03v3 L=0.6U W=8.1U AS=5.265P AD=5.265P PS=17.5U PD=17.5U
M$2 Q A VSS VSS nfet_03v3 L=0.6U W=2.7U AS=1.647P AD=1.647P PS=6.62U PD=6.62U
.ENDS inv_dut_030

.SUBCKT inv_dut_040 Q A VDD VSS
M$1 Q A VDD VDD pfet_05v0 L=0.6U W=16.2U AS=12.474P AD=12.474P PS=33.94U
+ PD=33.94U
M$2 Q A VSS VSS nfet_05v0 L=0.6U W=5.4U AS=3.942P AD=3.942P PS=12.26U PD=12.26U
.ENDS inv_dut_040

.SUBCKT inv_dut_043 Q A VDD VSS
M$1 Q A VDD VDD pfet_05v0 L=1.2U W=10.8U AS=8.316P AD=8.316P PS=23.14U PD=23.14U
M$2 Q A VSS VSS nfet_05v0 L=1.2U W=5.4U AS=3.942P AD=3.942P PS=12.26U PD=12.26U
.ENDS inv_dut_043

.SUBCKT inv_dut_042 Q A VDD VSS
M$1 Q A VDD VDD pfet_05v0 L=1.2U W=7.2U AS=5.544P AD=5.544P PS=15.94U PD=15.94U
M$2 Q A VSS VSS nfet_05v0 L=1.2U W=3.6U AS=2.628P AD=2.628P PS=8.66U PD=8.66U
.ENDS inv_dut_042

.SUBCKT inv_dut_041 Q A VDD VSS
M$1 Q A VDD VDD pfet_05v0 L=1.2U W=3.6U AS=2.772P AD=2.772P PS=8.74U PD=8.74U
M$2 Q A VSS VSS nfet_05v0 L=1.2U W=1.8U AS=1.314P AD=1.314P PS=5.06U PD=5.06U
.ENDS inv_dut_041

.SUBCKT inv_dut_047 Q A VDD VSS
M$1 Q A VDD VDD pfet_05v0 L=1.8U W=16.2U AS=12.474P AD=12.474P PS=33.94U
+ PD=33.94U
M$2 Q A VSS VSS nfet_05v0 L=1.8U W=5.4U AS=3.942P AD=3.942P PS=12.26U PD=12.26U
.ENDS inv_dut_047

.SUBCKT inv_dut_046 Q A VDD VSS
M$1 Q A VDD VDD pfet_05v0 L=1.2U W=16.2U AS=12.474P AD=12.474P PS=33.94U
+ PD=33.94U
M$2 Q A VSS VSS nfet_05v0 L=1.2U W=5.4U AS=3.942P AD=3.942P PS=12.26U PD=12.26U
.ENDS inv_dut_046

.SUBCKT inv_dut_045 Q A VDD VSS
M$1 Q A VDD VDD pfet_05v0 L=1.2U W=10.8U AS=8.316P AD=8.316P PS=23.14U PD=23.14U
M$2 Q A VSS VSS nfet_05v0 L=1.2U W=3.6U AS=2.628P AD=2.628P PS=8.66U PD=8.66U
.ENDS inv_dut_045

.SUBCKT inv_dut_044 Q A VDD VSS
M$1 Q A VDD VDD pfet_05v0 L=1.2U W=5.4U AS=4.158P AD=4.158P PS=12.34U PD=12.34U
M$2 Q A VSS VSS nfet_05v0 L=1.2U W=1.8U AS=1.314P AD=1.314P PS=5.06U PD=5.06U
.ENDS inv_dut_044

.SUBCKT inv_dut_034 Q A VDD VSS
M$1 Q A VDD VDD pfet_05v0 L=0.6U W=5.4U AS=4.158P AD=4.158P PS=12.34U PD=12.34U
M$2 Q A VSS VSS nfet_05v0 L=0.6U W=5.4U AS=3.942P AD=3.942P PS=12.26U PD=12.26U
.ENDS inv_dut_034

.SUBCKT inv_dut_033 Q A VDD VSS
M$1 Q A VDD VDD pfet_05v0 L=0.6U W=3.6U AS=2.772P AD=2.772P PS=8.74U PD=8.74U
M$2 Q A VSS VSS nfet_05v0 L=0.6U W=3.6U AS=2.628P AD=2.628P PS=8.66U PD=8.66U
.ENDS inv_dut_033

.SUBCKT inv_dut_032 Q A VDD VSS
M$1 Q A VDD VDD pfet_05v0 L=0.6U W=1.8U AS=1.386P AD=1.386P PS=5.14U PD=5.14U
M$2 Q A VSS VSS nfet_05v0 L=0.6U W=1.8U AS=1.314P AD=1.314P PS=5.06U PD=5.06U
.ENDS inv_dut_032

.SUBCKT inv_dut_036 Q A VDD VSS
M$1 Q A VDD VDD pfet_05v0 L=0.6U W=7.2U AS=5.544P AD=5.544P PS=15.94U PD=15.94U
M$2 Q A VSS VSS nfet_05v0 L=0.6U W=3.6U AS=2.628P AD=2.628P PS=8.66U PD=8.66U
.ENDS inv_dut_036

.SUBCKT inv_dut_038 Q A VDD VSS
M$1 Q A VDD VDD pfet_05v0 L=0.6U W=5.4U AS=4.158P AD=4.158P PS=12.34U PD=12.34U
M$2 Q A VSS VSS nfet_05v0 L=0.6U W=1.8U AS=1.314P AD=1.314P PS=5.06U PD=5.06U
.ENDS inv_dut_038

.SUBCKT inv_dut_037 Q A VDD VSS
M$1 Q A VDD VDD pfet_05v0 L=0.6U W=10.8U AS=8.316P AD=8.316P PS=23.14U PD=23.14U
M$2 Q A VSS VSS nfet_05v0 L=0.6U W=5.4U AS=3.942P AD=3.942P PS=12.26U PD=12.26U
.ENDS inv_dut_037

.SUBCKT inv_dut_035 Q A VDD VSS
M$1 Q A VDD VDD pfet_05v0 L=0.6U W=3.6U AS=2.772P AD=2.772P PS=8.74U PD=8.74U
M$2 Q A VSS VSS nfet_05v0 L=0.6U W=1.8U AS=1.314P AD=1.314P PS=5.06U PD=5.06U
.ENDS inv_dut_035

.SUBCKT inv_dut_039 Q A VDD VSS
M$1 Q A VDD VDD pfet_05v0 L=0.6U W=10.8U AS=8.316P AD=8.316P PS=23.14U PD=23.14U
M$2 Q A VSS VSS nfet_05v0 L=0.6U W=3.6U AS=2.628P AD=2.628P PS=8.66U PD=8.66U
.ENDS inv_dut_039

.SUBCKT gf180mcu_fd_sc_mcu7t5v0__clkbuf_1 I VSS VDD Z \$6 \$7 SUB
M$1 \$1 I VDD \$6 pfet_05v0 L=0.5U W=1.05U AS=0.4015P AD=0.462P PS=1.92U
+ PD=2.98U
M$2 Z \$1 VDD \$6 pfet_05v0 L=0.5U W=1.22U AS=0.4015P AD=0.5368P PS=1.92U
+ PD=3.32U
M$3 VSS I \$1 SUB nfet_05v0 L=0.6U W=0.36U AS=0.1584P AD=0.153P PS=1.6U
+ PD=1.195U
M$4 Z \$1 VSS SUB nfet_05v0 L=0.6U W=0.495U AS=0.153P AD=0.2178P PS=1.195U
+ PD=1.87U
.ENDS gf180mcu_fd_sc_mcu7t5v0__clkbuf_1

.SUBCKT gf180mcu_fd_sc_mcu7t5v0__and2_1 VDD A1 A2 VSS Z \$8 \$9 SUB
M$1 \$1 A1 VDD \$8 pfet_05v0 L=0.5U W=0.6U AS=0.264P AD=0.156P PS=2.08U PD=1.12U
M$2 \$1 A2 VDD \$8 pfet_05v0 L=0.5U W=0.6U AS=0.40575P AD=0.156P PS=2.055U
+ PD=1.12U
M$3 Z \$1 VDD \$8 pfet_05v0 L=0.5U W=1.215U AS=0.40575P AD=0.5346P PS=2.055U
+ PD=3.31U
M$4 \$7 A1 \$1 SUB nfet_05v0 L=0.6U W=0.365U AS=0.1606P AD=0.0584P PS=1.61U
+ PD=0.685U
M$5 \$7 A2 VSS SUB nfet_05v0 L=0.6U W=0.365U AS=0.23405P AD=0.0584P PS=1.555U
+ PD=0.685U
M$6 Z \$1 VSS SUB nfet_05v0 L=0.6U W=0.815U AS=0.23405P AD=0.3586P PS=1.555U
+ PD=2.51U
.ENDS gf180mcu_fd_sc_mcu7t5v0__and2_1

.SUBCKT gf180mcu_fd_sc_mcu7t5v0__or4_1 VSS A1 A2 A3 A4 VDD Z \$12 \$13 SUB
M$1 \$11 A1 \$5 \$12 pfet_05v0 L=0.5U W=0.56U AS=0.2464P AD=0.196P PS=2U
+ PD=1.26U
M$2 \$10 A2 \$11 \$12 pfet_05v0 L=0.5U W=0.56U AS=0.196P AD=0.1736P PS=1.26U
+ PD=1.18U
M$3 \$9 A3 \$10 \$12 pfet_05v0 L=0.5U W=0.56U AS=0.1736P AD=0.1736P PS=1.18U
+ PD=1.18U
M$4 \$9 A4 VDD \$12 pfet_05v0 L=0.5U W=0.56U AS=0.389P AD=0.1736P PS=2.02U
+ PD=1.18U
M$5 Z \$5 VDD \$12 pfet_05v0 L=0.5U W=1.22U AS=0.389P AD=0.5368P PS=2.02U
+ PD=3.32U
M$6 \$5 A1 VSS SUB nfet_05v0 L=0.6U W=0.36U AS=0.1584P AD=0.126P PS=1.6U
+ PD=1.06U
M$7 VSS A2 \$5 SUB nfet_05v0 L=0.6U W=0.36U AS=0.126P AD=0.0936P PS=1.06U
+ PD=0.88U
M$8 \$5 A3 VSS SUB nfet_05v0 L=0.6U W=0.36U AS=0.0936P AD=0.0936P PS=0.88U
+ PD=0.88U
M$9 \$5 A4 VSS SUB nfet_05v0 L=0.6U W=0.36U AS=0.218P AD=0.0936P PS=1.52U
+ PD=0.88U
M$10 Z \$5 VSS SUB nfet_05v0 L=0.6U W=0.82U AS=0.218P AD=0.3608P PS=1.52U
+ PD=2.52U
.ENDS gf180mcu_fd_sc_mcu7t5v0__or4_1

.SUBCKT gf180mcu_fd_sc_mcu7t5v0__buf_2 I VSS VDD Z \$6 \$7 SUB
M$1 VDD I \$1 \$6 pfet_05v0 L=0.5U W=1.22U AS=0.5368P AD=0.4941P PS=3.32U
+ PD=2.03U
M$2 Z \$1 VDD \$6 pfet_05v0 L=0.5U W=2.44U AS=0.8723P AD=0.915P PS=3.87U
+ PD=5.16U
M$4 VSS I \$1 SUB nfet_05v0 L=0.6U W=0.82U AS=0.3608P AD=0.2911P PS=2.52U
+ PD=1.53U
M$5 Z \$1 VSS SUB nfet_05v0 L=0.6U W=1.64U AS=0.5043P AD=0.574P PS=2.87U
+ PD=3.86U
.ENDS gf180mcu_fd_sc_mcu7t5v0__buf_2

.SUBCKT gf180mcu_fd_sc_mcu7t5v0__buf_1 I VSS VDD Z \$6 \$7 SUB
M$1 \$1 I VDD \$6 pfet_05v0 L=0.5U W=0.565U AS=0.35315P AD=0.2486P PS=1.96U
+ PD=2.01U
M$2 Z \$1 VDD \$6 pfet_05v0 L=0.5U W=1.22U AS=0.35315P AD=0.5368P PS=1.96U
+ PD=3.32U
M$3 \$1 I VSS SUB nfet_05v0 L=0.6U W=0.36U AS=0.2344P AD=0.1584P PS=1.56U
+ PD=1.6U
M$4 Z \$1 VSS SUB nfet_05v0 L=0.6U W=0.82U AS=0.2344P AD=0.3608P PS=1.56U
+ PD=2.52U
.ENDS gf180mcu_fd_sc_mcu7t5v0__buf_1

.SUBCKT gf180mcu_fd_sc_mcu7t5v0__and4_1 VDD A1 A2 A3 A4 VSS Z \$12 \$13 SUB
M$1 \$7 A1 VDD \$12 pfet_05v0 L=0.5U W=0.6U AS=0.264P AD=0.156P PS=2.08U
+ PD=1.12U
M$2 VDD A2 \$7 \$12 pfet_05v0 L=0.5U W=0.6U AS=0.156P AD=0.156P PS=1.12U
+ PD=1.12U
M$3 \$7 A3 VDD \$12 pfet_05v0 L=0.5U W=0.6U AS=0.156P AD=0.156P PS=1.12U
+ PD=1.12U
M$4 \$7 A4 VDD \$12 pfet_05v0 L=0.5U W=0.6U AS=0.395P AD=0.156P PS=2.02U
+ PD=1.12U
M$5 Z \$7 VDD \$12 pfet_05v0 L=0.5U W=1.22U AS=0.395P AD=0.5368P PS=2.02U
+ PD=3.32U
M$6 \$11 A1 \$7 SUB nfet_05v0 L=0.6U W=0.42U AS=0.1848P AD=0.0672P PS=1.72U
+ PD=0.74U
M$7 \$10 A2 \$11 SUB nfet_05v0 L=0.6U W=0.42U AS=0.0672P AD=0.0882P PS=0.74U
+ PD=0.84U
M$8 \$9 A3 \$10 SUB nfet_05v0 L=0.6U W=0.42U AS=0.0882P AD=0.0882P PS=0.84U
+ PD=0.84U
M$9 \$9 A4 VSS SUB nfet_05v0 L=0.6U W=0.42U AS=0.226P AD=0.0882P PS=1.515U
+ PD=0.84U
M$10 Z \$7 VSS SUB nfet_05v0 L=0.6U W=0.815U AS=0.226P AD=0.3586P PS=1.515U
+ PD=2.51U
.ENDS gf180mcu_fd_sc_mcu7t5v0__and4_1

.SUBCKT gf180mcu_fd_sc_mcu7t5v0__nand2_1 VSS VDD A2 A1 ZN \$7 \$8 SUB
M$1 ZN A2 VDD \$7 pfet_05v0 L=0.5U W=1.13U AS=0.4972P AD=0.2938P PS=3.14U
+ PD=1.65U
M$2 VDD A1 ZN \$7 pfet_05v0 L=0.5U W=1.13U AS=0.2938P AD=0.4972P PS=1.65U
+ PD=3.14U
M$3 \$6 A2 VSS SUB nfet_05v0 L=0.6U W=0.82U AS=0.3608P AD=0.1312P PS=2.52U
+ PD=1.14U
M$4 ZN A1 \$6 SUB nfet_05v0 L=0.6U W=0.82U AS=0.1312P AD=0.3608P PS=1.14U
+ PD=2.52U
.ENDS gf180mcu_fd_sc_mcu7t5v0__nand2_1

.SUBCKT gf180mcu_fd_sc_mcu7t5v0__fillcap_16 VSS \$10 VDD \$12 SUB
M$1 VDD \$5 \$9 \$12 pfet_05v0 L=1U W=1.22U AS=0.5368P AD=0.5368P PS=3.32U
+ PD=3.32U
M$2 VDD \$4 \$8 \$12 pfet_05v0 L=1U W=1.22U AS=0.5368P AD=0.5368P PS=3.32U
+ PD=3.32U
M$3 VDD \$3 \$7 \$12 pfet_05v0 L=1U W=1.22U AS=0.5368P AD=0.5368P PS=3.32U
+ PD=3.32U
M$4 VDD \$2 \$6 \$12 pfet_05v0 L=1U W=1.22U AS=0.5368P AD=0.5368P PS=3.32U
+ PD=3.32U
M$5 \$5 \$9 VSS SUB nfet_05v0 L=1U W=0.82U AS=0.3608P AD=0.3608P PS=2.52U
+ PD=2.52U
M$6 \$4 \$8 VSS SUB nfet_05v0 L=1U W=0.82U AS=0.3608P AD=0.3608P PS=2.52U
+ PD=2.52U
M$7 \$3 \$7 VSS SUB nfet_05v0 L=1U W=0.82U AS=0.3608P AD=0.3608P PS=2.52U
+ PD=2.52U
M$8 \$2 \$6 VSS SUB nfet_05v0 L=1U W=0.82U AS=0.3608P AD=0.3608P PS=2.52U
+ PD=2.52U
.ENDS gf180mcu_fd_sc_mcu7t5v0__fillcap_16

.SUBCKT gf180mcu_fd_sc_mcu7t5v0__nor3_1 VSS VDD A3 ZN A2 A1 \$9 \$10 SUB
M$1 \$8 A3 VDD \$9 pfet_05v0 L=0.5U W=1.22U AS=0.5368P AD=0.3172P PS=3.32U
+ PD=1.74U
M$2 \$7 A2 \$8 \$9 pfet_05v0 L=0.5U W=1.22U AS=0.3172P AD=0.3782P PS=1.74U
+ PD=1.84U
M$3 ZN A1 \$7 \$9 pfet_05v0 L=0.5U W=1.22U AS=0.3782P AD=0.5368P PS=1.84U
+ PD=3.32U
M$4 ZN A3 VSS SUB nfet_05v0 L=0.6U W=0.465U AS=0.2046P AD=0.1209P PS=1.81U
+ PD=0.985U
M$5 VSS A2 ZN SUB nfet_05v0 L=0.6U W=0.465U AS=0.1209P AD=0.1209P PS=0.985U
+ PD=0.985U
M$6 ZN A1 VSS SUB nfet_05v0 L=0.6U W=0.465U AS=0.1209P AD=0.2046P PS=0.985U
+ PD=1.81U
.ENDS gf180mcu_fd_sc_mcu7t5v0__nor3_1

.SUBCKT gf180mcu_fd_sc_mcu7t5v0__fillcap_64 VSS \$34 VDD \$36 SUB
M$1 VDD \$6 \$22 \$36 pfet_05v0 L=1U W=1.22U AS=0.5368P AD=0.5368P PS=3.32U
+ PD=3.32U
M$2 VDD \$15 \$31 \$36 pfet_05v0 L=1U W=1.22U AS=0.5368P AD=0.5368P PS=3.32U
+ PD=3.32U
M$3 VDD \$5 \$21 \$36 pfet_05v0 L=1U W=1.22U AS=0.5368P AD=0.5368P PS=3.32U
+ PD=3.32U
M$4 VDD \$7 \$23 \$36 pfet_05v0 L=1U W=1.22U AS=0.5368P AD=0.5368P PS=3.32U
+ PD=3.32U
M$5 VDD \$8 \$24 \$36 pfet_05v0 L=1U W=1.22U AS=0.5368P AD=0.5368P PS=3.32U
+ PD=3.32U
M$6 VDD \$2 \$18 \$36 pfet_05v0 L=1U W=1.22U AS=0.5368P AD=0.5368P PS=3.32U
+ PD=3.32U
M$7 VDD \$4 \$20 \$36 pfet_05v0 L=1U W=1.22U AS=0.5368P AD=0.5368P PS=3.32U
+ PD=3.32U
M$8 VDD \$14 \$30 \$36 pfet_05v0 L=1U W=1.22U AS=0.5368P AD=0.5368P PS=3.32U
+ PD=3.32U
M$9 VDD \$3 \$19 \$36 pfet_05v0 L=1U W=1.22U AS=0.5368P AD=0.5368P PS=3.32U
+ PD=3.32U
M$10 VDD \$9 \$25 \$36 pfet_05v0 L=1U W=1.22U AS=0.5368P AD=0.5368P PS=3.32U
+ PD=3.32U
M$11 VDD \$10 \$26 \$36 pfet_05v0 L=1U W=1.22U AS=0.5368P AD=0.5368P PS=3.32U
+ PD=3.32U
M$12 VDD \$11 \$27 \$36 pfet_05v0 L=1U W=1.22U AS=0.5368P AD=0.5368P PS=3.32U
+ PD=3.32U
M$13 VDD \$13 \$29 \$36 pfet_05v0 L=1U W=1.22U AS=0.5368P AD=0.5368P PS=3.32U
+ PD=3.32U
M$14 VDD \$16 \$32 \$36 pfet_05v0 L=1U W=1.22U AS=0.5368P AD=0.5368P PS=3.32U
+ PD=3.32U
M$15 VDD \$17 \$33 \$36 pfet_05v0 L=1U W=1.22U AS=0.5368P AD=0.5368P PS=3.32U
+ PD=3.32U
M$16 VDD \$12 \$28 \$36 pfet_05v0 L=1U W=1.22U AS=0.5368P AD=0.5368P PS=3.32U
+ PD=3.32U
M$17 \$17 \$33 VSS SUB nfet_05v0 L=1U W=0.82U AS=0.3608P AD=0.3608P PS=2.52U
+ PD=2.52U
M$18 \$3 \$19 VSS SUB nfet_05v0 L=1U W=0.82U AS=0.3608P AD=0.3608P PS=2.52U
+ PD=2.52U
M$19 \$7 \$23 VSS SUB nfet_05v0 L=1U W=0.82U AS=0.3608P AD=0.3608P PS=2.52U
+ PD=2.52U
M$20 \$6 \$22 VSS SUB nfet_05v0 L=1U W=0.82U AS=0.3608P AD=0.3608P PS=2.52U
+ PD=2.52U
M$21 \$12 \$28 VSS SUB nfet_05v0 L=1U W=0.82U AS=0.3608P AD=0.3608P PS=2.52U
+ PD=2.52U
M$22 \$5 \$21 VSS SUB nfet_05v0 L=1U W=0.82U AS=0.3608P AD=0.3608P PS=2.52U
+ PD=2.52U
M$23 \$4 \$20 VSS SUB nfet_05v0 L=1U W=0.82U AS=0.3608P AD=0.3608P PS=2.52U
+ PD=2.52U
M$24 \$16 \$32 VSS SUB nfet_05v0 L=1U W=0.82U AS=0.3608P AD=0.3608P PS=2.52U
+ PD=2.52U
M$25 \$14 \$30 VSS SUB nfet_05v0 L=1U W=0.82U AS=0.3608P AD=0.3608P PS=2.52U
+ PD=2.52U
M$26 \$2 \$18 VSS SUB nfet_05v0 L=1U W=0.82U AS=0.3608P AD=0.3608P PS=2.52U
+ PD=2.52U
M$27 \$9 \$25 VSS SUB nfet_05v0 L=1U W=0.82U AS=0.3608P AD=0.3608P PS=2.52U
+ PD=2.52U
M$28 \$8 \$24 VSS SUB nfet_05v0 L=1U W=0.82U AS=0.3608P AD=0.3608P PS=2.52U
+ PD=2.52U
M$29 \$10 \$26 VSS SUB nfet_05v0 L=1U W=0.82U AS=0.3608P AD=0.3608P PS=2.52U
+ PD=2.52U
M$30 \$13 \$29 VSS SUB nfet_05v0 L=1U W=0.82U AS=0.3608P AD=0.3608P PS=2.52U
+ PD=2.52U
M$31 \$11 \$27 VSS SUB nfet_05v0 L=1U W=0.82U AS=0.3608P AD=0.3608P PS=2.52U
+ PD=2.52U
M$32 \$15 \$31 VSS SUB nfet_05v0 L=1U W=0.82U AS=0.3608P AD=0.3608P PS=2.52U
+ PD=2.52U
.ENDS gf180mcu_fd_sc_mcu7t5v0__fillcap_64

.SUBCKT gf180mcu_fd_sc_mcu7t5v0__fillcap_32 VSS \$18 VDD \$20 SUB
M$1 VDD \$9 \$17 \$20 pfet_05v0 L=1U W=1.22U AS=0.5368P AD=0.5368P PS=3.32U
+ PD=3.32U
M$2 VDD \$6 \$14 \$20 pfet_05v0 L=1U W=1.22U AS=0.5368P AD=0.5368P PS=3.32U
+ PD=3.32U
M$3 VDD \$3 \$11 \$20 pfet_05v0 L=1U W=1.22U AS=0.5368P AD=0.5368P PS=3.32U
+ PD=3.32U
M$4 VDD \$7 \$15 \$20 pfet_05v0 L=1U W=1.22U AS=0.5368P AD=0.5368P PS=3.32U
+ PD=3.32U
M$5 VDD \$4 \$12 \$20 pfet_05v0 L=1U W=1.22U AS=0.5368P AD=0.5368P PS=3.32U
+ PD=3.32U
M$6 VDD \$8 \$16 \$20 pfet_05v0 L=1U W=1.22U AS=0.5368P AD=0.5368P PS=3.32U
+ PD=3.32U
M$7 VDD \$2 \$10 \$20 pfet_05v0 L=1U W=1.22U AS=0.5368P AD=0.5368P PS=3.32U
+ PD=3.32U
M$8 VDD \$5 \$13 \$20 pfet_05v0 L=1U W=1.22U AS=0.5368P AD=0.5368P PS=3.32U
+ PD=3.32U
M$9 \$9 \$17 VSS SUB nfet_05v0 L=1U W=0.82U AS=0.3608P AD=0.3608P PS=2.52U
+ PD=2.52U
M$10 \$8 \$16 VSS SUB nfet_05v0 L=1U W=0.82U AS=0.3608P AD=0.3608P PS=2.52U
+ PD=2.52U
M$11 \$2 \$10 VSS SUB nfet_05v0 L=1U W=0.82U AS=0.3608P AD=0.3608P PS=2.52U
+ PD=2.52U
M$12 \$4 \$12 VSS SUB nfet_05v0 L=1U W=0.82U AS=0.3608P AD=0.3608P PS=2.52U
+ PD=2.52U
M$13 \$5 \$13 VSS SUB nfet_05v0 L=1U W=0.82U AS=0.3608P AD=0.3608P PS=2.52U
+ PD=2.52U
M$14 \$6 \$14 VSS SUB nfet_05v0 L=1U W=0.82U AS=0.3608P AD=0.3608P PS=2.52U
+ PD=2.52U
M$15 \$7 \$15 VSS SUB nfet_05v0 L=1U W=0.82U AS=0.3608P AD=0.3608P PS=2.52U
+ PD=2.52U
M$16 \$3 \$11 VSS SUB nfet_05v0 L=1U W=0.82U AS=0.3608P AD=0.3608P PS=2.52U
+ PD=2.52U
.ENDS gf180mcu_fd_sc_mcu7t5v0__fillcap_32

.SUBCKT gf180mcu_fd_sc_mcu7t5v0__fillcap_8 VSS VDD \$7 \$8 SUB
M$1 VDD \$6 \$5 \$7 pfet_05v0 L=1U W=1.22U AS=0.5368P AD=0.5368P PS=3.32U
+ PD=3.32U
M$2 VDD \$3 \$2 \$7 pfet_05v0 L=1U W=1.22U AS=0.5368P AD=0.5368P PS=3.32U
+ PD=3.32U
M$3 \$6 \$5 VSS SUB nfet_05v0 L=1U W=0.82U AS=0.3608P AD=0.3608P PS=2.52U
+ PD=2.52U
M$4 \$3 \$2 VSS SUB nfet_05v0 L=1U W=0.82U AS=0.3608P AD=0.3608P PS=2.52U
+ PD=2.52U
.ENDS gf180mcu_fd_sc_mcu7t5v0__fillcap_8

.SUBCKT gf180mcu_fd_sc_mcu7t5v0__nand3_1 VSS VDD A3 ZN A2 A1 \$9 \$10 SUB
M$1 ZN A3 VDD \$9 pfet_05v0 L=0.5U W=0.985U AS=0.4334P AD=0.2561P PS=2.85U
+ PD=1.505U
M$2 VDD A2 ZN \$9 pfet_05v0 L=0.5U W=0.985U AS=0.2561P AD=0.2561P PS=1.505U
+ PD=1.505U
M$3 ZN A1 VDD \$9 pfet_05v0 L=0.5U W=0.985U AS=0.2561P AD=0.4334P PS=1.505U
+ PD=2.85U
M$4 \$8 A3 VSS SUB nfet_05v0 L=0.6U W=0.82U AS=0.3608P AD=0.1312P PS=2.52U
+ PD=1.14U
M$5 \$7 A2 \$8 SUB nfet_05v0 L=0.6U W=0.82U AS=0.1312P AD=0.1722P PS=1.14U
+ PD=1.24U
M$6 ZN A1 \$7 SUB nfet_05v0 L=0.6U W=0.82U AS=0.1722P AD=0.3608P PS=1.24U
+ PD=2.52U
.ENDS gf180mcu_fd_sc_mcu7t5v0__nand3_1

.SUBCKT gf180mcu_fd_sc_mcu7t5v0__nand4_1 VSS VDD A4 ZN A3 A2 A1 \$11 \$12 SUB
M$1 ZN A4 VDD \$11 pfet_05v0 L=0.5U W=0.845U AS=0.3718P AD=0.2197P PS=2.57U
+ PD=1.365U
M$2 VDD A3 ZN \$11 pfet_05v0 L=0.5U W=0.845U AS=0.2197P AD=0.2197P PS=1.365U
+ PD=1.365U
M$3 ZN A2 VDD \$11 pfet_05v0 L=0.5U W=0.845U AS=0.2197P AD=0.2197P PS=1.365U
+ PD=1.365U
M$4 VDD A1 ZN \$11 pfet_05v0 L=0.5U W=0.845U AS=0.2197P AD=0.3718P PS=1.365U
+ PD=2.57U
M$5 \$10 A4 VSS SUB nfet_05v0 L=0.6U W=0.82U AS=0.3608P AD=0.1517P PS=2.52U
+ PD=1.19U
M$6 \$9 A3 \$10 SUB nfet_05v0 L=0.6U W=0.82U AS=0.1517P AD=0.1722P PS=1.19U
+ PD=1.24U
M$7 \$8 A2 \$9 SUB nfet_05v0 L=0.6U W=0.82U AS=0.1722P AD=0.1517P PS=1.24U
+ PD=1.19U
M$8 ZN A1 \$8 SUB nfet_05v0 L=0.6U W=0.82U AS=0.1517P AD=0.3608P PS=1.19U
+ PD=2.52U
.ENDS gf180mcu_fd_sc_mcu7t5v0__nand4_1

.SUBCKT gf180mcu_fd_sc_mcu7t5v0__clkinv_1 VSS VDD I ZN \$5 \$6 SUB
M$1 ZN I VDD \$5 pfet_05v0 L=0.5U W=1.22U AS=0.5368P AD=0.5368P PS=3.32U
+ PD=3.32U
M$2 ZN I VSS SUB nfet_05v0 L=0.6U W=0.48U AS=0.2112P AD=0.2112P PS=1.84U
+ PD=1.84U
.ENDS gf180mcu_fd_sc_mcu7t5v0__clkinv_1

.SUBCKT gf180mcu_fd_sc_mcu7t5v0__nor2_1 VSS VDD A2 A1 ZN \$7 \$8 SUB
M$1 \$6 A2 VDD \$7 pfet_05v0 L=0.5U W=1.22U AS=0.5368P AD=0.4087P PS=3.32U
+ PD=1.89U
M$2 ZN A1 \$6 \$7 pfet_05v0 L=0.5U W=1.22U AS=0.4087P AD=0.5368P PS=1.89U
+ PD=3.32U
M$3 ZN A2 VSS SUB nfet_05v0 L=0.6U W=0.565U AS=0.2486P AD=0.1469P PS=2.01U
+ PD=1.085U
M$4 VSS A1 ZN SUB nfet_05v0 L=0.6U W=0.565U AS=0.1469P AD=0.2486P PS=1.085U
+ PD=2.01U
.ENDS gf180mcu_fd_sc_mcu7t5v0__nor2_1

.SUBCKT gf180mcu_fd_sc_mcu7t5v0__nor4_1 VSS VDD A4 ZN A3 A2 A1 \$11 \$12 SUB
M$1 \$10 A4 VDD \$11 pfet_05v0 L=0.5U W=1.22U AS=0.5368P AD=0.3172P PS=3.32U
+ PD=1.74U
M$2 \$9 A3 \$10 \$11 pfet_05v0 L=0.5U W=1.22U AS=0.3172P AD=0.3782P PS=1.74U
+ PD=1.84U
M$3 \$8 A2 \$9 \$11 pfet_05v0 L=0.5U W=1.22U AS=0.3782P AD=0.3782P PS=1.84U
+ PD=1.84U
M$4 ZN A1 \$8 \$11 pfet_05v0 L=0.5U W=1.22U AS=0.3782P AD=0.5368P PS=1.84U
+ PD=3.32U
M$5 ZN A4 VSS SUB nfet_05v0 L=0.6U W=0.36U AS=0.1584P AD=0.0936P PS=1.6U
+ PD=0.88U
M$6 VSS A3 ZN SUB nfet_05v0 L=0.6U W=0.36U AS=0.0936P AD=0.0936P PS=0.88U
+ PD=0.88U
M$7 ZN A2 VSS SUB nfet_05v0 L=0.6U W=0.36U AS=0.0936P AD=0.0936P PS=0.88U
+ PD=0.88U
M$8 VSS A1 ZN SUB nfet_05v0 L=0.6U W=0.36U AS=0.0936P AD=0.1584P PS=0.88U
+ PD=1.6U
.ENDS gf180mcu_fd_sc_mcu7t5v0__nor4_1

.SUBCKT gf180mcu_fd_sc_mcu7t5v0__fill_2 VDD VSS \$3 \$4
.ENDS gf180mcu_fd_sc_mcu7t5v0__fill_2

.SUBCKT gf180mcu_fd_sc_mcu7t5v0__fill_1 VDD VSS \$3 \$4
.ENDS gf180mcu_fd_sc_mcu7t5v0__fill_1

.SUBCKT gf180mcu_fd_sc_mcu7t5v0__filltie VDD VSS
.ENDS gf180mcu_fd_sc_mcu7t5v0__filltie

.SUBCKT gf180mcu_fd_sc_mcu7t5v0__fillcap_4 VSS VDD \$5 \$6 SUB
M$1 VDD \$3 \$2 \$5 pfet_05v0 L=1U W=1.22U AS=0.5368P AD=0.5368P PS=3.32U
+ PD=3.32U
M$2 \$3 \$2 VSS SUB nfet_05v0 L=1U W=0.82U AS=0.3608P AD=0.3608P PS=2.52U
+ PD=2.52U
.ENDS gf180mcu_fd_sc_mcu7t5v0__fillcap_4

.SUBCKT gf180mcu_fd_sc_mcu7t5v0__endcap VDD VSS
.ENDS gf180mcu_fd_sc_mcu7t5v0__endcap

.SUBCKT gf180mcu_fd_sc_mcu7t5v0__dlyb_1 I VDD VSS Z \$12 \$13 SUB
M$1 \$9 \$5 \$6 \$12 pfet_05v0 L=0.5U W=0.36U AS=0.3456P AD=0.0612P PS=2.64U
+ PD=0.7U
M$2 \$9 \$5 VDD \$12 pfet_05v0 L=0.5U W=0.36U AS=0.379P AD=0.0612P PS=2.37U
+ PD=0.7U
M$3 Z \$6 VDD \$12 pfet_05v0 L=0.5U W=1.22U AS=0.379P AD=0.5368P PS=2.37U
+ PD=3.32U
M$4 VDD I \$1 \$12 pfet_05v0 L=0.5U W=0.36U AS=0.3852P AD=0.1116P PS=2.86U
+ PD=0.98U
M$5 \$8 \$1 VDD \$12 pfet_05v0 L=0.5U W=0.36U AS=0.1116P AD=0.0612P PS=0.98U
+ PD=0.7U
M$6 \$8 \$1 \$5 \$12 pfet_05v0 L=0.5U W=0.36U AS=0.3852P AD=0.0612P PS=2.86U
+ PD=0.7U
M$7 \$11 \$5 \$6 SUB nfet_05v0 L=0.6U W=0.365U AS=0.3705P AD=0.0438P PS=2.77U
+ PD=0.605U
M$8 VSS \$5 \$11 SUB nfet_05v0 L=0.6U W=0.365U AS=0.0438P AD=0.282625P
+ PS=0.605U PD=1.87U
M$9 Z \$6 VSS SUB nfet_05v0 L=0.6U W=0.82U AS=0.282625P AD=0.3608P PS=1.87U
+ PD=2.52U
M$10 VSS I \$1 SUB nfet_05v0 L=0.6U W=0.36U AS=0.333P AD=0.0936P PS=2.57U
+ PD=0.88U
M$11 \$10 \$1 VSS SUB nfet_05v0 L=0.6U W=0.36U AS=0.0936P AD=0.0432P PS=0.88U
+ PD=0.6U
M$12 \$5 \$1 \$10 SUB nfet_05v0 L=0.6U W=0.36U AS=0.0432P AD=0.369P PS=0.6U
+ PD=2.77U
.ENDS gf180mcu_fd_sc_mcu7t5v0__dlyb_1
