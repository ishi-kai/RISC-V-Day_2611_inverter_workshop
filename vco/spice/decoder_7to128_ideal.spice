* Ideal (behavioural) decoder_7to128_xs, written by gen_tb_vco.py
.subckt decoder_7to128_xs VDD VSS I6 I5 I4 I3 I2 I1 I0
+ O127 O126 O125 O124 O123 O122 O121 O120 O119 O118 O117 O116 O115 O114 O113 O112 O111 O110 O109 O108 O107 O106 O105 O104 O103 O102 O101 O100 O99 O98 O97 O96 O95 O94 O93 O92 O91 O90 O89 O88 O87 O86 O85 O84 O83 O82 O81 O80 O79 O78 O77 O76 O75 O74 O73 O72 O71 O70 O69 O68 O67 O66 O65 O64 O63 O62 O61 O60 O59 O58 O57 O56 O55 O54 O53 O52 O51 O50 O49 O48 O47 O46 O45 O44 O43 O42 O41 O40 O39 O38 O37 O36 O35 O34 O33 O32 O31 O30 O29 O28 O27 O26 O25 O24 O23 O22 O21 O20 O19 O18 O17 O16 O15 O14 O13 O12 O11 O10 O9 O8 O7 O6 O5 O4 O3 O2 O1 O0
Bcode code VSS V=1*u(v(I0,VSS)-v(VDD,VSS)/2)+2*u(v(I1,VSS)-v(VDD,VSS)/2)+4*u(v(I2,VSS)-v(VDD,VSS)/2)+8*u(v(I3,VSS)-v(VDD,VSS)/2)+16*u(v(I4,VSS)-v(VDD,VSS)/2)+32*u(v(I5,VSS)-v(VDD,VSS)/2)+64*u(v(I6,VSS)-v(VDD,VSS)/2)
B0 o0i VSS V=v(VDD,VSS)*u(0.5-abs(v(code,VSS)-0))
R0 o0i O0 1k
C0 O0 VSS 20f
B1 o1i VSS V=v(VDD,VSS)*u(0.5-abs(v(code,VSS)-1))
R1 o1i O1 1k
C1 O1 VSS 20f
B2 o2i VSS V=v(VDD,VSS)*u(0.5-abs(v(code,VSS)-2))
R2 o2i O2 1k
C2 O2 VSS 20f
B3 o3i VSS V=v(VDD,VSS)*u(0.5-abs(v(code,VSS)-3))
R3 o3i O3 1k
C3 O3 VSS 20f
B4 o4i VSS V=v(VDD,VSS)*u(0.5-abs(v(code,VSS)-4))
R4 o4i O4 1k
C4 O4 VSS 20f
B5 o5i VSS V=v(VDD,VSS)*u(0.5-abs(v(code,VSS)-5))
R5 o5i O5 1k
C5 O5 VSS 20f
B6 o6i VSS V=v(VDD,VSS)*u(0.5-abs(v(code,VSS)-6))
R6 o6i O6 1k
C6 O6 VSS 20f
B7 o7i VSS V=v(VDD,VSS)*u(0.5-abs(v(code,VSS)-7))
R7 o7i O7 1k
C7 O7 VSS 20f
B8 o8i VSS V=v(VDD,VSS)*u(0.5-abs(v(code,VSS)-8))
R8 o8i O8 1k
C8 O8 VSS 20f
B9 o9i VSS V=v(VDD,VSS)*u(0.5-abs(v(code,VSS)-9))
R9 o9i O9 1k
C9 O9 VSS 20f
B10 o10i VSS V=v(VDD,VSS)*u(0.5-abs(v(code,VSS)-10))
R10 o10i O10 1k
C10 O10 VSS 20f
B11 o11i VSS V=v(VDD,VSS)*u(0.5-abs(v(code,VSS)-11))
R11 o11i O11 1k
C11 O11 VSS 20f
B12 o12i VSS V=v(VDD,VSS)*u(0.5-abs(v(code,VSS)-12))
R12 o12i O12 1k
C12 O12 VSS 20f
B13 o13i VSS V=v(VDD,VSS)*u(0.5-abs(v(code,VSS)-13))
R13 o13i O13 1k
C13 O13 VSS 20f
B14 o14i VSS V=v(VDD,VSS)*u(0.5-abs(v(code,VSS)-14))
R14 o14i O14 1k
C14 O14 VSS 20f
B15 o15i VSS V=v(VDD,VSS)*u(0.5-abs(v(code,VSS)-15))
R15 o15i O15 1k
C15 O15 VSS 20f
B16 o16i VSS V=v(VDD,VSS)*u(0.5-abs(v(code,VSS)-16))
R16 o16i O16 1k
C16 O16 VSS 20f
B17 o17i VSS V=v(VDD,VSS)*u(0.5-abs(v(code,VSS)-17))
R17 o17i O17 1k
C17 O17 VSS 20f
B18 o18i VSS V=v(VDD,VSS)*u(0.5-abs(v(code,VSS)-18))
R18 o18i O18 1k
C18 O18 VSS 20f
B19 o19i VSS V=v(VDD,VSS)*u(0.5-abs(v(code,VSS)-19))
R19 o19i O19 1k
C19 O19 VSS 20f
B20 o20i VSS V=v(VDD,VSS)*u(0.5-abs(v(code,VSS)-20))
R20 o20i O20 1k
C20 O20 VSS 20f
B21 o21i VSS V=v(VDD,VSS)*u(0.5-abs(v(code,VSS)-21))
R21 o21i O21 1k
C21 O21 VSS 20f
B22 o22i VSS V=v(VDD,VSS)*u(0.5-abs(v(code,VSS)-22))
R22 o22i O22 1k
C22 O22 VSS 20f
B23 o23i VSS V=v(VDD,VSS)*u(0.5-abs(v(code,VSS)-23))
R23 o23i O23 1k
C23 O23 VSS 20f
B24 o24i VSS V=v(VDD,VSS)*u(0.5-abs(v(code,VSS)-24))
R24 o24i O24 1k
C24 O24 VSS 20f
B25 o25i VSS V=v(VDD,VSS)*u(0.5-abs(v(code,VSS)-25))
R25 o25i O25 1k
C25 O25 VSS 20f
B26 o26i VSS V=v(VDD,VSS)*u(0.5-abs(v(code,VSS)-26))
R26 o26i O26 1k
C26 O26 VSS 20f
B27 o27i VSS V=v(VDD,VSS)*u(0.5-abs(v(code,VSS)-27))
R27 o27i O27 1k
C27 O27 VSS 20f
B28 o28i VSS V=v(VDD,VSS)*u(0.5-abs(v(code,VSS)-28))
R28 o28i O28 1k
C28 O28 VSS 20f
B29 o29i VSS V=v(VDD,VSS)*u(0.5-abs(v(code,VSS)-29))
R29 o29i O29 1k
C29 O29 VSS 20f
B30 o30i VSS V=v(VDD,VSS)*u(0.5-abs(v(code,VSS)-30))
R30 o30i O30 1k
C30 O30 VSS 20f
B31 o31i VSS V=v(VDD,VSS)*u(0.5-abs(v(code,VSS)-31))
R31 o31i O31 1k
C31 O31 VSS 20f
B32 o32i VSS V=v(VDD,VSS)*u(0.5-abs(v(code,VSS)-32))
R32 o32i O32 1k
C32 O32 VSS 20f
B33 o33i VSS V=v(VDD,VSS)*u(0.5-abs(v(code,VSS)-33))
R33 o33i O33 1k
C33 O33 VSS 20f
B34 o34i VSS V=v(VDD,VSS)*u(0.5-abs(v(code,VSS)-34))
R34 o34i O34 1k
C34 O34 VSS 20f
B35 o35i VSS V=v(VDD,VSS)*u(0.5-abs(v(code,VSS)-35))
R35 o35i O35 1k
C35 O35 VSS 20f
B36 o36i VSS V=v(VDD,VSS)*u(0.5-abs(v(code,VSS)-36))
R36 o36i O36 1k
C36 O36 VSS 20f
B37 o37i VSS V=v(VDD,VSS)*u(0.5-abs(v(code,VSS)-37))
R37 o37i O37 1k
C37 O37 VSS 20f
B38 o38i VSS V=v(VDD,VSS)*u(0.5-abs(v(code,VSS)-38))
R38 o38i O38 1k
C38 O38 VSS 20f
B39 o39i VSS V=v(VDD,VSS)*u(0.5-abs(v(code,VSS)-39))
R39 o39i O39 1k
C39 O39 VSS 20f
B40 o40i VSS V=v(VDD,VSS)*u(0.5-abs(v(code,VSS)-40))
R40 o40i O40 1k
C40 O40 VSS 20f
B41 o41i VSS V=v(VDD,VSS)*u(0.5-abs(v(code,VSS)-41))
R41 o41i O41 1k
C41 O41 VSS 20f
B42 o42i VSS V=v(VDD,VSS)*u(0.5-abs(v(code,VSS)-42))
R42 o42i O42 1k
C42 O42 VSS 20f
B43 o43i VSS V=v(VDD,VSS)*u(0.5-abs(v(code,VSS)-43))
R43 o43i O43 1k
C43 O43 VSS 20f
B44 o44i VSS V=v(VDD,VSS)*u(0.5-abs(v(code,VSS)-44))
R44 o44i O44 1k
C44 O44 VSS 20f
B45 o45i VSS V=v(VDD,VSS)*u(0.5-abs(v(code,VSS)-45))
R45 o45i O45 1k
C45 O45 VSS 20f
B46 o46i VSS V=v(VDD,VSS)*u(0.5-abs(v(code,VSS)-46))
R46 o46i O46 1k
C46 O46 VSS 20f
B47 o47i VSS V=v(VDD,VSS)*u(0.5-abs(v(code,VSS)-47))
R47 o47i O47 1k
C47 O47 VSS 20f
B48 o48i VSS V=v(VDD,VSS)*u(0.5-abs(v(code,VSS)-48))
R48 o48i O48 1k
C48 O48 VSS 20f
B49 o49i VSS V=v(VDD,VSS)*u(0.5-abs(v(code,VSS)-49))
R49 o49i O49 1k
C49 O49 VSS 20f
B50 o50i VSS V=v(VDD,VSS)*u(0.5-abs(v(code,VSS)-50))
R50 o50i O50 1k
C50 O50 VSS 20f
B51 o51i VSS V=v(VDD,VSS)*u(0.5-abs(v(code,VSS)-51))
R51 o51i O51 1k
C51 O51 VSS 20f
B52 o52i VSS V=v(VDD,VSS)*u(0.5-abs(v(code,VSS)-52))
R52 o52i O52 1k
C52 O52 VSS 20f
B53 o53i VSS V=v(VDD,VSS)*u(0.5-abs(v(code,VSS)-53))
R53 o53i O53 1k
C53 O53 VSS 20f
B54 o54i VSS V=v(VDD,VSS)*u(0.5-abs(v(code,VSS)-54))
R54 o54i O54 1k
C54 O54 VSS 20f
B55 o55i VSS V=v(VDD,VSS)*u(0.5-abs(v(code,VSS)-55))
R55 o55i O55 1k
C55 O55 VSS 20f
B56 o56i VSS V=v(VDD,VSS)*u(0.5-abs(v(code,VSS)-56))
R56 o56i O56 1k
C56 O56 VSS 20f
B57 o57i VSS V=v(VDD,VSS)*u(0.5-abs(v(code,VSS)-57))
R57 o57i O57 1k
C57 O57 VSS 20f
B58 o58i VSS V=v(VDD,VSS)*u(0.5-abs(v(code,VSS)-58))
R58 o58i O58 1k
C58 O58 VSS 20f
B59 o59i VSS V=v(VDD,VSS)*u(0.5-abs(v(code,VSS)-59))
R59 o59i O59 1k
C59 O59 VSS 20f
B60 o60i VSS V=v(VDD,VSS)*u(0.5-abs(v(code,VSS)-60))
R60 o60i O60 1k
C60 O60 VSS 20f
B61 o61i VSS V=v(VDD,VSS)*u(0.5-abs(v(code,VSS)-61))
R61 o61i O61 1k
C61 O61 VSS 20f
B62 o62i VSS V=v(VDD,VSS)*u(0.5-abs(v(code,VSS)-62))
R62 o62i O62 1k
C62 O62 VSS 20f
B63 o63i VSS V=v(VDD,VSS)*u(0.5-abs(v(code,VSS)-63))
R63 o63i O63 1k
C63 O63 VSS 20f
B64 o64i VSS V=v(VDD,VSS)*u(0.5-abs(v(code,VSS)-64))
R64 o64i O64 1k
C64 O64 VSS 20f
B65 o65i VSS V=v(VDD,VSS)*u(0.5-abs(v(code,VSS)-65))
R65 o65i O65 1k
C65 O65 VSS 20f
B66 o66i VSS V=v(VDD,VSS)*u(0.5-abs(v(code,VSS)-66))
R66 o66i O66 1k
C66 O66 VSS 20f
B67 o67i VSS V=v(VDD,VSS)*u(0.5-abs(v(code,VSS)-67))
R67 o67i O67 1k
C67 O67 VSS 20f
B68 o68i VSS V=v(VDD,VSS)*u(0.5-abs(v(code,VSS)-68))
R68 o68i O68 1k
C68 O68 VSS 20f
B69 o69i VSS V=v(VDD,VSS)*u(0.5-abs(v(code,VSS)-69))
R69 o69i O69 1k
C69 O69 VSS 20f
B70 o70i VSS V=v(VDD,VSS)*u(0.5-abs(v(code,VSS)-70))
R70 o70i O70 1k
C70 O70 VSS 20f
B71 o71i VSS V=v(VDD,VSS)*u(0.5-abs(v(code,VSS)-71))
R71 o71i O71 1k
C71 O71 VSS 20f
B72 o72i VSS V=v(VDD,VSS)*u(0.5-abs(v(code,VSS)-72))
R72 o72i O72 1k
C72 O72 VSS 20f
B73 o73i VSS V=v(VDD,VSS)*u(0.5-abs(v(code,VSS)-73))
R73 o73i O73 1k
C73 O73 VSS 20f
B74 o74i VSS V=v(VDD,VSS)*u(0.5-abs(v(code,VSS)-74))
R74 o74i O74 1k
C74 O74 VSS 20f
B75 o75i VSS V=v(VDD,VSS)*u(0.5-abs(v(code,VSS)-75))
R75 o75i O75 1k
C75 O75 VSS 20f
B76 o76i VSS V=v(VDD,VSS)*u(0.5-abs(v(code,VSS)-76))
R76 o76i O76 1k
C76 O76 VSS 20f
B77 o77i VSS V=v(VDD,VSS)*u(0.5-abs(v(code,VSS)-77))
R77 o77i O77 1k
C77 O77 VSS 20f
B78 o78i VSS V=v(VDD,VSS)*u(0.5-abs(v(code,VSS)-78))
R78 o78i O78 1k
C78 O78 VSS 20f
B79 o79i VSS V=v(VDD,VSS)*u(0.5-abs(v(code,VSS)-79))
R79 o79i O79 1k
C79 O79 VSS 20f
B80 o80i VSS V=v(VDD,VSS)*u(0.5-abs(v(code,VSS)-80))
R80 o80i O80 1k
C80 O80 VSS 20f
B81 o81i VSS V=v(VDD,VSS)*u(0.5-abs(v(code,VSS)-81))
R81 o81i O81 1k
C81 O81 VSS 20f
B82 o82i VSS V=v(VDD,VSS)*u(0.5-abs(v(code,VSS)-82))
R82 o82i O82 1k
C82 O82 VSS 20f
B83 o83i VSS V=v(VDD,VSS)*u(0.5-abs(v(code,VSS)-83))
R83 o83i O83 1k
C83 O83 VSS 20f
B84 o84i VSS V=v(VDD,VSS)*u(0.5-abs(v(code,VSS)-84))
R84 o84i O84 1k
C84 O84 VSS 20f
B85 o85i VSS V=v(VDD,VSS)*u(0.5-abs(v(code,VSS)-85))
R85 o85i O85 1k
C85 O85 VSS 20f
B86 o86i VSS V=v(VDD,VSS)*u(0.5-abs(v(code,VSS)-86))
R86 o86i O86 1k
C86 O86 VSS 20f
B87 o87i VSS V=v(VDD,VSS)*u(0.5-abs(v(code,VSS)-87))
R87 o87i O87 1k
C87 O87 VSS 20f
B88 o88i VSS V=v(VDD,VSS)*u(0.5-abs(v(code,VSS)-88))
R88 o88i O88 1k
C88 O88 VSS 20f
B89 o89i VSS V=v(VDD,VSS)*u(0.5-abs(v(code,VSS)-89))
R89 o89i O89 1k
C89 O89 VSS 20f
B90 o90i VSS V=v(VDD,VSS)*u(0.5-abs(v(code,VSS)-90))
R90 o90i O90 1k
C90 O90 VSS 20f
B91 o91i VSS V=v(VDD,VSS)*u(0.5-abs(v(code,VSS)-91))
R91 o91i O91 1k
C91 O91 VSS 20f
B92 o92i VSS V=v(VDD,VSS)*u(0.5-abs(v(code,VSS)-92))
R92 o92i O92 1k
C92 O92 VSS 20f
B93 o93i VSS V=v(VDD,VSS)*u(0.5-abs(v(code,VSS)-93))
R93 o93i O93 1k
C93 O93 VSS 20f
B94 o94i VSS V=v(VDD,VSS)*u(0.5-abs(v(code,VSS)-94))
R94 o94i O94 1k
C94 O94 VSS 20f
B95 o95i VSS V=v(VDD,VSS)*u(0.5-abs(v(code,VSS)-95))
R95 o95i O95 1k
C95 O95 VSS 20f
B96 o96i VSS V=v(VDD,VSS)*u(0.5-abs(v(code,VSS)-96))
R96 o96i O96 1k
C96 O96 VSS 20f
B97 o97i VSS V=v(VDD,VSS)*u(0.5-abs(v(code,VSS)-97))
R97 o97i O97 1k
C97 O97 VSS 20f
B98 o98i VSS V=v(VDD,VSS)*u(0.5-abs(v(code,VSS)-98))
R98 o98i O98 1k
C98 O98 VSS 20f
B99 o99i VSS V=v(VDD,VSS)*u(0.5-abs(v(code,VSS)-99))
R99 o99i O99 1k
C99 O99 VSS 20f
B100 o100i VSS V=v(VDD,VSS)*u(0.5-abs(v(code,VSS)-100))
R100 o100i O100 1k
C100 O100 VSS 20f
B101 o101i VSS V=v(VDD,VSS)*u(0.5-abs(v(code,VSS)-101))
R101 o101i O101 1k
C101 O101 VSS 20f
B102 o102i VSS V=v(VDD,VSS)*u(0.5-abs(v(code,VSS)-102))
R102 o102i O102 1k
C102 O102 VSS 20f
B103 o103i VSS V=v(VDD,VSS)*u(0.5-abs(v(code,VSS)-103))
R103 o103i O103 1k
C103 O103 VSS 20f
B104 o104i VSS V=v(VDD,VSS)*u(0.5-abs(v(code,VSS)-104))
R104 o104i O104 1k
C104 O104 VSS 20f
B105 o105i VSS V=v(VDD,VSS)*u(0.5-abs(v(code,VSS)-105))
R105 o105i O105 1k
C105 O105 VSS 20f
B106 o106i VSS V=v(VDD,VSS)*u(0.5-abs(v(code,VSS)-106))
R106 o106i O106 1k
C106 O106 VSS 20f
B107 o107i VSS V=v(VDD,VSS)*u(0.5-abs(v(code,VSS)-107))
R107 o107i O107 1k
C107 O107 VSS 20f
B108 o108i VSS V=v(VDD,VSS)*u(0.5-abs(v(code,VSS)-108))
R108 o108i O108 1k
C108 O108 VSS 20f
B109 o109i VSS V=v(VDD,VSS)*u(0.5-abs(v(code,VSS)-109))
R109 o109i O109 1k
C109 O109 VSS 20f
B110 o110i VSS V=v(VDD,VSS)*u(0.5-abs(v(code,VSS)-110))
R110 o110i O110 1k
C110 O110 VSS 20f
B111 o111i VSS V=v(VDD,VSS)*u(0.5-abs(v(code,VSS)-111))
R111 o111i O111 1k
C111 O111 VSS 20f
B112 o112i VSS V=v(VDD,VSS)*u(0.5-abs(v(code,VSS)-112))
R112 o112i O112 1k
C112 O112 VSS 20f
B113 o113i VSS V=v(VDD,VSS)*u(0.5-abs(v(code,VSS)-113))
R113 o113i O113 1k
C113 O113 VSS 20f
B114 o114i VSS V=v(VDD,VSS)*u(0.5-abs(v(code,VSS)-114))
R114 o114i O114 1k
C114 O114 VSS 20f
B115 o115i VSS V=v(VDD,VSS)*u(0.5-abs(v(code,VSS)-115))
R115 o115i O115 1k
C115 O115 VSS 20f
B116 o116i VSS V=v(VDD,VSS)*u(0.5-abs(v(code,VSS)-116))
R116 o116i O116 1k
C116 O116 VSS 20f
B117 o117i VSS V=v(VDD,VSS)*u(0.5-abs(v(code,VSS)-117))
R117 o117i O117 1k
C117 O117 VSS 20f
B118 o118i VSS V=v(VDD,VSS)*u(0.5-abs(v(code,VSS)-118))
R118 o118i O118 1k
C118 O118 VSS 20f
B119 o119i VSS V=v(VDD,VSS)*u(0.5-abs(v(code,VSS)-119))
R119 o119i O119 1k
C119 O119 VSS 20f
B120 o120i VSS V=v(VDD,VSS)*u(0.5-abs(v(code,VSS)-120))
R120 o120i O120 1k
C120 O120 VSS 20f
B121 o121i VSS V=v(VDD,VSS)*u(0.5-abs(v(code,VSS)-121))
R121 o121i O121 1k
C121 O121 VSS 20f
B122 o122i VSS V=v(VDD,VSS)*u(0.5-abs(v(code,VSS)-122))
R122 o122i O122 1k
C122 O122 VSS 20f
B123 o123i VSS V=v(VDD,VSS)*u(0.5-abs(v(code,VSS)-123))
R123 o123i O123 1k
C123 O123 VSS 20f
B124 o124i VSS V=v(VDD,VSS)*u(0.5-abs(v(code,VSS)-124))
R124 o124i O124 1k
C124 O124 VSS 20f
B125 o125i VSS V=v(VDD,VSS)*u(0.5-abs(v(code,VSS)-125))
R125 o125i O125 1k
C125 O125 VSS 20f
B126 o126i VSS V=v(VDD,VSS)*u(0.5-abs(v(code,VSS)-126))
R126 o126i O126 1k
C126 O126 VSS 20f
B127 o127i VSS V=v(VDD,VSS)*u(0.5-abs(v(code,VSS)-127))
R127 o127i O127 1k
C127 O127 VSS 20f
.ends
