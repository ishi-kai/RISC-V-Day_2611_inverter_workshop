* Extracted by KLayout with GF180MCU LVS runset on : 17/10/2026 13:40

* cell vco_buf_5v0
* pin SUB
.SUBCKT vco_buf_5v0 SUB
* device instance $1 m90 *1 3.14,1.275 nfet_05v0
M$1 SUB \$6 \$9 SUB nfet_05v0 L=0.6U W=1U AS=0.73P AD=0.73P PS=3.46U PD=3.46U
* device instance $2 r0 *1 5.865,1.275 nfet_05v0
M$2 SUB \$9 \$1 SUB nfet_05v0 L=0.6U W=4U AS=1.93P AD=1.93P PS=8.86U PD=8.86U
* device instance $6 r0 *1 6.195,6.835 pfet_05v0
M$6 \$5 \$9 \$1 \$5 pfet_05v0 L=0.5U W=8U AS=3.94P AD=3.94P PS=13.94U PD=13.94U
* device instance $10 m90 *1 3.14,6.835 pfet_05v0
M$10 \$5 \$6 \$9 \$5 pfet_05v0 L=0.5U W=2U AS=1.54P AD=1.54P PS=5.54U PD=5.54U
.ENDS vco_buf_5v0
