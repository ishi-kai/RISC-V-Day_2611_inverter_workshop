** sch_path: /home/noritsuna/vco/vco_only.sch
.subckt vco_only VCTRL VCO_EN IN OUT FOUT INV_IN VDD_DEC VSS INV_OUT VDD_INV
*.PININFO VCTRL:I VCO_EN:I IN:B OUT:B FOUT:O INV_IN:B VDD_DEC:B VSS:B INV_OUT:B VDD_INV:B
X2 VCTRL VBP VBN VDD_INV VSS vco_bias_5v0
X3 R0 R1 VBP VDD_INV VBN VSS cs_inv_5v0
X4 R1 R2 VBP VDD_INV VBN VSS cs_inv_5v0
X5 R2 R3 VBP VDD_INV VBN VSS cs_inv_5v0
X6 R3 R4 VBP VDD_INV VBN VSS cs_inv_5v0
X7 R4 R5 VBP VDD_INV VBN VSS cs_inv_5v0
X8 R5 R6 VBP VDD_INV VBN VSS cs_inv_x4_5v0
MPD R0 VCO_ENB1 VSS VSS nfet_05v0 L=0.60u W=0.42u nf=1
X9 R3 FB VDD_INV VSS vco_buf1_5v0
X10 FB FOUT VDD_INV VSS vco_buf2_5v0
X11 R6 INV_IN VCO_EN VCO_ENB3 VDD_DEC VSS tgate_5v0
X12 IN INV_IN VCO_ENB4 VCO_EN VDD_DEC VSS tgate_5v0
X13 INV_OUT R0 VCO_EN VCO_ENB1 VDD_DEC VSS tgate_5v0
X14 INV_OUT OUT VCO_ENB2 VCO_EN VDD_DEC VSS tgate_5v0
DANT2 VSS VCTRL diode_nw2ps_06v0 A='1.4u * 1.2u ' P='2*1.4u + 2*1.2u '
X15 VCO_EN VCO_ENB3 VDD_DEC VSS inv_ctrl_5v0
X16 VCO_EN VCO_ENB4 VDD_DEC VSS inv_ctrl_5v0
X17 VCO_EN VCO_ENB1 VDD_DEC VSS inv_ctrl_5v0
X18 VCO_EN VCO_ENB2 VDD_DEC VSS inv_ctrl_5v0
DANT3 VSS VCO_EN diode_nw2ps_06v0 A='1.4u * 1.2u ' P='2*1.4u + 2*1.2u '
DANT4 VSS VCO_EN diode_nw2ps_06v0 A='1.4u * 1.2u ' P='2*1.4u + 2*1.2u '
DANT5 VSS VCO_EN diode_nw2ps_06v0 A='1.4u * 1.2u ' P='2*1.4u + 2*1.2u '
DANT6 VSS VCO_EN diode_nw2ps_06v0 A='1.4u * 1.2u ' P='2*1.4u + 2*1.2u '
.ends

* expanding   symbol:  vco_bias_5v0.sym # of pins=5
** sym_path: /home/noritsuna/vco/vco_bias_5v0.sym
** sch_path: /home/noritsuna/vco/vco_bias_5v0.sch
.subckt vco_bias_5v0 VCTRL VBP VBN VDD VSS
*.PININFO VCTRL:I VBP:O VBN:O VDD:B VSS:B
MPB VBP VBP VDD VDD pfet_05v0 L=1u W=16u nf=1
MNI VBP VCTRL VSS VSS nfet_05v0 L=2u W=2u nf=1
MPM VBN VBP VDD VDD pfet_05v0 L=1u W=16u nf=1
MNM VBN VBN VSS VSS nfet_05v0 L=1u W=4u nf=1
.ends

* expanding   symbol:  cs_inv_5v0.sym # of pins=6
** sym_path: /home/noritsuna/vco/cs_inv_5v0.sym
** sch_path: /home/noritsuna/vco/cs_inv_5v0.sch
.subckt cs_inv_5v0 A Y VBP VDD VBN VSS
*.PININFO A:I Y:O VBP:I VDD:B VBN:I VSS:B
MPC NP VBP VDD VDD pfet_05v0 L=1u W=16u nf=1
MP Y A NP VDD pfet_05v0 L=0.50u W=4u nf=1
MN Y A NN VSS nfet_05v0 L=0.60u W=2u nf=1
MNC NN VBN VSS VSS nfet_05v0 L=1u W=4u nf=1
.ends

* expanding   symbol:  cs_inv_x4_5v0.sym # of pins=6
** sym_path: /home/noritsuna/vco/cs_inv_x4_5v0.sym
** sch_path: /home/noritsuna/vco/cs_inv_x4_5v0.sch
.subckt cs_inv_x4_5v0 A Y VBP VDD VBN VSS
*.PININFO A:I Y:O VBP:I VDD:B VBN:I VSS:B
MPC NP VBP VDD VDD pfet_05v0 L=1u W=64u nf=1
MP Y A NP VDD pfet_05v0 L=0.50u W=12u nf=1
MN Y A NN VSS nfet_05v0 L=0.60u W=6u nf=1
MNC NN VBN VSS VSS nfet_05v0 L=1u W=16u nf=1
.ends

* expanding   symbol:  vco_buf1_5v0.sym # of pins=4
** sym_path: /home/noritsuna/vco/vco_buf1_5v0.sym
** sch_path: /home/noritsuna/vco/vco_buf1_5v0.sch
.subckt vco_buf1_5v0 A Y VDD VSS
*.PININFO A:I Y:O VDD:B VSS:B
MP Y A VDD VDD pfet_05v0 L=0.50u W=2u nf=1
MN Y A VSS VSS nfet_05v0 L=0.60u W=1u nf=1
.ends

* expanding   symbol:  vco_buf2_5v0.sym # of pins=4
** sym_path: /home/noritsuna/vco/vco_buf2_5v0.sym
** sch_path: /home/noritsuna/vco/vco_buf2_5v0.sch
.subckt vco_buf2_5v0 A Y VDD VSS
*.PININFO A:I Y:O VDD:B VSS:B
MP Y A VDD VDD pfet_05v0 L=0.50u W=8u nf=1
MN Y A VSS VSS nfet_05v0 L=0.60u W=4u nf=1
.ends

* expanding   symbol:  tgate_5v0.sym # of pins=6
** sym_path: /home/noritsuna/inverter_matrix/tgate_5v0.sym
** sch_path: /home/noritsuna/inverter_matrix/tgate_5v0.sch
.subckt tgate_5v0 A B EN ENB VDD VSS
*.PININFO A:B B:B EN:I ENB:I VDD:B VSS:B
MN A EN B VSS nfet_05v0 L=0.60u W=2u nf=1
MP B ENB A VDD pfet_05v0 L=0.50u W=6u nf=1
.ends

* expanding   symbol:  inv_ctrl_5v0.sym # of pins=4
** sym_path: /home/noritsuna/inverter_matrix/inv_ctrl_5v0.sym
** sch_path: /home/noritsuna/inverter_matrix/inv_ctrl_5v0.sch
.subckt inv_ctrl_5v0 A Y VDD VSS
*.PININFO A:I Y:O VDD:B VSS:B
MP Y A VDD VDD pfet_05v0 L=0.50u W=2u nf=1
MN Y A VSS VSS nfet_05v0 L=0.60u W=1u nf=1
.ends
