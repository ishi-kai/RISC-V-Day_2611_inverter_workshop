* Extracted by KLayout with GF180MCU LVS runset on : 23/10/2026 05:19

* cell vco_only
* pin FOUT
* pin IN
* pin INV_IN
* pin INV_OUT
* pin OUT
* pin VCO_EN
* pin VCTRL
* pin VDD_DEC
* pin VDD_INV
* pin VSS
.SUBCKT vco_only FOUT IN INV_IN INV_OUT OUT VCO_EN VCTRL VDD_DEC VDD_INV VSS
* cell instance $8 r0 *1 0,0
X$8 \$I10 VDD_INV \$I15 VCTRL VSS vco_bias_5v0
* cell instance $10 r0 *1 18.305,0
X$10 VDD_INV \$I30 \$8 \$I10 \$I15 VSS cs_inv_5v0
* cell instance $11 r0 *1 99.025,0
X$11 \$I10 \$10 \$I25 VDD_INV \$I15 VSS cs_inv_x4_5v0
* cell instance $12 r0 *1 85.765,0
X$12 VDD_INV \$I25 \$I29 \$I10 \$I15 VSS cs_inv_5v0
* cell instance $13 r0 *1 72.505,0
X$13 VDD_INV \$I29 \$I28 \$I10 \$I15 VSS cs_inv_5v0
* cell instance $14 r0 *1 44.825,0
X$14 VDD_INV \$I28 \$I27 \$I10 \$I15 VSS cs_inv_5v0
* cell instance $16 r0 *1 31.565,0
X$16 VDD_INV \$I27 \$I30 \$I10 \$I15 VSS cs_inv_5v0
* device instance $1 r90 *1 2.14,0.855 diode_nw2ps_06v0
D$1 VSS VCTRL diode_nw2ps_06v0 A=0.3344P P=2.52U
* device instance $2 m90 *1 61.225,1.275 nfet_05v0
M$2 VSS \$I28 \$I38 VSS nfet_05v0 L=0.6U W=1U AS=0.73P AD=0.73P PS=3.46U
+ PD=3.46U
* device instance $3 m90 *1 61.225,6.835 pfet_05v0
M$3 VDD_INV \$I28 \$I38 VDD_INV pfet_05v0 L=0.5U W=2U AS=1.54P AD=1.54P
+ PS=5.54U PD=5.54U
* device instance $4 r0 *1 63.95,1.275 nfet_05v0
M$4 VSS \$I38 FOUT VSS nfet_05v0 L=0.6U W=4U AS=1.93P AD=1.93P PS=8.86U PD=8.86U
* device instance $8 r0 *1 64.28,6.835 pfet_05v0
M$8 VDD_INV \$I38 FOUT VDD_INV pfet_05v0 L=0.5U W=8U AS=3.94P AD=3.94P
+ PS=13.94U PD=13.94U
* device instance $12 r0 *1 28.985,-13.46 diode_nw2ps_06v0
D$12 VSS VCO_EN diode_nw2ps_06v0 A=1.728P P=12.48U
* device instance $13 r180 *1 31.67,-8.9 pfet_05v0
M$13 VDD_DEC VCO_EN \$I39 VDD_DEC pfet_05v0 L=0.5U W=2U AS=1.54P AD=1.54P
+ PS=5.54U PD=5.54U
* device instance $14 r0 *1 38.725,-7.98 nfet_05v0
M$14 VSS VCO_EN \$I39 VSS nfet_05v0 L=0.6U W=1U AS=0.73P AD=0.73P PS=3.46U
+ PD=3.46U
* device instance $15 r90 *1 38.695,-11.975 nfet_05v0
M$15 INV_OUT \$I39 OUT VSS nfet_05v0 L=0.6U W=2U AS=1.46P AD=1.46P PS=5.46U
+ PD=5.46U
* device instance $16 r90 *1 35.185,-12.005 pfet_05v0
M$16 INV_OUT VCO_EN OUT VDD_DEC pfet_05v0 L=0.5U W=6U AS=3.14P AD=3.14P
+ PS=11.14U PD=11.14U
* device instance $20 r180 *1 111.34,-8.9 pfet_05v0
M$20 VDD_DEC VCO_EN \$I40 VDD_DEC pfet_05v0 L=0.5U W=2U AS=1.54P AD=1.54P
+ PS=5.54U PD=5.54U
* device instance $21 r0 *1 118.395,-7.98 nfet_05v0
M$21 VSS VCO_EN \$I40 VSS nfet_05v0 L=0.6U W=1U AS=0.73P AD=0.73P PS=3.46U
+ PD=3.46U
* device instance $22 r90 *1 118.365,-11.975 nfet_05v0
M$22 IN \$I40 INV_IN VSS nfet_05v0 L=0.6U W=2U AS=1.46P AD=1.46P PS=5.46U
+ PD=5.46U
* device instance $23 r90 *1 114.855,-12.005 pfet_05v0
M$23 IN VCO_EN INV_IN VDD_DEC pfet_05v0 L=0.5U W=6U AS=3.14P AD=3.14P PS=11.14U
+ PD=11.14U
* device instance $27 r180 *1 123.665,-8.9 pfet_05v0
M$27 VDD_DEC VCO_EN \$I41 VDD_DEC pfet_05v0 L=0.5U W=2U AS=1.54P AD=1.54P
+ PS=5.54U PD=5.54U
* device instance $28 r0 *1 130.72,-7.98 nfet_05v0
M$28 VSS VCO_EN \$I41 VSS nfet_05v0 L=0.6U W=1U AS=0.73P AD=0.73P PS=3.46U
+ PD=3.46U
* device instance $29 r90 *1 130.69,-11.975 nfet_05v0
M$29 \$10 VCO_EN INV_IN VSS nfet_05v0 L=0.6U W=2U AS=1.46P AD=1.46P PS=5.46U
+ PD=5.46U
* device instance $30 r90 *1 127.18,-12.005 pfet_05v0
M$30 \$10 \$I41 INV_IN VDD_DEC pfet_05v0 L=0.5U W=6U AS=3.14P AD=3.14P
+ PS=11.14U PD=11.14U
* device instance $34 r180 *1 19.345,-8.9 pfet_05v0
M$34 VDD_DEC VCO_EN \$I42 VDD_DEC pfet_05v0 L=0.5U W=2U AS=1.54P AD=1.54P
+ PS=5.54U PD=5.54U
* device instance $35 r0 *1 26.4,-9.895 nfet_05v0
M$35 VSS \$I42 \$8 VSS nfet_05v0 L=0.6U W=0.42U AS=0.315P AD=0.315P PS=2.34U
+ PD=2.34U
* device instance $36 r0 *1 26.4,-7.98 nfet_05v0
M$36 VSS VCO_EN \$I42 VSS nfet_05v0 L=0.6U W=1U AS=0.73P AD=0.73P PS=3.46U
+ PD=3.46U
* device instance $37 r90 *1 26.37,-11.975 nfet_05v0
M$37 INV_OUT VCO_EN \$8 VSS nfet_05v0 L=0.6U W=2U AS=1.46P AD=1.46P PS=5.46U
+ PD=5.46U
* device instance $38 r90 *1 22.86,-12.005 pfet_05v0
M$38 INV_OUT \$I42 \$8 VDD_DEC pfet_05v0 L=0.5U W=6U AS=3.14P AD=3.14P
+ PS=11.14U PD=11.14U
.ENDS vco_only

* cell cs_inv_x4_5v0
* pin
* pin
* pin
* pin
* pin
* pin SUB
.SUBCKT cs_inv_x4_5v0 \$6 \$17 \$19 \$23 \$55 SUB
* device instance $1 r0 *1 2.97,7.835 pfet_05v0
M$1 \$23 \$55 \$25 \$23 pfet_05v0 L=1U W=64U AS=18.68P AD=17.76P PS=77.34U
+ PD=72.88U
* device instance $17 r0 *1 27.6,7.835 pfet_05v0
M$17 \$17 \$19 \$25 \$23 pfet_05v0 L=0.5U W=12U AS=5.36P AD=6.28P PS=14.68U
+ PD=19.14U
* device instance $20 r0 *1 15.07,1.775 nfet_05v0
M$20 SUB \$6 \$7 SUB nfet_05v0 L=1U W=16U AS=5.1P AD=4.68P PS=23.1U PD=20.68U
* device instance $28 r0 *1 27.55,1.775 nfet_05v0
M$28 \$17 \$19 \$7 SUB nfet_05v0 L=0.6U W=6U AS=2.64P AD=3.06P PS=8.64U
+ PD=11.06U
.ENDS cs_inv_x4_5v0

* cell vco_bias_5v0
* pin
* pin
* pin
* pin
* pin SUB
.SUBCKT vco_bias_5v0 \$1 \$2 \$7 \$18 SUB
* device instance $1 r0 *1 2.97,7.835 pfet_05v0
M$1 \$7 \$7 \$2 \$2 pfet_05v0 L=1U W=16U AS=6.2P AD=5.28P PS=23.1U PD=18.64U
* device instance $5 r0 *1 9.61,7.835 pfet_05v0
M$5 \$1 \$7 \$2 \$2 pfet_05v0 L=1U W=16U AS=5.28P AD=6.2P PS=18.64U PD=23.1U
* device instance $9 r0 *1 8.29,1.775 nfet_05v0
M$9 SUB \$18 \$7 SUB nfet_05v0 L=2U W=2U AS=1.46P AD=1.04P PS=5.46U PD=3.04U
* device instance $10 r0 *1 10.83,1.775 nfet_05v0
M$10 \$1 \$1 SUB SUB nfet_05v0 L=1U W=4U AS=1.56P AD=1.98P PS=5.56U PD=7.98U
.ENDS vco_bias_5v0

* cell cs_inv_5v0
* pin
* pin
* pin
* pin
* pin
* pin SUB
.SUBCKT cs_inv_5v0 \$2 \$5 \$15 \$23 \$24 SUB
* device instance $1 r0 *1 2.97,7.835 pfet_05v0
M$1 \$2 \$24 \$3 \$2 pfet_05v0 L=1U W=16U AS=6.2P AD=5.28P PS=23.1U PD=18.64U
* device instance $5 r0 *1 9.36,7.835 pfet_05v0
M$5 \$5 \$15 \$3 \$2 pfet_05v0 L=0.5U W=4U AS=2.16P AD=3.08P PS=5.08U PD=9.54U
* device instance $6 r0 *1 6,1.775 nfet_05v0
M$6 SUB \$23 \$6 SUB nfet_05v0 L=1U W=4U AS=1.98P AD=1.56P PS=7.98U PD=5.56U
* device instance $8 r0 *1 9.36,1.775 nfet_05v0
M$8 \$5 \$15 \$6 SUB nfet_05v0 L=0.6U W=2U AS=1.04P AD=1.46P PS=3.04U PD=5.46U
.ENDS cs_inv_5v0
