* Extracted by KLayout with GF180MCU LVS runset on : 19/10/2026 05:40

* cell workshop_inverter
* pin D[0]
* pin D[1]
* pin D[2]
* pin D[3]
* pin D[4]
* pin D[5]
* pin D[6]
* pin FOUT
* pin IN
* pin OUT
* pin VCO_EN
* pin VCTRL
* pin VDD_DEC
* pin VDD_INV
* pin VSS
.SUBCKT workshop_inverter D[0] D[1] D[2] D[3] D[4] D[5] D[6] FOUT IN OUT VCO_EN
+ VCTRL VDD_DEC VDD_INV VSS
* cell instance $731 r0 *1 60,842.5
X$731 \$I2018 VDD_INV \$I2017 VCTRL VSS vco_bias_5v0
* cell instance $733 r0 *1 78.305,842.5
X$733 VDD_INV \$I2014 \$I2010 \$I2018 \$I2017 VSS cs_inv_5v0
* cell instance $734 r0 *1 159.025,842.5
X$734 \$I2011 VDD_INV \$I2016 \$I2018 \$I2017 VSS cs_inv_x4_5v0
* cell instance $735 r0 *1 145.765,842.5
X$735 VDD_INV \$I2016 \$I2012 \$I2018 \$I2017 VSS cs_inv_5v0
* cell instance $736 r0 *1 132.505,842.5
X$736 VDD_INV \$I2012 \$I2015 \$I2018 \$I2017 VSS cs_inv_5v0
* cell instance $737 r0 *1 104.825,842.5
X$737 VDD_INV \$I2015 \$I2013 \$I2018 \$I2017 VSS cs_inv_5v0
* cell instance $739 r0 *1 91.565,842.5
X$739 VDD_INV \$I2013 \$I2014 \$I2018 \$I2017 VSS cs_inv_5v0
* device instance $1 r0 *1 632.46,858 diode_nw2ps_06v0
D$1 VSS D[5] diode_nw2ps_06v0 A=0.3888P P=2.88U
* device instance $2 r0 *1 660.46,858 diode_nw2ps_06v0
D$2 VSS D[6] diode_nw2ps_06v0 A=0.3888P P=2.88U
* device instance $3 r0 *1 604.46,858 diode_nw2ps_06v0
D$3 VSS D[4] diode_nw2ps_06v0 A=0.3888P P=2.88U
* device instance $4 r0 *1 576.46,858 diode_nw2ps_06v0
D$4 VSS D[3] diode_nw2ps_06v0 A=0.3888P P=2.88U
* device instance $5 r0 *1 548.46,858 diode_nw2ps_06v0
D$5 VSS D[2] diode_nw2ps_06v0 A=0.3888P P=2.88U
* device instance $6 r0 *1 520.46,858 diode_nw2ps_06v0
D$6 VSS D[1] diode_nw2ps_06v0 A=0.3888P P=2.88U
* device instance $7 r0 *1 492.46,858 diode_nw2ps_06v0
D$7 VSS D[0] diode_nw2ps_06v0 A=0.3888P P=2.88U
* device instance $8 r90 *1 62.14,843.355 diode_nw2ps_06v0
D$8 VSS VCTRL diode_nw2ps_06v0 A=0.3344P P=2.52U
* device instance $9 r180 *1 568.63,799.985 pfet_05v0
M$9 \$I2445 \$I2282 VDD_DEC VDD_DEC pfet_05v0 L=0.5U W=1.05U AS=0.4015P
+ AD=0.462P PS=1.92U PD=2.98U
* device instance $10 r180 *1 567.43,800.07 pfet_05v0
M$10 \$I2102 \$I2445 VDD_DEC VDD_DEC pfet_05v0 L=0.5U W=1.22U AS=0.4015P
+ AD=0.5368P PS=1.92U PD=3.32U
* device instance $11 r180 *1 568.68,802.295 nfet_05v0
M$11 VSS \$I2282 \$I2445 VSS nfet_05v0 L=0.6U W=0.36U AS=0.1584P AD=0.153P
+ PS=1.6U PD=1.195U
* device instance $12 r180 *1 567.38,802.228 nfet_05v0
M$12 \$I2102 \$I2445 VSS VSS nfet_05v0 L=0.6U W=0.495U AS=0.153P AD=0.2178P
+ PS=1.195U PD=1.87U
* device instance $13 m0 *1 512.23,823.285 pfet_05v0
M$13 \$I2446 \$I2353 VDD_DEC VDD_DEC pfet_05v0 L=0.5U W=0.6U AS=0.264P
+ AD=0.156P PS=2.08U PD=1.12U
* device instance $14 m0 *1 513.25,823.285 pfet_05v0
M$14 \$I2446 \$I2322 VDD_DEC VDD_DEC pfet_05v0 L=0.5U W=0.6U AS=0.40575P
+ AD=0.156P PS=2.055U PD=1.12U
* device instance $15 m0 *1 514.59,823.593 pfet_05v0
M$15 \$I2364 \$I2446 VDD_DEC VDD_DEC pfet_05v0 L=0.5U W=1.215U AS=0.40575P
+ AD=0.5346P PS=2.055U PD=3.31U
* device instance $16 m0 *1 512.28,825.583 nfet_05v0
M$16 \$I2447 \$I2353 \$I2446 VSS nfet_05v0 L=0.6U W=0.365U AS=0.1606P
+ AD=0.0584P PS=1.61U PD=0.685U
* device instance $17 m0 *1 513.2,825.583 nfet_05v0
M$17 \$I2447 \$I2322 VSS VSS nfet_05v0 L=0.6U W=0.365U AS=0.23405P AD=0.0584P
+ PS=1.555U PD=0.685U
* device instance $18 m0 *1 514.54,825.808 nfet_05v0
M$18 \$I2364 \$I2446 VSS VSS nfet_05v0 L=0.6U W=0.815U AS=0.23405P AD=0.3586P
+ PS=1.555U PD=2.51U
* device instance $19 m0 *1 544.81,823.26 pfet_05v0
M$19 \$I2451 \$I2384 \$I2448 VDD_DEC pfet_05v0 L=0.5U W=0.56U AS=0.2464P
+ AD=0.196P PS=2U PD=1.26U
* device instance $20 m0 *1 546.01,823.26 pfet_05v0
M$20 \$I2450 \$I2333 \$I2451 VDD_DEC pfet_05v0 L=0.5U W=0.56U AS=0.196P
+ AD=0.1736P PS=1.26U PD=1.18U
* device instance $21 m0 *1 547.13,823.26 pfet_05v0
M$21 \$I2449 \$I2332 \$I2450 VDD_DEC pfet_05v0 L=0.5U W=0.56U AS=0.1736P
+ AD=0.1736P PS=1.18U PD=1.18U
* device instance $22 m0 *1 548.25,823.26 pfet_05v0
M$22 \$I2449 \$I2382 VDD_DEC VDD_DEC pfet_05v0 L=0.5U W=0.56U AS=0.389P
+ AD=0.1736P PS=2.02U PD=1.18U
* device instance $23 m0 *1 549.55,823.59 pfet_05v0
M$23 \$I2419 \$I2448 VDD_DEC VDD_DEC pfet_05v0 L=0.5U W=1.22U AS=0.389P
+ AD=0.5368P PS=2.02U PD=3.32U
* device instance $24 m0 *1 544.76,825.915 nfet_05v0
M$24 \$I2448 \$I2384 VSS VSS nfet_05v0 L=0.6U W=0.36U AS=0.1584P AD=0.126P
+ PS=1.6U PD=1.06U
* device instance $25 m0 *1 546.06,825.915 nfet_05v0
M$25 VSS \$I2333 \$I2448 VSS nfet_05v0 L=0.6U W=0.36U AS=0.126P AD=0.0936P
+ PS=1.06U PD=0.88U
* device instance $26 m0 *1 547.18,825.915 nfet_05v0
M$26 \$I2448 \$I2332 VSS VSS nfet_05v0 L=0.6U W=0.36U AS=0.0936P AD=0.0936P
+ PS=0.88U PD=0.88U
* device instance $27 m0 *1 548.3,825.915 nfet_05v0
M$27 \$I2448 \$I2382 VSS VSS nfet_05v0 L=0.6U W=0.36U AS=0.218P AD=0.0936P
+ PS=1.52U PD=0.88U
* device instance $28 m0 *1 549.6,825.81 nfet_05v0
M$28 \$I2419 \$I2448 VSS VSS nfet_05v0 L=0.6U W=0.82U AS=0.218P AD=0.3608P
+ PS=1.52U PD=2.52U
* device instance $29 m0 *1 528.47,831.43 pfet_05v0
M$29 VDD_DEC \$I2247 \$I2452 VDD_DEC pfet_05v0 L=0.5U W=1.22U AS=0.5368P
+ AD=0.4941P PS=3.32U PD=2.03U
* device instance $30 m0 *1 529.78,831.43 pfet_05v0
M$30 \$I2308 \$I2452 VDD_DEC VDD_DEC pfet_05v0 L=0.5U W=2.44U AS=0.8723P
+ AD=0.915P PS=3.87U PD=5.16U
* device instance $32 m0 *1 528.52,833.65 nfet_05v0
M$32 VSS \$I2247 \$I2452 VSS nfet_05v0 L=0.6U W=0.82U AS=0.3608P AD=0.2911P
+ PS=2.52U PD=1.53U
* device instance $33 m0 *1 529.83,833.65 nfet_05v0
M$33 \$I2308 \$I2452 VSS VSS nfet_05v0 L=0.6U W=1.64U AS=0.5043P AD=0.574P
+ PS=2.87U PD=3.86U
* device instance $35 m0 *1 538.55,831.43 pfet_05v0
M$35 VDD_DEC \$I2380 \$I2453 VDD_DEC pfet_05v0 L=0.5U W=1.22U AS=0.5368P
+ AD=0.4941P PS=3.32U PD=2.03U
* device instance $36 m0 *1 539.86,831.43 pfet_05v0
M$36 \$I2251 \$I2453 VDD_DEC VDD_DEC pfet_05v0 L=0.5U W=2.44U AS=0.8723P
+ AD=0.915P PS=3.87U PD=5.16U
* device instance $38 m0 *1 538.6,833.65 nfet_05v0
M$38 VSS \$I2380 \$I2453 VSS nfet_05v0 L=0.6U W=0.82U AS=0.3608P AD=0.2911P
+ PS=2.52U PD=1.53U
* device instance $39 m0 *1 539.91,833.65 nfet_05v0
M$39 \$I2251 \$I2453 VSS VSS nfet_05v0 L=0.6U W=1.64U AS=0.5043P AD=0.574P
+ PS=2.87U PD=3.86U
* device instance $41 m0 *1 522.31,831.43 pfet_05v0
M$41 VDD_DEC \$I2363 \$I2454 VDD_DEC pfet_05v0 L=0.5U W=1.22U AS=0.5368P
+ AD=0.4941P PS=3.32U PD=2.03U
* device instance $42 m0 *1 523.62,831.43 pfet_05v0
M$42 \$I2274 \$I2454 VDD_DEC VDD_DEC pfet_05v0 L=0.5U W=2.44U AS=0.8723P
+ AD=0.915P PS=3.87U PD=5.16U
* device instance $44 m0 *1 522.36,833.65 nfet_05v0
M$44 VSS \$I2363 \$I2454 VSS nfet_05v0 L=0.6U W=0.82U AS=0.3608P AD=0.2911P
+ PS=2.52U PD=1.53U
* device instance $45 m0 *1 523.67,833.65 nfet_05v0
M$45 \$I2274 \$I2454 VSS VSS nfet_05v0 L=0.6U W=1.64U AS=0.5043P AD=0.574P
+ PS=2.87U PD=3.86U
* device instance $47 r0 *1 512.23,829.53 pfet_05v0
M$47 VDD_DEC \$I2330 \$I2455 VDD_DEC pfet_05v0 L=0.5U W=1.22U AS=0.5368P
+ AD=0.4941P PS=3.32U PD=2.03U
* device instance $48 r0 *1 513.54,829.53 pfet_05v0
M$48 \$I2166 \$I2455 VDD_DEC VDD_DEC pfet_05v0 L=0.5U W=2.44U AS=0.8723P
+ AD=0.915P PS=3.87U PD=5.16U
* device instance $50 r0 *1 512.28,827.31 nfet_05v0
M$50 VSS \$I2330 \$I2455 VSS nfet_05v0 L=0.6U W=0.82U AS=0.3608P AD=0.2911P
+ PS=2.52U PD=1.53U
* device instance $51 r0 *1 513.59,827.31 nfet_05v0
M$51 \$I2166 \$I2455 VSS VSS nfet_05v0 L=0.6U W=1.64U AS=0.5043P AD=0.574P
+ PS=2.87U PD=3.86U
* device instance $53 r0 *1 516.71,829.53 pfet_05v0
M$53 VDD_DEC \$I2232 \$I2456 VDD_DEC pfet_05v0 L=0.5U W=1.22U AS=0.5368P
+ AD=0.4941P PS=3.32U PD=2.03U
* device instance $54 r0 *1 518.02,829.53 pfet_05v0
M$54 \$I2209 \$I2456 VDD_DEC VDD_DEC pfet_05v0 L=0.5U W=2.44U AS=0.8723P
+ AD=0.915P PS=3.87U PD=5.16U
* device instance $56 r0 *1 516.76,827.31 nfet_05v0
M$56 VSS \$I2232 \$I2456 VSS nfet_05v0 L=0.6U W=0.82U AS=0.3608P AD=0.2911P
+ PS=2.52U PD=1.53U
* device instance $57 r0 *1 518.07,827.31 nfet_05v0
M$57 \$I2209 \$I2456 VSS VSS nfet_05v0 L=0.6U W=1.64U AS=0.5043P AD=0.574P
+ PS=2.87U PD=3.86U
* device instance $59 r0 *1 540.23,837.37 pfet_05v0
M$59 VDD_DEC \$I2323 \$I2457 VDD_DEC pfet_05v0 L=0.5U W=1.22U AS=0.5368P
+ AD=0.4941P PS=3.32U PD=2.03U
* device instance $60 r0 *1 541.54,837.37 pfet_05v0
M$60 \$I2238 \$I2457 VDD_DEC VDD_DEC pfet_05v0 L=0.5U W=2.44U AS=0.8723P
+ AD=0.915P PS=3.87U PD=5.16U
* device instance $62 r0 *1 540.28,835.15 nfet_05v0
M$62 VSS \$I2323 \$I2457 VSS nfet_05v0 L=0.6U W=0.82U AS=0.3608P AD=0.2911P
+ PS=2.52U PD=1.53U
* device instance $63 r0 *1 541.59,835.15 nfet_05v0
M$63 \$I2238 \$I2457 VSS VSS nfet_05v0 L=0.6U W=1.64U AS=0.5043P AD=0.574P
+ PS=2.87U PD=3.86U
* device instance $65 r0 *1 535.75,837.37 pfet_05v0
M$65 VDD_DEC \$I2305 \$I2458 VDD_DEC pfet_05v0 L=0.5U W=1.22U AS=0.5368P
+ AD=0.4941P PS=3.32U PD=2.03U
* device instance $66 r0 *1 537.06,837.37 pfet_05v0
M$66 \$I2205 \$I2458 VDD_DEC VDD_DEC pfet_05v0 L=0.5U W=2.44U AS=0.8723P
+ AD=0.915P PS=3.87U PD=5.16U
* device instance $68 r0 *1 535.8,835.15 nfet_05v0
M$68 VSS \$I2305 \$I2458 VSS nfet_05v0 L=0.6U W=0.82U AS=0.3608P AD=0.2911P
+ PS=2.52U PD=1.53U
* device instance $69 r0 *1 537.11,835.15 nfet_05v0
M$69 \$I2205 \$I2458 VSS VSS nfet_05v0 L=0.6U W=1.64U AS=0.5043P AD=0.574P
+ PS=2.87U PD=3.86U
* device instance $71 m0 *1 503.27,823.59 pfet_05v0
M$71 VDD_DEC \$I2362 \$I2459 VDD_DEC pfet_05v0 L=0.5U W=1.22U AS=0.5368P
+ AD=0.4941P PS=3.32U PD=2.03U
* device instance $72 m0 *1 504.58,823.59 pfet_05v0
M$72 \$I2360 \$I2459 VDD_DEC VDD_DEC pfet_05v0 L=0.5U W=2.44U AS=0.8723P
+ AD=0.915P PS=3.87U PD=5.16U
* device instance $74 m0 *1 503.32,825.81 nfet_05v0
M$74 VSS \$I2362 \$I2459 VSS nfet_05v0 L=0.6U W=0.82U AS=0.3608P AD=0.2911P
+ PS=2.52U PD=1.53U
* device instance $75 m0 *1 504.63,825.81 nfet_05v0
M$75 \$I2360 \$I2459 VSS VSS nfet_05v0 L=0.6U W=1.64U AS=0.5043P AD=0.574P
+ PS=2.87U PD=3.86U
* device instance $77 r0 *1 508.97,822.017 pfet_05v0
M$77 \$I2460 \$I2399 VDD_DEC VDD_DEC pfet_05v0 L=0.5U W=0.565U AS=0.35315P
+ AD=0.2486P PS=1.96U PD=2.01U
* device instance $78 r0 *1 510.21,821.69 pfet_05v0
M$78 \$I2407 \$I2460 VDD_DEC VDD_DEC pfet_05v0 L=0.5U W=1.22U AS=0.35315P
+ AD=0.5368P PS=1.96U PD=3.32U
* device instance $79 r0 *1 508.92,819.7 nfet_05v0
M$79 \$I2460 \$I2399 VSS VSS nfet_05v0 L=0.6U W=0.36U AS=0.2344P AD=0.1584P
+ PS=1.56U PD=1.6U
* device instance $80 r0 *1 510.26,819.47 nfet_05v0
M$80 \$I2407 \$I2460 VSS VSS nfet_05v0 L=0.6U W=0.82U AS=0.2344P AD=0.3608P
+ PS=1.56U PD=2.52U
* device instance $81 m0 *1 567.17,807.6 pfet_05v0
M$81 \$I2461 \$I2338 VDD_DEC VDD_DEC pfet_05v0 L=0.5U W=0.6U AS=0.264P
+ AD=0.156P PS=2.08U PD=1.12U
* device instance $82 m0 *1 568.19,807.6 pfet_05v0
M$82 VDD_DEC \$I2383 \$I2461 VDD_DEC pfet_05v0 L=0.5U W=0.6U AS=0.156P
+ AD=0.156P PS=1.12U PD=1.12U
* device instance $83 m0 *1 569.21,807.6 pfet_05v0
M$83 \$I2461 \$I2337 VDD_DEC VDD_DEC pfet_05v0 L=0.5U W=0.6U AS=0.156P
+ AD=0.156P PS=1.12U PD=1.12U
* device instance $84 m0 *1 570.23,807.6 pfet_05v0
M$84 \$I2461 \$I2336 VDD_DEC VDD_DEC pfet_05v0 L=0.5U W=0.6U AS=0.395P
+ AD=0.156P PS=2.02U PD=1.12U
* device instance $85 m0 *1 571.53,807.91 pfet_05v0
M$85 \$I2165 \$I2461 VDD_DEC VDD_DEC pfet_05v0 L=0.5U W=1.22U AS=0.395P
+ AD=0.5368P PS=2.02U PD=3.32U
* device instance $86 m0 *1 567.22,809.93 nfet_05v0
M$86 \$I2464 \$I2338 \$I2461 VSS nfet_05v0 L=0.6U W=0.42U AS=0.1848P AD=0.0672P
+ PS=1.72U PD=0.74U
* device instance $87 m0 *1 568.14,809.93 nfet_05v0
M$87 \$I2463 \$I2383 \$I2464 VSS nfet_05v0 L=0.6U W=0.42U AS=0.0672P AD=0.0882P
+ PS=0.74U PD=0.84U
* device instance $88 m0 *1 569.16,809.93 nfet_05v0
M$88 \$I2462 \$I2337 \$I2463 VSS nfet_05v0 L=0.6U W=0.42U AS=0.0882P AD=0.0882P
+ PS=0.84U PD=0.84U
* device instance $89 m0 *1 570.18,809.93 nfet_05v0
M$89 \$I2462 \$I2336 VSS VSS nfet_05v0 L=0.6U W=0.42U AS=0.226P AD=0.0882P
+ PS=1.515U PD=0.84U
* device instance $90 m0 *1 571.48,810.128 nfet_05v0
M$90 \$I2165 \$I2461 VSS VSS nfet_05v0 L=0.6U W=0.815U AS=0.226P AD=0.3586P
+ PS=1.515U PD=2.51U
* device instance $91 m0 *1 617.57,807.6 pfet_05v0
M$91 \$I2465 \$I2342 VDD_DEC VDD_DEC pfet_05v0 L=0.5U W=0.6U AS=0.264P
+ AD=0.156P PS=2.08U PD=1.12U
* device instance $92 m0 *1 618.59,807.6 pfet_05v0
M$92 VDD_DEC \$I2179 \$I2465 VDD_DEC pfet_05v0 L=0.5U W=0.6U AS=0.156P
+ AD=0.156P PS=1.12U PD=1.12U
* device instance $93 m0 *1 619.61,807.6 pfet_05v0
M$93 \$I2465 \$I2285 VDD_DEC VDD_DEC pfet_05v0 L=0.5U W=0.6U AS=0.156P
+ AD=0.156P PS=1.12U PD=1.12U
* device instance $94 m0 *1 620.63,807.6 pfet_05v0
M$94 \$I2465 \$I2336 VDD_DEC VDD_DEC pfet_05v0 L=0.5U W=0.6U AS=0.395P
+ AD=0.156P PS=2.02U PD=1.12U
* device instance $95 m0 *1 621.93,807.91 pfet_05v0
M$95 \$I2079 \$I2465 VDD_DEC VDD_DEC pfet_05v0 L=0.5U W=1.22U AS=0.395P
+ AD=0.5368P PS=2.02U PD=3.32U
* device instance $96 m0 *1 617.62,809.93 nfet_05v0
M$96 \$I2468 \$I2342 \$I2465 VSS nfet_05v0 L=0.6U W=0.42U AS=0.1848P AD=0.0672P
+ PS=1.72U PD=0.74U
* device instance $97 m0 *1 618.54,809.93 nfet_05v0
M$97 \$I2467 \$I2179 \$I2468 VSS nfet_05v0 L=0.6U W=0.42U AS=0.0672P AD=0.0882P
+ PS=0.74U PD=0.84U
* device instance $98 m0 *1 619.56,809.93 nfet_05v0
M$98 \$I2466 \$I2285 \$I2467 VSS nfet_05v0 L=0.6U W=0.42U AS=0.0882P AD=0.0882P
+ PS=0.84U PD=0.84U
* device instance $99 m0 *1 620.58,809.93 nfet_05v0
M$99 \$I2466 \$I2336 VSS VSS nfet_05v0 L=0.6U W=0.42U AS=0.226P AD=0.0882P
+ PS=1.515U PD=0.84U
* device instance $100 m0 *1 621.88,810.128 nfet_05v0
M$100 \$I2079 \$I2465 VSS VSS nfet_05v0 L=0.6U W=0.815U AS=0.226P AD=0.3586P
+ PS=1.515U PD=2.51U
* device instance $101 m0 *1 599.09,807.6 pfet_05v0
M$101 \$I2469 \$I2237 VDD_DEC VDD_DEC pfet_05v0 L=0.5U W=0.6U AS=0.264P
+ AD=0.156P PS=2.08U PD=1.12U
* device instance $102 m0 *1 600.11,807.6 pfet_05v0
M$102 VDD_DEC \$I2284 \$I2469 VDD_DEC pfet_05v0 L=0.5U W=0.6U AS=0.156P
+ AD=0.156P PS=1.12U PD=1.12U
* device instance $103 m0 *1 601.13,807.6 pfet_05v0
M$103 \$I2469 \$I2286 VDD_DEC VDD_DEC pfet_05v0 L=0.5U W=0.6U AS=0.156P
+ AD=0.156P PS=1.12U PD=1.12U
* device instance $104 m0 *1 602.15,807.6 pfet_05v0
M$104 \$I2469 \$I2336 VDD_DEC VDD_DEC pfet_05v0 L=0.5U W=0.6U AS=0.395P
+ AD=0.156P PS=2.02U PD=1.12U
* device instance $105 m0 *1 603.45,807.91 pfet_05v0
M$105 \$I2255 \$I2469 VDD_DEC VDD_DEC pfet_05v0 L=0.5U W=1.22U AS=0.395P
+ AD=0.5368P PS=2.02U PD=3.32U
* device instance $106 m0 *1 599.14,809.93 nfet_05v0
M$106 \$I2472 \$I2237 \$I2469 VSS nfet_05v0 L=0.6U W=0.42U AS=0.1848P
+ AD=0.0672P PS=1.72U PD=0.74U
* device instance $107 m0 *1 600.06,809.93 nfet_05v0
M$107 \$I2471 \$I2284 \$I2472 VSS nfet_05v0 L=0.6U W=0.42U AS=0.0672P
+ AD=0.0882P PS=0.74U PD=0.84U
* device instance $108 m0 *1 601.08,809.93 nfet_05v0
M$108 \$I2470 \$I2286 \$I2471 VSS nfet_05v0 L=0.6U W=0.42U AS=0.0882P
+ AD=0.0882P PS=0.84U PD=0.84U
* device instance $109 m0 *1 602.1,809.93 nfet_05v0
M$109 \$I2470 \$I2336 VSS VSS nfet_05v0 L=0.6U W=0.42U AS=0.226P AD=0.0882P
+ PS=1.515U PD=0.84U
* device instance $110 m0 *1 603.4,810.128 nfet_05v0
M$110 \$I2255 \$I2469 VSS VSS nfet_05v0 L=0.6U W=0.815U AS=0.226P AD=0.3586P
+ PS=1.515U PD=2.51U
* device instance $111 r180 *1 554.11,807.6 pfet_05v0
M$111 \$I2473 \$I2338 VDD_DEC VDD_DEC pfet_05v0 L=0.5U W=0.6U AS=0.264P
+ AD=0.156P PS=2.08U PD=1.12U
* device instance $112 r180 *1 553.09,807.6 pfet_05v0
M$112 VDD_DEC \$I2170 \$I2473 VDD_DEC pfet_05v0 L=0.5U W=0.6U AS=0.156P
+ AD=0.156P PS=1.12U PD=1.12U
* device instance $113 r180 *1 552.07,807.6 pfet_05v0
M$113 \$I2473 \$I2337 VDD_DEC VDD_DEC pfet_05v0 L=0.5U W=0.6U AS=0.156P
+ AD=0.156P PS=1.12U PD=1.12U
* device instance $114 r180 *1 551.05,807.6 pfet_05v0
M$114 \$I2473 \$I2336 VDD_DEC VDD_DEC pfet_05v0 L=0.5U W=0.6U AS=0.395P
+ AD=0.156P PS=2.02U PD=1.12U
* device instance $115 r180 *1 549.75,807.91 pfet_05v0
M$115 \$I2023 \$I2473 VDD_DEC VDD_DEC pfet_05v0 L=0.5U W=1.22U AS=0.395P
+ AD=0.5368P PS=2.02U PD=3.32U
* device instance $116 r180 *1 554.06,809.93 nfet_05v0
M$116 \$I2476 \$I2338 \$I2473 VSS nfet_05v0 L=0.6U W=0.42U AS=0.1848P
+ AD=0.0672P PS=1.72U PD=0.74U
* device instance $117 r180 *1 553.14,809.93 nfet_05v0
M$117 \$I2475 \$I2170 \$I2476 VSS nfet_05v0 L=0.6U W=0.42U AS=0.0672P
+ AD=0.0882P PS=0.74U PD=0.84U
* device instance $118 r180 *1 552.12,809.93 nfet_05v0
M$118 \$I2474 \$I2337 \$I2475 VSS nfet_05v0 L=0.6U W=0.42U AS=0.0882P
+ AD=0.0882P PS=0.84U PD=0.84U
* device instance $119 r180 *1 551.1,809.93 nfet_05v0
M$119 \$I2474 \$I2336 VSS VSS nfet_05v0 L=0.6U W=0.42U AS=0.226P AD=0.0882P
+ PS=1.515U PD=0.84U
* device instance $120 r180 *1 549.8,810.128 nfet_05v0
M$120 \$I2023 \$I2473 VSS VSS nfet_05v0 L=0.6U W=0.815U AS=0.226P AD=0.3586P
+ PS=1.515U PD=2.51U
* device instance $121 r180 *1 560.27,807.6 pfet_05v0
M$121 \$I2477 \$I2338 VDD_DEC VDD_DEC pfet_05v0 L=0.5U W=0.6U AS=0.264P
+ AD=0.156P PS=2.08U PD=1.12U
* device instance $122 r180 *1 559.25,807.6 pfet_05v0
M$122 VDD_DEC \$I2333 \$I2477 VDD_DEC pfet_05v0 L=0.5U W=0.6U AS=0.156P
+ AD=0.156P PS=1.12U PD=1.12U
* device instance $123 r180 *1 558.23,807.6 pfet_05v0
M$123 \$I2477 \$I2203 VDD_DEC VDD_DEC pfet_05v0 L=0.5U W=0.6U AS=0.156P
+ AD=0.156P PS=1.12U PD=1.12U
* device instance $124 r180 *1 557.21,807.6 pfet_05v0
M$124 \$I2477 \$I2336 VDD_DEC VDD_DEC pfet_05v0 L=0.5U W=0.6U AS=0.395P
+ AD=0.156P PS=2.02U PD=1.12U
* device instance $125 r180 *1 555.91,807.91 pfet_05v0
M$125 \$I2055 \$I2477 VDD_DEC VDD_DEC pfet_05v0 L=0.5U W=1.22U AS=0.395P
+ AD=0.5368P PS=2.02U PD=3.32U
* device instance $126 r180 *1 560.22,809.93 nfet_05v0
M$126 \$I2480 \$I2338 \$I2477 VSS nfet_05v0 L=0.6U W=0.42U AS=0.1848P
+ AD=0.0672P PS=1.72U PD=0.74U
* device instance $127 r180 *1 559.3,809.93 nfet_05v0
M$127 \$I2479 \$I2333 \$I2480 VSS nfet_05v0 L=0.6U W=0.42U AS=0.0672P
+ AD=0.0882P PS=0.74U PD=0.84U
* device instance $128 r180 *1 558.28,809.93 nfet_05v0
M$128 \$I2478 \$I2203 \$I2479 VSS nfet_05v0 L=0.6U W=0.42U AS=0.0882P
+ AD=0.0882P PS=0.84U PD=0.84U
* device instance $129 r180 *1 557.26,809.93 nfet_05v0
M$129 \$I2478 \$I2336 VSS VSS nfet_05v0 L=0.6U W=0.42U AS=0.226P AD=0.0882P
+ PS=1.515U PD=0.84U
* device instance $130 r180 *1 555.96,810.128 nfet_05v0
M$130 \$I2055 \$I2477 VSS VSS nfet_05v0 L=0.6U W=0.815U AS=0.226P AD=0.3586P
+ PS=1.515U PD=2.51U
* device instance $131 r0 *1 547.57,814.16 pfet_05v0
M$131 \$I2481 \$I2355 VDD_DEC VDD_DEC pfet_05v0 L=0.5U W=0.6U AS=0.264P
+ AD=0.156P PS=2.08U PD=1.12U
* device instance $132 r0 *1 548.59,814.16 pfet_05v0
M$132 VDD_DEC \$I2365 \$I2481 VDD_DEC pfet_05v0 L=0.5U W=0.6U AS=0.156P
+ AD=0.156P PS=1.12U PD=1.12U
* device instance $133 r0 *1 549.61,814.16 pfet_05v0
M$133 \$I2481 \$I2417 VDD_DEC VDD_DEC pfet_05v0 L=0.5U W=0.6U AS=0.156P
+ AD=0.156P PS=1.12U PD=1.12U
* device instance $134 r0 *1 550.63,814.16 pfet_05v0
M$134 \$I2481 \$I2384 VDD_DEC VDD_DEC pfet_05v0 L=0.5U W=0.6U AS=0.395P
+ AD=0.156P PS=2.02U PD=1.12U
* device instance $135 r0 *1 551.93,813.85 pfet_05v0
M$135 \$I2366 \$I2481 VDD_DEC VDD_DEC pfet_05v0 L=0.5U W=1.22U AS=0.395P
+ AD=0.5368P PS=2.02U PD=3.32U
* device instance $136 r0 *1 547.62,811.83 nfet_05v0
M$136 \$I2484 \$I2355 \$I2481 VSS nfet_05v0 L=0.6U W=0.42U AS=0.1848P
+ AD=0.0672P PS=1.72U PD=0.74U
* device instance $137 r0 *1 548.54,811.83 nfet_05v0
M$137 \$I2483 \$I2365 \$I2484 VSS nfet_05v0 L=0.6U W=0.42U AS=0.0672P
+ AD=0.0882P PS=0.74U PD=0.84U
* device instance $138 r0 *1 549.56,811.83 nfet_05v0
M$138 \$I2482 \$I2417 \$I2483 VSS nfet_05v0 L=0.6U W=0.42U AS=0.0882P
+ AD=0.0882P PS=0.84U PD=0.84U
* device instance $139 r0 *1 550.58,811.83 nfet_05v0
M$139 \$I2482 \$I2384 VSS VSS nfet_05v0 L=0.6U W=0.42U AS=0.226P AD=0.0882P
+ PS=1.515U PD=0.84U
* device instance $140 r0 *1 551.88,811.632 nfet_05v0
M$140 \$I2366 \$I2481 VSS VSS nfet_05v0 L=0.6U W=0.815U AS=0.226P AD=0.3586P
+ PS=1.515U PD=2.51U
* device instance $141 r0 *1 634.93,798.48 pfet_05v0
M$141 \$I2485 \$I2342 VDD_DEC VDD_DEC pfet_05v0 L=0.5U W=0.6U AS=0.264P
+ AD=0.156P PS=2.08U PD=1.12U
* device instance $142 r0 *1 635.95,798.48 pfet_05v0
M$142 VDD_DEC \$I2341 \$I2485 VDD_DEC pfet_05v0 L=0.5U W=0.6U AS=0.156P
+ AD=0.156P PS=1.12U PD=1.12U
* device instance $143 r0 *1 636.97,798.48 pfet_05v0
M$143 \$I2485 \$I2285 VDD_DEC VDD_DEC pfet_05v0 L=0.5U W=0.6U AS=0.156P
+ AD=0.156P PS=1.12U PD=1.12U
* device instance $144 r0 *1 637.99,798.48 pfet_05v0
M$144 \$I2485 \$I2336 VDD_DEC VDD_DEC pfet_05v0 L=0.5U W=0.6U AS=0.395P
+ AD=0.156P PS=2.02U PD=1.12U
* device instance $145 r0 *1 639.29,798.17 pfet_05v0
M$145 \$I2258 \$I2485 VDD_DEC VDD_DEC pfet_05v0 L=0.5U W=1.22U AS=0.395P
+ AD=0.5368P PS=2.02U PD=3.32U
* device instance $146 r0 *1 634.98,796.15 nfet_05v0
M$146 \$I2488 \$I2342 \$I2485 VSS nfet_05v0 L=0.6U W=0.42U AS=0.1848P
+ AD=0.0672P PS=1.72U PD=0.74U
* device instance $147 r0 *1 635.9,796.15 nfet_05v0
M$147 \$I2487 \$I2341 \$I2488 VSS nfet_05v0 L=0.6U W=0.42U AS=0.0672P
+ AD=0.0882P PS=0.74U PD=0.84U
* device instance $148 r0 *1 636.92,796.15 nfet_05v0
M$148 \$I2486 \$I2285 \$I2487 VSS nfet_05v0 L=0.6U W=0.42U AS=0.0882P
+ AD=0.0882P PS=0.84U PD=0.84U
* device instance $149 r0 *1 637.94,796.15 nfet_05v0
M$149 \$I2486 \$I2336 VSS VSS nfet_05v0 L=0.6U W=0.42U AS=0.226P AD=0.0882P
+ PS=1.515U PD=0.84U
* device instance $150 r0 *1 639.24,795.952 nfet_05v0
M$150 \$I2258 \$I2485 VSS VSS nfet_05v0 L=0.6U W=0.815U AS=0.226P AD=0.3586P
+ PS=1.515U PD=2.51U
* device instance $151 r180 *1 517.765,823.635 pfet_05v0
M$151 \$I2199 \$I2399 VDD_DEC VDD_DEC pfet_05v0 L=0.5U W=1.13U AS=0.4972P
+ AD=0.2938P PS=3.14U PD=1.65U
* device instance $152 r180 *1 516.745,823.635 pfet_05v0
M$152 VDD_DEC \$I2329 \$I2199 VDD_DEC pfet_05v0 L=0.5U W=1.13U AS=0.2938P
+ AD=0.4972P PS=1.65U PD=3.14U
* device instance $153 r180 *1 517.715,825.81 nfet_05v0
M$153 \$I2489 \$I2399 VSS VSS nfet_05v0 L=0.6U W=0.82U AS=0.3608P AD=0.1312P
+ PS=2.52U PD=1.14U
* device instance $154 r180 *1 516.795,825.81 nfet_05v0
M$154 \$I2199 \$I2329 \$I2489 VSS nfet_05v0 L=0.6U W=0.82U AS=0.1312P
+ AD=0.3608P PS=1.14U PD=2.52U
* device instance $155 r0 *1 606.315,829.485 pfet_05v0
M$155 \$I2368 \$I2366 VDD_DEC VDD_DEC pfet_05v0 L=0.5U W=1.13U AS=0.4972P
+ AD=0.2938P PS=3.14U PD=1.65U
* device instance $156 r0 *1 607.335,829.485 pfet_05v0
M$156 VDD_DEC \$I2211 \$I2368 VDD_DEC pfet_05v0 L=0.5U W=1.13U AS=0.2938P
+ AD=0.4972P PS=1.65U PD=3.14U
* device instance $157 r0 *1 606.365,827.31 nfet_05v0
M$157 \$I2490 \$I2366 VSS VSS nfet_05v0 L=0.6U W=0.82U AS=0.3608P AD=0.1312P
+ PS=2.52U PD=1.14U
* device instance $158 r0 *1 607.285,827.31 nfet_05v0
M$158 \$I2368 \$I2211 \$I2490 VSS nfet_05v0 L=0.6U W=0.82U AS=0.1312P
+ AD=0.3608P PS=1.14U PD=2.52U
* device instance $159 r0 *1 574.395,829.485 pfet_05v0
M$159 \$I2402 \$I2407 VDD_DEC VDD_DEC pfet_05v0 L=0.5U W=1.13U AS=0.4972P
+ AD=0.2938P PS=3.14U PD=1.65U
* device instance $160 r0 *1 575.415,829.485 pfet_05v0
M$160 VDD_DEC \$I2384 \$I2402 VDD_DEC pfet_05v0 L=0.5U W=1.13U AS=0.2938P
+ AD=0.4972P PS=1.65U PD=3.14U
* device instance $161 r0 *1 574.445,827.31 nfet_05v0
M$161 \$I2491 \$I2407 VSS VSS nfet_05v0 L=0.6U W=0.82U AS=0.3608P AD=0.1312P
+ PS=2.52U PD=1.14U
* device instance $162 r0 *1 575.365,827.31 nfet_05v0
M$162 \$I2402 \$I2384 \$I2491 VSS nfet_05v0 L=0.6U W=0.82U AS=0.1312P
+ AD=0.3608P PS=1.14U PD=2.52U
* device instance $163 r180 *1 548.005,807.955 pfet_05v0
M$163 \$I2381 \$I2335 VDD_DEC VDD_DEC pfet_05v0 L=0.5U W=1.13U AS=0.4972P
+ AD=0.2938P PS=3.14U PD=1.65U
* device instance $164 r180 *1 546.985,807.955 pfet_05v0
M$164 VDD_DEC \$I2333 \$I2381 VDD_DEC pfet_05v0 L=0.5U W=1.13U AS=0.2938P
+ AD=0.4972P PS=1.65U PD=3.14U
* device instance $165 r180 *1 547.955,810.13 nfet_05v0
M$165 \$I2492 \$I2335 VSS VSS nfet_05v0 L=0.6U W=0.82U AS=0.3608P AD=0.1312P
+ PS=2.52U PD=1.14U
* device instance $166 r180 *1 547.035,810.13 nfet_05v0
M$166 \$I2381 \$I2333 \$I2492 VSS nfet_05v0 L=0.6U W=0.82U AS=0.1312P
+ AD=0.3608P PS=1.14U PD=2.52U
* device instance $167 m0 *1 495.68,823.59 pfet_05v0
M$167 VDD_DEC \$I2500 \$I2499 VDD_DEC pfet_05v0 L=1U W=1.22U AS=0.5368P
+ AD=0.5368P PS=3.32U PD=3.32U
* device instance $168 m0 *1 493.44,823.59 pfet_05v0
M$168 VDD_DEC \$I2498 \$I2497 VDD_DEC pfet_05v0 L=1U W=1.22U AS=0.5368P
+ AD=0.5368P PS=3.32U PD=3.32U
* device instance $169 m0 *1 491.2,823.59 pfet_05v0
M$169 VDD_DEC \$I2496 \$I2495 VDD_DEC pfet_05v0 L=1U W=1.22U AS=0.5368P
+ AD=0.5368P PS=3.32U PD=3.32U
* device instance $170 m0 *1 488.96,823.59 pfet_05v0
M$170 VDD_DEC \$I2494 \$I2493 VDD_DEC pfet_05v0 L=1U W=1.22U AS=0.5368P
+ AD=0.5368P PS=3.32U PD=3.32U
* device instance $171 m0 *1 495.68,825.81 nfet_05v0
M$171 \$I2500 \$I2499 VSS VSS nfet_05v0 L=1U W=0.82U AS=0.3608P AD=0.3608P
+ PS=2.52U PD=2.52U
* device instance $172 m0 *1 493.44,825.81 nfet_05v0
M$172 \$I2498 \$I2497 VSS VSS nfet_05v0 L=1U W=0.82U AS=0.3608P AD=0.3608P
+ PS=2.52U PD=2.52U
* device instance $173 m0 *1 491.2,825.81 nfet_05v0
M$173 \$I2496 \$I2495 VSS VSS nfet_05v0 L=1U W=0.82U AS=0.3608P AD=0.3608P
+ PS=2.52U PD=2.52U
* device instance $174 m0 *1 488.96,825.81 nfet_05v0
M$174 \$I2494 \$I2493 VSS VSS nfet_05v0 L=1U W=0.82U AS=0.3608P AD=0.3608P
+ PS=2.52U PD=2.52U
* device instance $175 m0 *1 665.36,831.43 pfet_05v0
M$175 VDD_DEC \$I2508 \$I2507 VDD_DEC pfet_05v0 L=1U W=1.22U AS=0.5368P
+ AD=0.5368P PS=3.32U PD=3.32U
* device instance $176 m0 *1 663.12,831.43 pfet_05v0
M$176 VDD_DEC \$I2506 \$I2505 VDD_DEC pfet_05v0 L=1U W=1.22U AS=0.5368P
+ AD=0.5368P PS=3.32U PD=3.32U
* device instance $177 m0 *1 660.88,831.43 pfet_05v0
M$177 VDD_DEC \$I2504 \$I2503 VDD_DEC pfet_05v0 L=1U W=1.22U AS=0.5368P
+ AD=0.5368P PS=3.32U PD=3.32U
* device instance $178 m0 *1 658.64,831.43 pfet_05v0
M$178 VDD_DEC \$I2502 \$I2501 VDD_DEC pfet_05v0 L=1U W=1.22U AS=0.5368P
+ AD=0.5368P PS=3.32U PD=3.32U
* device instance $179 m0 *1 665.36,833.65 nfet_05v0
M$179 \$I2508 \$I2507 VSS VSS nfet_05v0 L=1U W=0.82U AS=0.3608P AD=0.3608P
+ PS=2.52U PD=2.52U
* device instance $180 m0 *1 663.12,833.65 nfet_05v0
M$180 \$I2506 \$I2505 VSS VSS nfet_05v0 L=1U W=0.82U AS=0.3608P AD=0.3608P
+ PS=2.52U PD=2.52U
* device instance $181 m0 *1 660.88,833.65 nfet_05v0
M$181 \$I2504 \$I2503 VSS VSS nfet_05v0 L=1U W=0.82U AS=0.3608P AD=0.3608P
+ PS=2.52U PD=2.52U
* device instance $182 m0 *1 658.64,833.65 nfet_05v0
M$182 \$I2502 \$I2501 VSS VSS nfet_05v0 L=1U W=0.82U AS=0.3608P AD=0.3608P
+ PS=2.52U PD=2.52U
* device instance $183 r0 *1 656.96,837.37 pfet_05v0
M$183 VDD_DEC \$I2516 \$I2515 VDD_DEC pfet_05v0 L=1U W=1.22U AS=0.5368P
+ AD=0.5368P PS=3.32U PD=3.32U
* device instance $184 r0 *1 654.72,837.37 pfet_05v0
M$184 VDD_DEC \$I2514 \$I2513 VDD_DEC pfet_05v0 L=1U W=1.22U AS=0.5368P
+ AD=0.5368P PS=3.32U PD=3.32U
* device instance $185 r0 *1 652.48,837.37 pfet_05v0
M$185 VDD_DEC \$I2512 \$I2511 VDD_DEC pfet_05v0 L=1U W=1.22U AS=0.5368P
+ AD=0.5368P PS=3.32U PD=3.32U
* device instance $186 r0 *1 650.24,837.37 pfet_05v0
M$186 VDD_DEC \$I2510 \$I2509 VDD_DEC pfet_05v0 L=1U W=1.22U AS=0.5368P
+ AD=0.5368P PS=3.32U PD=3.32U
* device instance $187 r0 *1 656.96,835.15 nfet_05v0
M$187 \$I2516 \$I2515 VSS VSS nfet_05v0 L=1U W=0.82U AS=0.3608P AD=0.3608P
+ PS=2.52U PD=2.52U
* device instance $188 r0 *1 654.72,835.15 nfet_05v0
M$188 \$I2514 \$I2513 VSS VSS nfet_05v0 L=1U W=0.82U AS=0.3608P AD=0.3608P
+ PS=2.52U PD=2.52U
* device instance $189 r0 *1 652.48,835.15 nfet_05v0
M$189 \$I2512 \$I2511 VSS VSS nfet_05v0 L=1U W=0.82U AS=0.3608P AD=0.3608P
+ PS=2.52U PD=2.52U
* device instance $190 r0 *1 650.24,835.15 nfet_05v0
M$190 \$I2510 \$I2509 VSS VSS nfet_05v0 L=1U W=0.82U AS=0.3608P AD=0.3608P
+ PS=2.52U PD=2.52U
* device instance $191 r0 *1 599.84,837.37 pfet_05v0
M$191 VDD_DEC \$I2524 \$I2523 VDD_DEC pfet_05v0 L=1U W=1.22U AS=0.5368P
+ AD=0.5368P PS=3.32U PD=3.32U
* device instance $192 r0 *1 597.6,837.37 pfet_05v0
M$192 VDD_DEC \$I2522 \$I2521 VDD_DEC pfet_05v0 L=1U W=1.22U AS=0.5368P
+ AD=0.5368P PS=3.32U PD=3.32U
* device instance $193 r0 *1 595.36,837.37 pfet_05v0
M$193 VDD_DEC \$I2520 \$I2519 VDD_DEC pfet_05v0 L=1U W=1.22U AS=0.5368P
+ AD=0.5368P PS=3.32U PD=3.32U
* device instance $194 r0 *1 593.12,837.37 pfet_05v0
M$194 VDD_DEC \$I2518 \$I2517 VDD_DEC pfet_05v0 L=1U W=1.22U AS=0.5368P
+ AD=0.5368P PS=3.32U PD=3.32U
* device instance $195 r0 *1 599.84,835.15 nfet_05v0
M$195 \$I2524 \$I2523 VSS VSS nfet_05v0 L=1U W=0.82U AS=0.3608P AD=0.3608P
+ PS=2.52U PD=2.52U
* device instance $196 r0 *1 597.6,835.15 nfet_05v0
M$196 \$I2522 \$I2521 VSS VSS nfet_05v0 L=1U W=0.82U AS=0.3608P AD=0.3608P
+ PS=2.52U PD=2.52U
* device instance $197 r0 *1 595.36,835.15 nfet_05v0
M$197 \$I2520 \$I2519 VSS VSS nfet_05v0 L=1U W=0.82U AS=0.3608P AD=0.3608P
+ PS=2.52U PD=2.52U
* device instance $198 r0 *1 593.12,835.15 nfet_05v0
M$198 \$I2518 \$I2517 VSS VSS nfet_05v0 L=1U W=0.82U AS=0.3608P AD=0.3608P
+ PS=2.52U PD=2.52U
* device instance $199 r0 *1 514.72,837.37 pfet_05v0
M$199 VDD_DEC \$I2532 \$I2531 VDD_DEC pfet_05v0 L=1U W=1.22U AS=0.5368P
+ AD=0.5368P PS=3.32U PD=3.32U
* device instance $200 r0 *1 512.48,837.37 pfet_05v0
M$200 VDD_DEC \$I2530 \$I2529 VDD_DEC pfet_05v0 L=1U W=1.22U AS=0.5368P
+ AD=0.5368P PS=3.32U PD=3.32U
* device instance $201 r0 *1 510.24,837.37 pfet_05v0
M$201 VDD_DEC \$I2528 \$I2527 VDD_DEC pfet_05v0 L=1U W=1.22U AS=0.5368P
+ AD=0.5368P PS=3.32U PD=3.32U
* device instance $202 r0 *1 508,837.37 pfet_05v0
M$202 VDD_DEC \$I2526 \$I2525 VDD_DEC pfet_05v0 L=1U W=1.22U AS=0.5368P
+ AD=0.5368P PS=3.32U PD=3.32U
* device instance $203 r0 *1 514.72,835.15 nfet_05v0
M$203 \$I2532 \$I2531 VSS VSS nfet_05v0 L=1U W=0.82U AS=0.3608P AD=0.3608P
+ PS=2.52U PD=2.52U
* device instance $204 r0 *1 512.48,835.15 nfet_05v0
M$204 \$I2530 \$I2529 VSS VSS nfet_05v0 L=1U W=0.82U AS=0.3608P AD=0.3608P
+ PS=2.52U PD=2.52U
* device instance $205 r0 *1 510.24,835.15 nfet_05v0
M$205 \$I2528 \$I2527 VSS VSS nfet_05v0 L=1U W=0.82U AS=0.3608P AD=0.3608P
+ PS=2.52U PD=2.52U
* device instance $206 r0 *1 508,835.15 nfet_05v0
M$206 \$I2526 \$I2525 VSS VSS nfet_05v0 L=1U W=0.82U AS=0.3608P AD=0.3608P
+ PS=2.52U PD=2.52U
* device instance $207 r0 *1 495.68,829.53 pfet_05v0
M$207 VDD_DEC \$I2540 \$I2539 VDD_DEC pfet_05v0 L=1U W=1.22U AS=0.5368P
+ AD=0.5368P PS=3.32U PD=3.32U
* device instance $208 r0 *1 493.44,829.53 pfet_05v0
M$208 VDD_DEC \$I2538 \$I2537 VDD_DEC pfet_05v0 L=1U W=1.22U AS=0.5368P
+ AD=0.5368P PS=3.32U PD=3.32U
* device instance $209 r0 *1 491.2,829.53 pfet_05v0
M$209 VDD_DEC \$I2536 \$I2535 VDD_DEC pfet_05v0 L=1U W=1.22U AS=0.5368P
+ AD=0.5368P PS=3.32U PD=3.32U
* device instance $210 r0 *1 488.96,829.53 pfet_05v0
M$210 VDD_DEC \$I2534 \$I2533 VDD_DEC pfet_05v0 L=1U W=1.22U AS=0.5368P
+ AD=0.5368P PS=3.32U PD=3.32U
* device instance $211 r0 *1 495.68,827.31 nfet_05v0
M$211 \$I2540 \$I2539 VSS VSS nfet_05v0 L=1U W=0.82U AS=0.3608P AD=0.3608P
+ PS=2.52U PD=2.52U
* device instance $212 r0 *1 493.44,827.31 nfet_05v0
M$212 \$I2538 \$I2537 VSS VSS nfet_05v0 L=1U W=0.82U AS=0.3608P AD=0.3608P
+ PS=2.52U PD=2.52U
* device instance $213 r0 *1 491.2,827.31 nfet_05v0
M$213 \$I2536 \$I2535 VSS VSS nfet_05v0 L=1U W=0.82U AS=0.3608P AD=0.3608P
+ PS=2.52U PD=2.52U
* device instance $214 r0 *1 488.96,827.31 nfet_05v0
M$214 \$I2534 \$I2533 VSS VSS nfet_05v0 L=1U W=0.82U AS=0.3608P AD=0.3608P
+ PS=2.52U PD=2.52U
* device instance $215 m90 *1 523.83,837.37 pfet_05v0
M$215 \$I2542 \$I2426 VDD_DEC VDD_DEC pfet_05v0 L=0.5U W=1.22U AS=0.5368P
+ AD=0.3172P PS=3.32U PD=1.74U
* device instance $216 m90 *1 522.81,837.37 pfet_05v0
M$216 \$I2541 \$I2200 \$I2542 VDD_DEC pfet_05v0 L=0.5U W=1.22U AS=0.3172P
+ AD=0.3782P PS=1.74U PD=1.84U
* device instance $217 m90 *1 521.69,837.37 pfet_05v0
M$217 \$I2202 \$I2201 \$I2541 VDD_DEC pfet_05v0 L=0.5U W=1.22U AS=0.3782P
+ AD=0.5368P PS=1.84U PD=3.32U
* device instance $218 m90 *1 523.88,835.157 nfet_05v0
M$218 \$I2202 \$I2426 VSS VSS nfet_05v0 L=0.6U W=0.465U AS=0.2046P AD=0.1209P
+ PS=1.81U PD=0.985U
* device instance $219 m90 *1 522.76,835.157 nfet_05v0
M$219 VSS \$I2200 \$I2202 VSS nfet_05v0 L=0.6U W=0.465U AS=0.1209P AD=0.1209P
+ PS=0.985U PD=0.985U
* device instance $220 m90 *1 521.64,835.157 nfet_05v0
M$220 \$I2202 \$I2201 VSS VSS nfet_05v0 L=0.6U W=0.465U AS=0.1209P AD=0.2046P
+ PS=0.985U PD=1.81U
* device instance $221 m90 *1 611.19,813.85 pfet_05v0
M$221 \$I2544 \$I2368 VDD_DEC VDD_DEC pfet_05v0 L=0.5U W=1.22U AS=0.5368P
+ AD=0.3172P PS=3.32U PD=1.74U
* device instance $222 m90 *1 610.17,813.85 pfet_05v0
M$222 \$I2543 \$I2241 \$I2544 VDD_DEC pfet_05v0 L=0.5U W=1.22U AS=0.3172P
+ AD=0.3782P PS=1.74U PD=1.84U
* device instance $223 m90 *1 609.05,813.85 pfet_05v0
M$223 \$I2057 \$I2237 \$I2543 VDD_DEC pfet_05v0 L=0.5U W=1.22U AS=0.3782P
+ AD=0.5368P PS=1.84U PD=3.32U
* device instance $224 m90 *1 611.24,811.637 nfet_05v0
M$224 \$I2057 \$I2368 VSS VSS nfet_05v0 L=0.6U W=0.465U AS=0.2046P AD=0.1209P
+ PS=1.81U PD=0.985U
* device instance $225 m90 *1 610.12,811.637 nfet_05v0
M$225 VSS \$I2241 \$I2057 VSS nfet_05v0 L=0.6U W=0.465U AS=0.1209P AD=0.1209P
+ PS=0.985U PD=0.985U
* device instance $226 m90 *1 609,811.637 nfet_05v0
M$226 \$I2057 \$I2237 VSS VSS nfet_05v0 L=0.6U W=0.465U AS=0.1209P AD=0.2046P
+ PS=0.985U PD=1.81U
* device instance $227 m90 *1 628.55,813.85 pfet_05v0
M$227 \$I2546 \$I2277 VDD_DEC VDD_DEC pfet_05v0 L=0.5U W=1.22U AS=0.5368P
+ AD=0.3172P PS=3.32U PD=1.74U
* device instance $228 m90 *1 627.53,813.85 pfet_05v0
M$228 \$I2545 \$I2241 \$I2546 VDD_DEC pfet_05v0 L=0.5U W=1.22U AS=0.3172P
+ AD=0.3782P PS=1.74U PD=1.84U
* device instance $229 m90 *1 626.41,813.85 pfet_05v0
M$229 \$I2137 \$I2240 \$I2545 VDD_DEC pfet_05v0 L=0.5U W=1.22U AS=0.3782P
+ AD=0.5368P PS=1.84U PD=3.32U
* device instance $230 m90 *1 628.6,811.637 nfet_05v0
M$230 \$I2137 \$I2277 VSS VSS nfet_05v0 L=0.6U W=0.465U AS=0.2046P AD=0.1209P
+ PS=1.81U PD=0.985U
* device instance $231 m90 *1 627.48,811.637 nfet_05v0
M$231 VSS \$I2241 \$I2137 VSS nfet_05v0 L=0.6U W=0.465U AS=0.1209P AD=0.1209P
+ PS=0.985U PD=0.985U
* device instance $232 m90 *1 626.36,811.637 nfet_05v0
M$232 \$I2137 \$I2240 VSS VSS nfet_05v0 L=0.6U W=0.465U AS=0.1209P AD=0.2046P
+ PS=0.985U PD=1.81U
* device instance $233 m90 *1 528.31,829.53 pfet_05v0
M$233 \$I2548 \$I2381 VDD_DEC VDD_DEC pfet_05v0 L=0.5U W=1.22U AS=0.5368P
+ AD=0.3172P PS=3.32U PD=1.74U
* device instance $234 m90 *1 527.29,829.53 pfet_05v0
M$234 \$I2547 \$I2332 \$I2548 VDD_DEC pfet_05v0 L=0.5U W=1.22U AS=0.3172P
+ AD=0.3782P PS=1.74U PD=1.84U
* device instance $235 m90 *1 526.17,829.53 pfet_05v0
M$235 \$I2161 \$I2331 \$I2547 VDD_DEC pfet_05v0 L=0.5U W=1.22U AS=0.3782P
+ AD=0.5368P PS=1.84U PD=3.32U
* device instance $236 m90 *1 528.36,827.317 nfet_05v0
M$236 \$I2161 \$I2381 VSS VSS nfet_05v0 L=0.6U W=0.465U AS=0.2046P AD=0.1209P
+ PS=1.81U PD=0.985U
* device instance $237 m90 *1 527.24,827.317 nfet_05v0
M$237 VSS \$I2332 \$I2161 VSS nfet_05v0 L=0.6U W=0.465U AS=0.1209P AD=0.1209P
+ PS=0.985U PD=0.985U
* device instance $238 m90 *1 526.12,827.317 nfet_05v0
M$238 \$I2161 \$I2331 VSS VSS nfet_05v0 L=0.6U W=0.465U AS=0.1209P AD=0.2046P
+ PS=0.985U PD=1.81U
* device instance $239 m90 *1 569.19,829.53 pfet_05v0
M$239 \$I2550 \$I2426 VDD_DEC VDD_DEC pfet_05v0 L=0.5U W=1.22U AS=0.5368P
+ AD=0.3172P PS=3.32U PD=1.74U
* device instance $240 m90 *1 568.17,829.53 pfet_05v0
M$240 \$I2549 \$I2203 \$I2550 VDD_DEC pfet_05v0 L=0.5U W=1.22U AS=0.3172P
+ AD=0.3782P PS=1.74U PD=1.84U
* device instance $241 m90 *1 567.05,829.53 pfet_05v0
M$241 \$I2131 \$I2204 \$I2549 VDD_DEC pfet_05v0 L=0.5U W=1.22U AS=0.3782P
+ AD=0.5368P PS=1.84U PD=3.32U
* device instance $242 m90 *1 569.24,827.317 nfet_05v0
M$242 \$I2131 \$I2426 VSS VSS nfet_05v0 L=0.6U W=0.465U AS=0.2046P AD=0.1209P
+ PS=1.81U PD=0.985U
* device instance $243 m90 *1 568.12,827.317 nfet_05v0
M$243 VSS \$I2203 \$I2131 VSS nfet_05v0 L=0.6U W=0.465U AS=0.1209P AD=0.1209P
+ PS=0.985U PD=0.985U
* device instance $244 m90 *1 567,827.317 nfet_05v0
M$244 \$I2131 \$I2204 VSS VSS nfet_05v0 L=0.6U W=0.465U AS=0.1209P AD=0.2046P
+ PS=0.985U PD=1.81U
* device instance $245 m90 *1 505.35,829.53 pfet_05v0
M$245 \$I2552 \$I2400 VDD_DEC VDD_DEC pfet_05v0 L=0.5U W=1.22U AS=0.5368P
+ AD=0.3172P PS=3.32U PD=1.74U
* device instance $246 m90 *1 504.33,829.53 pfet_05v0
M$246 \$I2551 \$I2197 \$I2552 VDD_DEC pfet_05v0 L=0.5U W=1.22U AS=0.3172P
+ AD=0.3782P PS=1.74U PD=1.84U
* device instance $247 m90 *1 503.21,829.53 pfet_05v0
M$247 \$I2123 \$I2196 \$I2551 VDD_DEC pfet_05v0 L=0.5U W=1.22U AS=0.3782P
+ AD=0.5368P PS=1.84U PD=3.32U
* device instance $248 m90 *1 505.4,827.317 nfet_05v0
M$248 \$I2123 \$I2400 VSS VSS nfet_05v0 L=0.6U W=0.465U AS=0.2046P AD=0.1209P
+ PS=1.81U PD=0.985U
* device instance $249 m90 *1 504.28,827.317 nfet_05v0
M$249 VSS \$I2197 \$I2123 VSS nfet_05v0 L=0.6U W=0.465U AS=0.1209P AD=0.1209P
+ PS=0.985U PD=0.985U
* device instance $250 m90 *1 503.16,827.317 nfet_05v0
M$250 \$I2123 \$I2196 VSS VSS nfet_05v0 L=0.6U W=0.465U AS=0.1209P AD=0.2046P
+ PS=0.985U PD=1.81U
* device instance $251 m90 *1 548.47,837.37 pfet_05v0
M$251 \$I2554 \$I2431 VDD_DEC VDD_DEC pfet_05v0 L=0.5U W=1.22U AS=0.5368P
+ AD=0.3172P PS=3.32U PD=1.74U
* device instance $252 m90 *1 547.45,837.37 pfet_05v0
M$252 \$I2553 \$I2418 \$I2554 VDD_DEC pfet_05v0 L=0.5U W=1.22U AS=0.3172P
+ AD=0.3782P PS=1.74U PD=1.84U
* device instance $253 m90 *1 546.33,837.37 pfet_05v0
M$253 \$I2051 \$I2359 \$I2553 VDD_DEC pfet_05v0 L=0.5U W=1.22U AS=0.3782P
+ AD=0.5368P PS=1.84U PD=3.32U
* device instance $254 m90 *1 548.52,835.157 nfet_05v0
M$254 \$I2051 \$I2431 VSS VSS nfet_05v0 L=0.6U W=0.465U AS=0.2046P AD=0.1209P
+ PS=1.81U PD=0.985U
* device instance $255 m90 *1 547.4,835.157 nfet_05v0
M$255 VSS \$I2418 \$I2051 VSS nfet_05v0 L=0.6U W=0.465U AS=0.1209P AD=0.1209P
+ PS=0.985U PD=0.985U
* device instance $256 m90 *1 546.28,835.157 nfet_05v0
M$256 \$I2051 \$I2359 VSS VSS nfet_05v0 L=0.6U W=0.465U AS=0.1209P AD=0.2046P
+ PS=0.985U PD=1.81U
* device instance $257 m90 *1 559.11,829.53 pfet_05v0
M$257 \$I2556 \$I2427 VDD_DEC VDD_DEC pfet_05v0 L=0.5U W=1.22U AS=0.5368P
+ AD=0.3172P PS=3.32U PD=1.74U
* device instance $258 m90 *1 558.09,829.53 pfet_05v0
M$258 \$I2555 \$I2418 \$I2556 VDD_DEC pfet_05v0 L=0.5U W=1.22U AS=0.3172P
+ AD=0.3782P PS=1.74U PD=1.84U
* device instance $259 m90 *1 556.97,829.53 pfet_05v0
M$259 \$I2279 \$I2359 \$I2555 VDD_DEC pfet_05v0 L=0.5U W=1.22U AS=0.3782P
+ AD=0.5368P PS=1.84U PD=3.32U
* device instance $260 m90 *1 559.16,827.317 nfet_05v0
M$260 \$I2279 \$I2427 VSS VSS nfet_05v0 L=0.6U W=0.465U AS=0.2046P AD=0.1209P
+ PS=1.81U PD=0.985U
* device instance $261 m90 *1 558.04,827.317 nfet_05v0
M$261 VSS \$I2418 \$I2279 VSS nfet_05v0 L=0.6U W=0.465U AS=0.1209P AD=0.1209P
+ PS=0.985U PD=0.985U
* device instance $262 m90 *1 556.92,827.317 nfet_05v0
M$262 \$I2279 \$I2359 VSS VSS nfet_05v0 L=0.6U W=0.465U AS=0.1209P AD=0.2046P
+ PS=0.985U PD=1.81U
* device instance $263 m90 *1 523.83,829.53 pfet_05v0
M$263 \$I2558 \$I2277 VDD_DEC VDD_DEC pfet_05v0 L=0.5U W=1.22U AS=0.5368P
+ AD=0.3172P PS=3.32U PD=1.74U
* device instance $264 m90 *1 522.81,829.53 pfet_05v0
M$264 \$I2557 \$I2332 \$I2558 VDD_DEC pfet_05v0 L=0.5U W=1.22U AS=0.3172P
+ AD=0.3782P PS=1.74U PD=1.84U
* device instance $265 m90 *1 521.69,829.53 pfet_05v0
M$265 \$I2021 \$I2359 \$I2557 VDD_DEC pfet_05v0 L=0.5U W=1.22U AS=0.3782P
+ AD=0.5368P PS=1.84U PD=3.32U
* device instance $266 m90 *1 523.88,827.317 nfet_05v0
M$266 \$I2021 \$I2277 VSS VSS nfet_05v0 L=0.6U W=0.465U AS=0.2046P AD=0.1209P
+ PS=1.81U PD=0.985U
* device instance $267 m90 *1 522.76,827.317 nfet_05v0
M$267 VSS \$I2332 \$I2021 VSS nfet_05v0 L=0.6U W=0.465U AS=0.1209P AD=0.1209P
+ PS=0.985U PD=0.985U
* device instance $268 m90 *1 521.64,827.317 nfet_05v0
M$268 \$I2021 \$I2359 VSS VSS nfet_05v0 L=0.6U W=0.465U AS=0.1209P AD=0.2046P
+ PS=0.985U PD=1.81U
* device instance $269 m90 *1 505.35,821.69 pfet_05v0
M$269 \$I2560 \$I2405 VDD_DEC VDD_DEC pfet_05v0 L=0.5U W=1.22U AS=0.5368P
+ AD=0.3172P PS=3.32U PD=1.74U
* device instance $270 m90 *1 504.33,821.69 pfet_05v0
M$270 \$I2559 \$I2200 \$I2560 VDD_DEC pfet_05v0 L=0.5U W=1.22U AS=0.3172P
+ AD=0.3782P PS=1.74U PD=1.84U
* device instance $271 m90 *1 503.21,821.69 pfet_05v0
M$271 \$I2053 \$I2201 \$I2559 VDD_DEC pfet_05v0 L=0.5U W=1.22U AS=0.3782P
+ AD=0.5368P PS=1.84U PD=3.32U
* device instance $272 m90 *1 505.4,819.477 nfet_05v0
M$272 \$I2053 \$I2405 VSS VSS nfet_05v0 L=0.6U W=0.465U AS=0.2046P AD=0.1209P
+ PS=1.81U PD=0.985U
* device instance $273 m90 *1 504.28,819.477 nfet_05v0
M$273 VSS \$I2200 \$I2053 VSS nfet_05v0 L=0.6U W=0.465U AS=0.1209P AD=0.1209P
+ PS=0.985U PD=0.985U
* device instance $274 m90 *1 503.16,819.477 nfet_05v0
M$274 \$I2053 \$I2201 VSS VSS nfet_05v0 L=0.6U W=0.465U AS=0.1209P AD=0.2046P
+ PS=0.985U PD=1.81U
* device instance $275 m0 *1 570.57,823.59 pfet_05v0
M$275 \$I2562 \$I2406 VDD_DEC VDD_DEC pfet_05v0 L=0.5U W=1.22U AS=0.5368P
+ AD=0.3172P PS=3.32U PD=1.74U
* device instance $276 m0 *1 571.59,823.59 pfet_05v0
M$276 \$I2561 \$I2207 \$I2562 VDD_DEC pfet_05v0 L=0.5U W=1.22U AS=0.3172P
+ AD=0.3782P PS=1.74U PD=1.84U
* device instance $277 m0 *1 572.71,823.59 pfet_05v0
M$277 \$I2210 \$I2237 \$I2561 VDD_DEC pfet_05v0 L=0.5U W=1.22U AS=0.3782P
+ AD=0.5368P PS=1.84U PD=3.32U
* device instance $278 m0 *1 570.52,825.803 nfet_05v0
M$278 \$I2210 \$I2406 VSS VSS nfet_05v0 L=0.6U W=0.465U AS=0.2046P AD=0.1209P
+ PS=1.81U PD=0.985U
* device instance $279 m0 *1 571.64,825.803 nfet_05v0
M$279 VSS \$I2207 \$I2210 VSS nfet_05v0 L=0.6U W=0.465U AS=0.1209P AD=0.1209P
+ PS=0.985U PD=0.985U
* device instance $280 m0 *1 572.76,825.803 nfet_05v0
M$280 \$I2210 \$I2237 VSS VSS nfet_05v0 L=0.6U W=0.465U AS=0.1209P AD=0.2046P
+ PS=0.985U PD=1.81U
* device instance $281 m0 *1 528.01,792.23 pfet_05v0
M$281 \$I2564 \$I2234 VDD_DEC VDD_DEC pfet_05v0 L=0.5U W=1.22U AS=0.5368P
+ AD=0.3172P PS=3.32U PD=1.74U
* device instance $282 m0 *1 529.03,792.23 pfet_05v0
M$282 \$I2563 \$I2203 \$I2564 VDD_DEC pfet_05v0 L=0.5U W=1.22U AS=0.3172P
+ AD=0.3782P PS=1.74U PD=1.84U
* device instance $283 m0 *1 530.15,792.23 pfet_05v0
M$283 \$I2127 \$I2204 \$I2563 VDD_DEC pfet_05v0 L=0.5U W=1.22U AS=0.3782P
+ AD=0.5368P PS=1.84U PD=3.32U
* device instance $284 m0 *1 527.96,794.443 nfet_05v0
M$284 \$I2127 \$I2234 VSS VSS nfet_05v0 L=0.6U W=0.465U AS=0.2046P AD=0.1209P
+ PS=1.81U PD=0.985U
* device instance $285 m0 *1 529.08,794.443 nfet_05v0
M$285 VSS \$I2203 \$I2127 VSS nfet_05v0 L=0.6U W=0.465U AS=0.1209P AD=0.1209P
+ PS=0.985U PD=0.985U
* device instance $286 m0 *1 530.2,794.443 nfet_05v0
M$286 \$I2127 \$I2204 VSS VSS nfet_05v0 L=0.6U W=0.465U AS=0.1209P AD=0.2046P
+ PS=0.985U PD=1.81U
* device instance $287 m0 *1 619.85,800.07 pfet_05v0
M$287 \$I2566 \$I2234 VDD_DEC VDD_DEC pfet_05v0 L=0.5U W=1.22U AS=0.5368P
+ AD=0.3172P PS=3.32U PD=1.74U
* device instance $288 m0 *1 620.87,800.07 pfet_05v0
M$288 \$I2565 \$I2241 \$I2566 VDD_DEC pfet_05v0 L=0.5U W=1.22U AS=0.3172P
+ AD=0.3782P PS=1.74U PD=1.84U
* device instance $289 m0 *1 621.99,800.07 pfet_05v0
M$289 \$I2257 \$I2240 \$I2565 VDD_DEC pfet_05v0 L=0.5U W=1.22U AS=0.3782P
+ AD=0.5368P PS=1.84U PD=3.32U
* device instance $290 m0 *1 619.8,802.283 nfet_05v0
M$290 \$I2257 \$I2234 VSS VSS nfet_05v0 L=0.6U W=0.465U AS=0.2046P AD=0.1209P
+ PS=1.81U PD=0.985U
* device instance $291 m0 *1 620.92,802.283 nfet_05v0
M$291 VSS \$I2241 \$I2257 VSS nfet_05v0 L=0.6U W=0.465U AS=0.1209P AD=0.1209P
+ PS=0.985U PD=0.985U
* device instance $292 m0 *1 622.04,802.283 nfet_05v0
M$292 \$I2257 \$I2240 VSS VSS nfet_05v0 L=0.6U W=0.465U AS=0.1209P AD=0.2046P
+ PS=0.985U PD=1.81U
* device instance $293 m0 *1 645.61,807.91 pfet_05v0
M$293 \$I2568 \$I2405 VDD_DEC VDD_DEC pfet_05v0 L=0.5U W=1.22U AS=0.5368P
+ AD=0.3172P PS=3.32U PD=1.74U
* device instance $294 m0 *1 646.63,807.91 pfet_05v0
M$294 \$I2567 \$I2140 \$I2568 VDD_DEC pfet_05v0 L=0.5U W=1.22U AS=0.3172P
+ AD=0.3782P PS=1.74U PD=1.84U
* device instance $295 m0 *1 647.75,807.91 pfet_05v0
M$295 \$I2327 \$I2138 \$I2567 VDD_DEC pfet_05v0 L=0.5U W=1.22U AS=0.3782P
+ AD=0.5368P PS=1.84U PD=3.32U
* device instance $296 m0 *1 645.56,810.123 nfet_05v0
M$296 \$I2327 \$I2405 VSS VSS nfet_05v0 L=0.6U W=0.465U AS=0.2046P AD=0.1209P
+ PS=1.81U PD=0.985U
* device instance $297 m0 *1 646.68,810.123 nfet_05v0
M$297 VSS \$I2140 \$I2327 VSS nfet_05v0 L=0.6U W=0.465U AS=0.1209P AD=0.1209P
+ PS=0.985U PD=0.985U
* device instance $298 m0 *1 647.8,810.123 nfet_05v0
M$298 \$I2327 \$I2138 VSS VSS nfet_05v0 L=0.6U W=0.465U AS=0.1209P AD=0.2046P
+ PS=0.985U PD=1.81U
* device instance $299 m0 *1 610.89,823.59 pfet_05v0
M$299 \$I2570 \$I2368 VDD_DEC VDD_DEC pfet_05v0 L=0.5U W=1.22U AS=0.5368P
+ AD=0.3172P PS=3.32U PD=1.74U
* device instance $300 m0 *1 611.91,823.59 pfet_05v0
M$300 \$I2569 \$I2285 \$I2570 VDD_DEC pfet_05v0 L=0.5U W=1.22U AS=0.3172P
+ AD=0.3782P PS=1.74U PD=1.84U
* device instance $301 m0 *1 613.03,823.59 pfet_05v0
M$301 \$I2420 \$I2214 \$I2569 VDD_DEC pfet_05v0 L=0.5U W=1.22U AS=0.3782P
+ AD=0.5368P PS=1.84U PD=3.32U
* device instance $302 m0 *1 610.84,825.803 nfet_05v0
M$302 \$I2420 \$I2368 VSS VSS nfet_05v0 L=0.6U W=0.465U AS=0.2046P AD=0.1209P
+ PS=1.81U PD=0.985U
* device instance $303 m0 *1 611.96,825.803 nfet_05v0
M$303 VSS \$I2285 \$I2420 VSS nfet_05v0 L=0.6U W=0.465U AS=0.1209P AD=0.1209P
+ PS=0.985U PD=0.985U
* device instance $304 m0 *1 613.08,825.803 nfet_05v0
M$304 \$I2420 \$I2214 VSS VSS nfet_05v0 L=0.6U W=0.465U AS=0.1209P AD=0.2046P
+ PS=0.985U PD=1.81U
* device instance $305 m0 *1 615.93,823.59 pfet_05v0
M$305 \$I2572 \$I2400 VDD_DEC VDD_DEC pfet_05v0 L=0.5U W=1.22U AS=0.5368P
+ AD=0.3172P PS=3.32U PD=1.74U
* device instance $306 m0 *1 616.95,823.59 pfet_05v0
M$306 \$I2571 \$I2286 \$I2572 VDD_DEC pfet_05v0 L=0.5U W=1.22U AS=0.3172P
+ AD=0.3782P PS=1.74U PD=1.84U
* device instance $307 m0 *1 618.07,823.59 pfet_05v0
M$307 \$I2246 \$I2214 \$I2571 VDD_DEC pfet_05v0 L=0.5U W=1.22U AS=0.3782P
+ AD=0.5368P PS=1.84U PD=3.32U
* device instance $308 m0 *1 615.88,825.803 nfet_05v0
M$308 \$I2246 \$I2400 VSS VSS nfet_05v0 L=0.6U W=0.465U AS=0.2046P AD=0.1209P
+ PS=1.81U PD=0.985U
* device instance $309 m0 *1 617,825.803 nfet_05v0
M$309 VSS \$I2286 \$I2246 VSS nfet_05v0 L=0.6U W=0.465U AS=0.1209P AD=0.1209P
+ PS=0.985U PD=0.985U
* device instance $310 m0 *1 618.12,825.803 nfet_05v0
M$310 \$I2246 \$I2214 VSS VSS nfet_05v0 L=0.6U W=0.465U AS=0.1209P AD=0.2046P
+ PS=0.985U PD=1.81U
* device instance $311 m0 *1 600.81,815.75 pfet_05v0
M$311 \$I2574 \$I2340 VDD_DEC VDD_DEC pfet_05v0 L=0.5U W=1.22U AS=0.5368P
+ AD=0.3172P PS=3.32U PD=1.74U
* device instance $312 m0 *1 601.83,815.75 pfet_05v0
M$312 \$I2573 \$I2285 \$I2574 VDD_DEC pfet_05v0 L=0.5U W=1.22U AS=0.3172P
+ AD=0.3782P PS=1.74U PD=1.84U
* device instance $313 m0 *1 602.95,815.75 pfet_05v0
M$313 \$I2104 \$I2214 \$I2573 VDD_DEC pfet_05v0 L=0.5U W=1.22U AS=0.3782P
+ AD=0.5368P PS=1.84U PD=3.32U
* device instance $314 m0 *1 600.76,817.963 nfet_05v0
M$314 \$I2104 \$I2340 VSS VSS nfet_05v0 L=0.6U W=0.465U AS=0.2046P AD=0.1209P
+ PS=1.81U PD=0.985U
* device instance $315 m0 *1 601.88,817.963 nfet_05v0
M$315 VSS \$I2285 \$I2104 VSS nfet_05v0 L=0.6U W=0.465U AS=0.1209P AD=0.1209P
+ PS=0.985U PD=0.985U
* device instance $316 m0 *1 603,817.963 nfet_05v0
M$316 \$I2104 \$I2214 VSS VSS nfet_05v0 L=0.6U W=0.465U AS=0.1209P AD=0.2046P
+ PS=0.985U PD=1.81U
* device instance $317 m0 *1 595.21,815.75 pfet_05v0
M$317 \$I2576 \$I2381 VDD_DEC VDD_DEC pfet_05v0 L=0.5U W=1.22U AS=0.5368P
+ AD=0.3172P PS=3.32U PD=1.74U
* device instance $318 m0 *1 596.23,815.75 pfet_05v0
M$318 \$I2575 \$I2311 \$I2576 VDD_DEC pfet_05v0 L=0.5U W=1.22U AS=0.3172P
+ AD=0.3782P PS=1.74U PD=1.84U
* device instance $319 m0 *1 597.35,815.75 pfet_05v0
M$319 \$I2174 \$I2252 \$I2575 VDD_DEC pfet_05v0 L=0.5U W=1.22U AS=0.3782P
+ AD=0.5368P PS=1.84U PD=3.32U
* device instance $320 m0 *1 595.16,817.963 nfet_05v0
M$320 \$I2174 \$I2381 VSS VSS nfet_05v0 L=0.6U W=0.465U AS=0.2046P AD=0.1209P
+ PS=1.81U PD=0.985U
* device instance $321 m0 *1 596.28,817.963 nfet_05v0
M$321 VSS \$I2311 \$I2174 VSS nfet_05v0 L=0.6U W=0.465U AS=0.1209P AD=0.1209P
+ PS=0.985U PD=0.985U
* device instance $322 m0 *1 597.4,817.963 nfet_05v0
M$322 \$I2174 \$I2252 VSS VSS nfet_05v0 L=0.6U W=0.465U AS=0.1209P AD=0.2046P
+ PS=0.985U PD=1.81U
* device instance $323 r180 *1 511.51,831.43 pfet_05v0
M$323 \$I2578 \$I2431 VDD_DEC VDD_DEC pfet_05v0 L=0.5U W=1.22U AS=0.5368P
+ AD=0.3172P PS=3.32U PD=1.74U
* device instance $324 r180 *1 510.49,831.43 pfet_05v0
M$324 \$I2577 \$I2197 \$I2578 VDD_DEC pfet_05v0 L=0.5U W=1.22U AS=0.3172P
+ AD=0.3782P PS=1.74U PD=1.84U
* device instance $325 r180 *1 509.37,831.43 pfet_05v0
M$325 \$I2306 \$I2196 \$I2577 VDD_DEC pfet_05v0 L=0.5U W=1.22U AS=0.3782P
+ AD=0.5368P PS=1.84U PD=3.32U
* device instance $326 r180 *1 511.56,833.643 nfet_05v0
M$326 \$I2306 \$I2431 VSS VSS nfet_05v0 L=0.6U W=0.465U AS=0.2046P AD=0.1209P
+ PS=1.81U PD=0.985U
* device instance $327 r180 *1 510.44,833.643 nfet_05v0
M$327 VSS \$I2197 \$I2306 VSS nfet_05v0 L=0.6U W=0.465U AS=0.1209P AD=0.1209P
+ PS=0.985U PD=0.985U
* device instance $328 r180 *1 509.32,833.643 nfet_05v0
M$328 \$I2306 \$I2196 VSS VSS nfet_05v0 L=0.6U W=0.465U AS=0.1209P AD=0.2046P
+ PS=0.985U PD=1.81U
* device instance $329 r180 *1 515.99,831.43 pfet_05v0
M$329 \$I2580 \$I2427 VDD_DEC VDD_DEC pfet_05v0 L=0.5U W=1.22U AS=0.5368P
+ AD=0.3172P PS=3.32U PD=1.74U
* device instance $330 r180 *1 514.97,831.43 pfet_05v0
M$330 \$I2579 \$I2200 \$I2580 VDD_DEC pfet_05v0 L=0.5U W=1.22U AS=0.3172P
+ AD=0.3782P PS=1.74U PD=1.84U
* device instance $331 r180 *1 513.85,831.43 pfet_05v0
M$331 \$I2019 \$I2196 \$I2579 VDD_DEC pfet_05v0 L=0.5U W=1.22U AS=0.3782P
+ AD=0.5368P PS=1.84U PD=3.32U
* device instance $332 r180 *1 516.04,833.643 nfet_05v0
M$332 \$I2019 \$I2427 VSS VSS nfet_05v0 L=0.6U W=0.465U AS=0.2046P AD=0.1209P
+ PS=1.81U PD=0.985U
* device instance $333 r180 *1 514.92,833.643 nfet_05v0
M$333 VSS \$I2200 \$I2019 VSS nfet_05v0 L=0.6U W=0.465U AS=0.1209P AD=0.1209P
+ PS=0.985U PD=0.985U
* device instance $334 r180 *1 513.8,833.643 nfet_05v0
M$334 \$I2019 \$I2196 VSS VSS nfet_05v0 L=0.6U W=0.465U AS=0.1209P AD=0.2046P
+ PS=0.985U PD=1.81U
* device instance $335 r180 *1 520.47,831.43 pfet_05v0
M$335 \$I2582 \$I2406 VDD_DEC VDD_DEC pfet_05v0 L=0.5U W=1.22U AS=0.5368P
+ AD=0.3172P PS=3.32U PD=1.74U
* device instance $336 r180 *1 519.45,831.43 pfet_05v0
M$336 \$I2581 \$I2332 \$I2582 VDD_DEC pfet_05v0 L=0.5U W=1.22U AS=0.3172P
+ AD=0.3782P PS=1.74U PD=1.84U
* device instance $337 r180 *1 518.33,831.43 pfet_05v0
M$337 \$I2307 \$I2331 \$I2581 VDD_DEC pfet_05v0 L=0.5U W=1.22U AS=0.3782P
+ AD=0.5368P PS=1.84U PD=3.32U
* device instance $338 r180 *1 520.52,833.643 nfet_05v0
M$338 \$I2307 \$I2406 VSS VSS nfet_05v0 L=0.6U W=0.465U AS=0.2046P AD=0.1209P
+ PS=1.81U PD=0.985U
* device instance $339 r180 *1 519.4,833.643 nfet_05v0
M$339 VSS \$I2332 \$I2307 VSS nfet_05v0 L=0.6U W=0.465U AS=0.1209P AD=0.1209P
+ PS=0.985U PD=0.985U
* device instance $340 r180 *1 518.28,833.643 nfet_05v0
M$340 \$I2307 \$I2331 VSS VSS nfet_05v0 L=0.6U W=0.465U AS=0.1209P AD=0.2046P
+ PS=0.985U PD=1.81U
* device instance $341 r180 *1 585.43,823.59 pfet_05v0
M$341 \$I2584 \$I2400 VDD_DEC VDD_DEC pfet_05v0 L=0.5U W=1.22U AS=0.5368P
+ AD=0.3172P PS=3.32U PD=1.74U
* device instance $342 r180 *1 584.41,823.59 pfet_05v0
M$342 \$I2583 \$I2173 \$I2584 VDD_DEC pfet_05v0 L=0.5U W=1.22U AS=0.3172P
+ AD=0.3782P PS=1.74U PD=1.84U
* device instance $343 r180 *1 583.29,823.59 pfet_05v0
M$343 \$I2068 \$I2172 \$I2583 VDD_DEC pfet_05v0 L=0.5U W=1.22U AS=0.3782P
+ AD=0.5368P PS=1.84U PD=3.32U
* device instance $344 r180 *1 585.48,825.803 nfet_05v0
M$344 \$I2068 \$I2400 VSS VSS nfet_05v0 L=0.6U W=0.465U AS=0.2046P AD=0.1209P
+ PS=1.81U PD=0.985U
* device instance $345 r180 *1 584.36,825.803 nfet_05v0
M$345 VSS \$I2173 \$I2068 VSS nfet_05v0 L=0.6U W=0.465U AS=0.1209P AD=0.1209P
+ PS=0.985U PD=0.985U
* device instance $346 r180 *1 583.24,825.803 nfet_05v0
M$346 \$I2068 \$I2172 VSS VSS nfet_05v0 L=0.6U W=0.465U AS=0.1209P AD=0.2046P
+ PS=0.985U PD=1.81U
* device instance $347 r180 *1 510.39,823.59 pfet_05v0
M$347 \$I2586 \$I2234 VDD_DEC VDD_DEC pfet_05v0 L=0.5U W=1.22U AS=0.5368P
+ AD=0.3172P PS=3.32U PD=1.74U
* device instance $348 r180 *1 509.37,823.59 pfet_05v0
M$348 \$I2585 \$I2200 \$I2586 VDD_DEC pfet_05v0 L=0.5U W=1.22U AS=0.3172P
+ AD=0.3782P PS=1.74U PD=1.84U
* device instance $349 r180 *1 508.25,823.59 pfet_05v0
M$349 \$I2020 \$I2201 \$I2585 VDD_DEC pfet_05v0 L=0.5U W=1.22U AS=0.3782P
+ AD=0.5368P PS=1.84U PD=3.32U
* device instance $350 r180 *1 510.44,825.803 nfet_05v0
M$350 \$I2020 \$I2234 VSS VSS nfet_05v0 L=0.6U W=0.465U AS=0.2046P AD=0.1209P
+ PS=1.81U PD=0.985U
* device instance $351 r180 *1 509.32,825.803 nfet_05v0
M$351 VSS \$I2200 \$I2020 VSS nfet_05v0 L=0.6U W=0.465U AS=0.1209P AD=0.1209P
+ PS=0.985U PD=0.985U
* device instance $352 r180 *1 508.2,825.803 nfet_05v0
M$352 \$I2020 \$I2201 VSS VSS nfet_05v0 L=0.6U W=0.465U AS=0.1209P AD=0.2046P
+ PS=0.985U PD=1.81U
* device instance $353 r180 *1 588.79,807.91 pfet_05v0
M$353 \$I2588 \$I2340 VDD_DEC VDD_DEC pfet_05v0 L=0.5U W=1.22U AS=0.5368P
+ AD=0.3172P PS=3.32U PD=1.74U
* device instance $354 r180 *1 587.77,807.91 pfet_05v0
M$354 \$I2587 \$I2212 \$I2588 VDD_DEC pfet_05v0 L=0.5U W=1.22U AS=0.3172P
+ AD=0.3782P PS=1.74U PD=1.84U
* device instance $355 r180 *1 586.65,807.91 pfet_05v0
M$355 \$I2235 \$I2237 \$I2587 VDD_DEC pfet_05v0 L=0.5U W=1.22U AS=0.3782P
+ AD=0.5368P PS=1.84U PD=3.32U
* device instance $356 r180 *1 588.84,810.123 nfet_05v0
M$356 \$I2235 \$I2340 VSS VSS nfet_05v0 L=0.6U W=0.465U AS=0.2046P AD=0.1209P
+ PS=1.81U PD=0.985U
* device instance $357 r180 *1 587.72,810.123 nfet_05v0
M$357 VSS \$I2212 \$I2235 VSS nfet_05v0 L=0.6U W=0.465U AS=0.1209P AD=0.1209P
+ PS=0.985U PD=0.985U
* device instance $358 r180 *1 586.6,810.123 nfet_05v0
M$358 \$I2235 \$I2237 VSS VSS nfet_05v0 L=0.6U W=0.465U AS=0.1209P AD=0.2046P
+ PS=0.985U PD=1.81U
* device instance $359 r180 *1 554.63,823.59 pfet_05v0
M$359 \$I2590 \$I2405 VDD_DEC VDD_DEC pfet_05v0 L=0.5U W=1.22U AS=0.5368P
+ AD=0.3172P PS=3.32U PD=1.74U
* device instance $360 r180 *1 553.61,823.59 pfet_05v0
M$360 \$I2589 \$I2418 \$I2590 VDD_DEC pfet_05v0 L=0.5U W=1.22U AS=0.3172P
+ AD=0.3782P PS=1.74U PD=1.84U
* device instance $361 r180 *1 552.49,823.59 pfet_05v0
M$361 \$I2163 \$I2204 \$I2589 VDD_DEC pfet_05v0 L=0.5U W=1.22U AS=0.3782P
+ AD=0.5368P PS=1.84U PD=3.32U
* device instance $362 r180 *1 554.68,825.803 nfet_05v0
M$362 \$I2163 \$I2405 VSS VSS nfet_05v0 L=0.6U W=0.465U AS=0.2046P AD=0.1209P
+ PS=1.81U PD=0.985U
* device instance $363 r180 *1 553.56,825.803 nfet_05v0
M$363 VSS \$I2418 \$I2163 VSS nfet_05v0 L=0.6U W=0.465U AS=0.1209P AD=0.1209P
+ PS=0.985U PD=0.985U
* device instance $364 r180 *1 552.44,825.803 nfet_05v0
M$364 \$I2163 \$I2204 VSS VSS nfet_05v0 L=0.6U W=0.465U AS=0.1209P AD=0.2046P
+ PS=0.985U PD=1.81U
* device instance $365 r180 *1 559.11,831.43 pfet_05v0
M$365 \$I2592 \$I2400 VDD_DEC VDD_DEC pfet_05v0 L=0.5U W=1.22U AS=0.5368P
+ AD=0.3172P PS=3.32U PD=1.74U
* device instance $366 r180 *1 558.09,831.43 pfet_05v0
M$366 \$I2591 \$I2418 \$I2592 VDD_DEC pfet_05v0 L=0.5U W=1.22U AS=0.3172P
+ AD=0.3782P PS=1.74U PD=1.84U
* device instance $367 r180 *1 556.97,831.43 pfet_05v0
M$367 \$I2128 \$I2359 \$I2591 VDD_DEC pfet_05v0 L=0.5U W=1.22U AS=0.3782P
+ AD=0.5368P PS=1.84U PD=3.32U
* device instance $368 r180 *1 559.16,833.643 nfet_05v0
M$368 \$I2128 \$I2400 VSS VSS nfet_05v0 L=0.6U W=0.465U AS=0.2046P AD=0.1209P
+ PS=1.81U PD=0.985U
* device instance $369 r180 *1 558.04,833.643 nfet_05v0
M$369 VSS \$I2418 \$I2128 VSS nfet_05v0 L=0.6U W=0.465U AS=0.1209P AD=0.1209P
+ PS=0.985U PD=0.985U
* device instance $370 r180 *1 556.92,833.643 nfet_05v0
M$370 \$I2128 \$I2359 VSS VSS nfet_05v0 L=0.6U W=0.465U AS=0.1209P AD=0.2046P
+ PS=0.985U PD=1.81U
* device instance $371 r180 *1 535.59,831.43 pfet_05v0
M$371 \$I2594 \$I2354 VDD_DEC VDD_DEC pfet_05v0 L=0.5U W=1.22U AS=0.5368P
+ AD=0.3172P PS=3.32U PD=1.74U
* device instance $372 r180 *1 534.57,831.43 pfet_05v0
M$372 \$I2593 \$I2322 \$I2594 VDD_DEC pfet_05v0 L=0.5U W=1.22U AS=0.3172P
+ AD=0.3782P PS=1.74U PD=1.84U
* device instance $373 r180 *1 533.45,831.43 pfet_05v0
M$373 \$I2399 \$I2353 \$I2593 VDD_DEC pfet_05v0 L=0.5U W=1.22U AS=0.3782P
+ AD=0.5368P PS=1.84U PD=3.32U
* device instance $374 r180 *1 535.64,833.643 nfet_05v0
M$374 \$I2399 \$I2354 VSS VSS nfet_05v0 L=0.6U W=0.465U AS=0.2046P AD=0.1209P
+ PS=1.81U PD=0.985U
* device instance $375 r180 *1 534.52,833.643 nfet_05v0
M$375 VSS \$I2322 \$I2399 VSS nfet_05v0 L=0.6U W=0.465U AS=0.1209P AD=0.1209P
+ PS=0.985U PD=0.985U
* device instance $376 r180 *1 533.4,833.643 nfet_05v0
M$376 \$I2399 \$I2353 VSS VSS nfet_05v0 L=0.6U W=0.465U AS=0.1209P AD=0.2046P
+ PS=0.985U PD=1.81U
* device instance $377 r180 *1 671.11,807.91 pfet_05v0
M$377 \$I2596 \$I2406 VDD_DEC VDD_DEC pfet_05v0 L=0.5U W=1.22U AS=0.5368P
+ AD=0.3172P PS=3.32U PD=1.74U
* device instance $378 r180 *1 670.09,807.91 pfet_05v0
M$378 \$I2595 \$I2177 \$I2596 VDD_DEC pfet_05v0 L=0.5U W=1.22U AS=0.3172P
+ AD=0.3782P PS=1.74U PD=1.84U
* device instance $379 r180 *1 668.97,807.91 pfet_05v0
M$379 \$I2409 \$I2178 \$I2595 VDD_DEC pfet_05v0 L=0.5U W=1.22U AS=0.3782P
+ AD=0.5368P PS=1.84U PD=3.32U
* device instance $380 r180 *1 671.16,810.123 nfet_05v0
M$380 \$I2409 \$I2406 VSS VSS nfet_05v0 L=0.6U W=0.465U AS=0.2046P AD=0.1209P
+ PS=1.81U PD=0.985U
* device instance $381 r180 *1 670.04,810.123 nfet_05v0
M$381 VSS \$I2177 \$I2409 VSS nfet_05v0 L=0.6U W=0.465U AS=0.1209P AD=0.1209P
+ PS=0.985U PD=0.985U
* device instance $382 r180 *1 668.92,810.123 nfet_05v0
M$382 \$I2409 \$I2178 VSS VSS nfet_05v0 L=0.6U W=0.465U AS=0.1209P AD=0.2046P
+ PS=0.985U PD=1.81U
* device instance $383 r0 *1 597.45,821.69 pfet_05v0
M$383 \$I2598 \$I2426 VDD_DEC VDD_DEC pfet_05v0 L=0.5U W=1.22U AS=0.5368P
+ AD=0.3172P PS=3.32U PD=1.74U
* device instance $384 r0 *1 598.47,821.69 pfet_05v0
M$384 \$I2597 \$I2241 \$I2598 VDD_DEC pfet_05v0 L=0.5U W=1.22U AS=0.3172P
+ AD=0.3782P PS=1.74U PD=1.84U
* device instance $385 r0 *1 599.59,821.69 pfet_05v0
M$385 \$I2073 \$I2240 \$I2597 VDD_DEC pfet_05v0 L=0.5U W=1.22U AS=0.3782P
+ AD=0.5368P PS=1.84U PD=3.32U
* device instance $386 r0 *1 597.4,819.477 nfet_05v0
M$386 \$I2073 \$I2426 VSS VSS nfet_05v0 L=0.6U W=0.465U AS=0.2046P AD=0.1209P
+ PS=1.81U PD=0.985U
* device instance $387 r0 *1 598.52,819.477 nfet_05v0
M$387 VSS \$I2241 \$I2073 VSS nfet_05v0 L=0.6U W=0.465U AS=0.1209P AD=0.1209P
+ PS=0.985U PD=0.985U
* device instance $388 r0 *1 599.64,819.477 nfet_05v0
M$388 \$I2073 \$I2240 VSS VSS nfet_05v0 L=0.6U W=0.465U AS=0.1209P AD=0.2046P
+ PS=0.985U PD=1.81U
* device instance $389 r0 *1 592.97,821.69 pfet_05v0
M$389 \$I2600 \$I2405 VDD_DEC VDD_DEC pfet_05v0 L=0.5U W=1.22U AS=0.5368P
+ AD=0.3172P PS=3.32U PD=1.74U
* device instance $390 r0 *1 593.99,821.69 pfet_05v0
M$390 \$I2599 \$I2173 \$I2600 VDD_DEC pfet_05v0 L=0.5U W=1.22U AS=0.3172P
+ AD=0.3782P PS=1.74U PD=1.84U
* device instance $391 r0 *1 595.11,821.69 pfet_05v0
M$391 \$I2367 \$I2172 \$I2599 VDD_DEC pfet_05v0 L=0.5U W=1.22U AS=0.3782P
+ AD=0.5368P PS=1.84U PD=3.32U
* device instance $392 r0 *1 592.92,819.477 nfet_05v0
M$392 \$I2367 \$I2405 VSS VSS nfet_05v0 L=0.6U W=0.465U AS=0.2046P AD=0.1209P
+ PS=1.81U PD=0.985U
* device instance $393 r0 *1 594.04,819.477 nfet_05v0
M$393 VSS \$I2173 \$I2367 VSS nfet_05v0 L=0.6U W=0.465U AS=0.1209P AD=0.1209P
+ PS=0.985U PD=0.985U
* device instance $394 r0 *1 595.16,819.477 nfet_05v0
M$394 \$I2367 \$I2172 VSS VSS nfet_05v0 L=0.6U W=0.465U AS=0.1209P AD=0.2046P
+ PS=0.985U PD=1.81U
* device instance $395 r0 *1 659.61,798.17 pfet_05v0
M$395 \$I2602 \$I2234 VDD_DEC VDD_DEC pfet_05v0 L=0.5U W=1.22U AS=0.5368P
+ AD=0.3172P PS=3.32U PD=1.74U
* device instance $396 r0 *1 660.63,798.17 pfet_05v0
M$396 \$I2601 \$I2140 \$I2602 VDD_DEC pfet_05v0 L=0.5U W=1.22U AS=0.3172P
+ AD=0.3782P PS=1.74U PD=1.84U
* device instance $397 r0 *1 661.75,798.17 pfet_05v0
M$397 \$I2245 \$I2138 \$I2601 VDD_DEC pfet_05v0 L=0.5U W=1.22U AS=0.3782P
+ AD=0.5368P PS=1.84U PD=3.32U
* device instance $398 r0 *1 659.56,795.957 nfet_05v0
M$398 \$I2245 \$I2234 VSS VSS nfet_05v0 L=0.6U W=0.465U AS=0.2046P AD=0.1209P
+ PS=1.81U PD=0.985U
* device instance $399 r0 *1 660.68,795.957 nfet_05v0
M$399 VSS \$I2140 \$I2245 VSS nfet_05v0 L=0.6U W=0.465U AS=0.1209P AD=0.1209P
+ PS=0.985U PD=0.985U
* device instance $400 r0 *1 661.8,795.957 nfet_05v0
M$400 \$I2245 \$I2138 VSS VSS nfet_05v0 L=0.6U W=0.465U AS=0.1209P AD=0.2046P
+ PS=0.985U PD=1.81U
* device instance $401 r0 *1 548.17,798.17 pfet_05v0
M$401 \$I2604 \$I2277 VDD_DEC VDD_DEC pfet_05v0 L=0.5U W=1.22U AS=0.5368P
+ AD=0.3172P PS=3.32U PD=1.74U
* device instance $402 r0 *1 549.19,798.17 pfet_05v0
M$402 \$I2603 \$I2207 \$I2604 VDD_DEC pfet_05v0 L=0.5U W=1.22U AS=0.3172P
+ AD=0.3782P PS=1.74U PD=1.84U
* device instance $403 r0 *1 550.31,798.17 pfet_05v0
M$403 \$I2062 \$I2237 \$I2603 VDD_DEC pfet_05v0 L=0.5U W=1.22U AS=0.3782P
+ AD=0.5368P PS=1.84U PD=3.32U
* device instance $404 r0 *1 548.12,795.957 nfet_05v0
M$404 \$I2062 \$I2277 VSS VSS nfet_05v0 L=0.6U W=0.465U AS=0.2046P AD=0.1209P
+ PS=1.81U PD=0.985U
* device instance $405 r0 *1 549.24,795.957 nfet_05v0
M$405 VSS \$I2207 \$I2062 VSS nfet_05v0 L=0.6U W=0.465U AS=0.1209P AD=0.1209P
+ PS=0.985U PD=0.985U
* device instance $406 r0 *1 550.36,795.957 nfet_05v0
M$406 \$I2062 \$I2237 VSS VSS nfet_05v0 L=0.6U W=0.465U AS=0.1209P AD=0.2046P
+ PS=0.985U PD=1.81U
* device instance $407 r0 *1 617.05,829.53 pfet_05v0
M$407 \$I2606 \$I2431 VDD_DEC VDD_DEC pfet_05v0 L=0.5U W=1.22U AS=0.5368P
+ AD=0.3172P PS=3.32U PD=1.74U
* device instance $408 r0 *1 618.07,829.53 pfet_05v0
M$408 \$I2605 \$I2286 \$I2606 VDD_DEC pfet_05v0 L=0.5U W=1.22U AS=0.3172P
+ AD=0.3782P PS=1.74U PD=1.84U
* device instance $409 r0 *1 619.19,829.53 pfet_05v0
M$409 \$I2032 \$I2214 \$I2605 VDD_DEC pfet_05v0 L=0.5U W=1.22U AS=0.3782P
+ AD=0.5368P PS=1.84U PD=3.32U
* device instance $410 r0 *1 617,827.317 nfet_05v0
M$410 \$I2032 \$I2431 VSS VSS nfet_05v0 L=0.6U W=0.465U AS=0.2046P AD=0.1209P
+ PS=1.81U PD=0.985U
* device instance $411 r0 *1 618.12,827.317 nfet_05v0
M$411 VSS \$I2286 \$I2032 VSS nfet_05v0 L=0.6U W=0.465U AS=0.1209P AD=0.1209P
+ PS=0.985U PD=0.985U
* device instance $412 r0 *1 619.24,827.317 nfet_05v0
M$412 \$I2032 \$I2214 VSS VSS nfet_05v0 L=0.6U W=0.465U AS=0.1209P AD=0.2046P
+ PS=0.985U PD=1.81U
* device instance $413 r0 *1 610.33,829.53 pfet_05v0
M$413 \$I2608 \$I2406 VDD_DEC VDD_DEC pfet_05v0 L=0.5U W=1.22U AS=0.5368P
+ AD=0.3172P PS=3.32U PD=1.74U
* device instance $414 r0 *1 611.35,829.53 pfet_05v0
M$414 \$I2607 \$I2241 \$I2608 VDD_DEC pfet_05v0 L=0.5U W=1.22U AS=0.3172P
+ AD=0.3782P PS=1.74U PD=1.84U
* device instance $415 r0 *1 612.47,829.53 pfet_05v0
M$415 \$I2074 \$I2240 \$I2607 VDD_DEC pfet_05v0 L=0.5U W=1.22U AS=0.3782P
+ AD=0.5368P PS=1.84U PD=3.32U
* device instance $416 r0 *1 610.28,827.317 nfet_05v0
M$416 \$I2074 \$I2406 VSS VSS nfet_05v0 L=0.6U W=0.465U AS=0.2046P AD=0.1209P
+ PS=1.81U PD=0.985U
* device instance $417 r0 *1 611.4,827.317 nfet_05v0
M$417 VSS \$I2241 \$I2074 VSS nfet_05v0 L=0.6U W=0.465U AS=0.1209P AD=0.1209P
+ PS=0.985U PD=0.985U
* device instance $418 r0 *1 612.52,827.317 nfet_05v0
M$418 \$I2074 \$I2240 VSS VSS nfet_05v0 L=0.6U W=0.465U AS=0.1209P AD=0.2046P
+ PS=0.985U PD=1.81U
* device instance $419 r0 *1 626.01,829.53 pfet_05v0
M$419 \$I2610 \$I2427 VDD_DEC VDD_DEC pfet_05v0 L=0.5U W=1.22U AS=0.5368P
+ AD=0.3172P PS=3.32U PD=1.74U
* device instance $420 r0 *1 627.03,829.53 pfet_05v0
M$420 \$I2609 \$I2140 \$I2610 VDD_DEC pfet_05v0 L=0.5U W=1.22U AS=0.3172P
+ AD=0.3782P PS=1.74U PD=1.84U
* device instance $421 r0 *1 628.15,829.53 pfet_05v0
M$421 \$I2077 \$I2138 \$I2609 VDD_DEC pfet_05v0 L=0.5U W=1.22U AS=0.3782P
+ AD=0.5368P PS=1.84U PD=3.32U
* device instance $422 r0 *1 625.96,827.317 nfet_05v0
M$422 \$I2077 \$I2427 VSS VSS nfet_05v0 L=0.6U W=0.465U AS=0.2046P AD=0.1209P
+ PS=1.81U PD=0.985U
* device instance $423 r0 *1 627.08,827.317 nfet_05v0
M$423 VSS \$I2140 \$I2077 VSS nfet_05v0 L=0.6U W=0.465U AS=0.1209P AD=0.1209P
+ PS=0.985U PD=0.985U
* device instance $424 r0 *1 628.2,827.317 nfet_05v0
M$424 \$I2077 \$I2138 VSS VSS nfet_05v0 L=0.6U W=0.465U AS=0.1209P AD=0.2046P
+ PS=0.985U PD=1.81U
* device instance $425 r0 *1 665.21,813.85 pfet_05v0
M$425 \$I2612 \$I2277 VDD_DEC VDD_DEC pfet_05v0 L=0.5U W=1.22U AS=0.5368P
+ AD=0.3172P PS=3.32U PD=1.74U
* device instance $426 r0 *1 666.23,813.85 pfet_05v0
M$426 \$I2611 \$I2177 \$I2612 VDD_DEC pfet_05v0 L=0.5U W=1.22U AS=0.3172P
+ AD=0.3782P PS=1.74U PD=1.84U
* device instance $427 r0 *1 667.35,813.85 pfet_05v0
M$427 \$I2370 \$I2178 \$I2611 VDD_DEC pfet_05v0 L=0.5U W=1.22U AS=0.3782P
+ AD=0.5368P PS=1.84U PD=3.32U
* device instance $428 r0 *1 665.16,811.637 nfet_05v0
M$428 \$I2370 \$I2277 VSS VSS nfet_05v0 L=0.6U W=0.465U AS=0.2046P AD=0.1209P
+ PS=1.81U PD=0.985U
* device instance $429 r0 *1 666.28,811.637 nfet_05v0
M$429 VSS \$I2177 \$I2370 VSS nfet_05v0 L=0.6U W=0.465U AS=0.1209P AD=0.1209P
+ PS=0.985U PD=0.985U
* device instance $430 r0 *1 667.4,811.637 nfet_05v0
M$430 \$I2370 \$I2178 VSS VSS nfet_05v0 L=0.6U W=0.465U AS=0.1209P AD=0.2046P
+ PS=0.985U PD=1.81U
* device instance $431 r0 *1 572.25,798.17 pfet_05v0
M$431 \$I2614 \$I2427 VDD_DEC VDD_DEC pfet_05v0 L=0.5U W=1.22U AS=0.5368P
+ AD=0.3172P PS=3.32U PD=1.74U
* device instance $432 r0 *1 573.27,798.17 pfet_05v0
M$432 \$I2613 \$I2173 \$I2614 VDD_DEC pfet_05v0 L=0.5U W=1.22U AS=0.3172P
+ AD=0.3782P PS=1.74U PD=1.84U
* device instance $433 r0 *1 574.39,798.17 pfet_05v0
M$433 \$I2133 \$I2172 \$I2613 VDD_DEC pfet_05v0 L=0.5U W=1.22U AS=0.3782P
+ AD=0.5368P PS=1.84U PD=3.32U
* device instance $434 r0 *1 572.2,795.957 nfet_05v0
M$434 \$I2133 \$I2427 VSS VSS nfet_05v0 L=0.6U W=0.465U AS=0.2046P AD=0.1209P
+ PS=1.81U PD=0.985U
* device instance $435 r0 *1 573.32,795.957 nfet_05v0
M$435 VSS \$I2173 \$I2133 VSS nfet_05v0 L=0.6U W=0.465U AS=0.1209P AD=0.1209P
+ PS=0.985U PD=0.985U
* device instance $436 r0 *1 574.44,795.957 nfet_05v0
M$436 \$I2133 \$I2172 VSS VSS nfet_05v0 L=0.6U W=0.465U AS=0.1209P AD=0.2046P
+ PS=0.985U PD=1.81U
* device instance $437 r0 *1 634.97,829.53 pfet_05v0
M$437 \$I2616 \$I2426 VDD_DEC VDD_DEC pfet_05v0 L=0.5U W=1.22U AS=0.5368P
+ AD=0.3172P PS=3.32U PD=1.74U
* device instance $438 r0 *1 635.99,829.53 pfet_05v0
M$438 \$I2615 \$I2140 \$I2616 VDD_DEC pfet_05v0 L=0.5U W=1.22U AS=0.3172P
+ AD=0.3782P PS=1.74U PD=1.84U
* device instance $439 r0 *1 637.11,829.53 pfet_05v0
M$439 \$I2416 \$I2178 \$I2615 VDD_DEC pfet_05v0 L=0.5U W=1.22U AS=0.3782P
+ AD=0.5368P PS=1.84U PD=3.32U
* device instance $440 r0 *1 634.92,827.317 nfet_05v0
M$440 \$I2416 \$I2426 VSS VSS nfet_05v0 L=0.6U W=0.465U AS=0.2046P AD=0.1209P
+ PS=1.81U PD=0.985U
* device instance $441 r0 *1 636.04,827.317 nfet_05v0
M$441 VSS \$I2140 \$I2416 VSS nfet_05v0 L=0.6U W=0.465U AS=0.1209P AD=0.1209P
+ PS=0.985U PD=0.985U
* device instance $442 r0 *1 637.16,827.317 nfet_05v0
M$442 \$I2416 \$I2178 VSS VSS nfet_05v0 L=0.6U W=0.465U AS=0.1209P AD=0.2046P
+ PS=0.985U PD=1.81U
* device instance $443 m90 *1 599.43,774.65 pfet_05v0
M$443 \$I2618 \$I2431 VDD_DEC VDD_DEC pfet_05v0 L=0.5U W=1.22U AS=0.5368P
+ AD=0.3172P PS=3.32U PD=1.74U
* device instance $444 m90 *1 598.41,774.65 pfet_05v0
M$444 \$I2617 \$I2173 \$I2618 VDD_DEC pfet_05v0 L=0.5U W=1.22U AS=0.3172P
+ AD=0.3782P PS=1.74U PD=1.84U
* device instance $445 m90 *1 597.29,774.65 pfet_05v0
M$445 \$I2135 \$I2172 \$I2617 VDD_DEC pfet_05v0 L=0.5U W=1.22U AS=0.3782P
+ AD=0.5368P PS=1.84U PD=3.32U
* device instance $446 m90 *1 599.48,772.437 nfet_05v0
M$446 \$I2135 \$I2431 VSS VSS nfet_05v0 L=0.6U W=0.465U AS=0.2046P AD=0.1209P
+ PS=1.81U PD=0.985U
* device instance $447 m90 *1 598.36,772.437 nfet_05v0
M$447 VSS \$I2173 \$I2135 VSS nfet_05v0 L=0.6U W=0.465U AS=0.1209P AD=0.1209P
+ PS=0.985U PD=0.985U
* device instance $448 m90 *1 597.24,772.437 nfet_05v0
M$448 \$I2135 \$I2172 VSS VSS nfet_05v0 L=0.6U W=0.465U AS=0.1209P AD=0.2046P
+ PS=0.985U PD=1.81U
* device instance $449 m0 *1 615.52,831.43 pfet_05v0
M$449 VDD_DEC \$I2639 \$I2623 VDD_DEC pfet_05v0 L=1U W=1.22U AS=0.5368P
+ AD=0.5368P PS=3.32U PD=3.32U
* device instance $450 m0 *1 635.68,831.43 pfet_05v0
M$450 VDD_DEC \$I2648 \$I2632 VDD_DEC pfet_05v0 L=1U W=1.22U AS=0.5368P
+ AD=0.5368P PS=3.32U PD=3.32U
* device instance $451 m0 *1 613.28,831.43 pfet_05v0
M$451 VDD_DEC \$I2638 \$I2622 VDD_DEC pfet_05v0 L=1U W=1.22U AS=0.5368P
+ AD=0.5368P PS=3.32U PD=3.32U
* device instance $452 m0 *1 617.76,831.43 pfet_05v0
M$452 VDD_DEC \$I2640 \$I2624 VDD_DEC pfet_05v0 L=1U W=1.22U AS=0.5368P
+ AD=0.5368P PS=3.32U PD=3.32U
* device instance $453 m0 *1 620,831.43 pfet_05v0
M$453 VDD_DEC \$I2641 \$I2625 VDD_DEC pfet_05v0 L=1U W=1.22U AS=0.5368P
+ AD=0.5368P PS=3.32U PD=3.32U
* device instance $454 m0 *1 606.56,831.43 pfet_05v0
M$454 VDD_DEC \$I2635 \$I2619 VDD_DEC pfet_05v0 L=1U W=1.22U AS=0.5368P
+ AD=0.5368P PS=3.32U PD=3.32U
* device instance $455 m0 *1 611.04,831.43 pfet_05v0
M$455 VDD_DEC \$I2637 \$I2621 VDD_DEC pfet_05v0 L=1U W=1.22U AS=0.5368P
+ AD=0.5368P PS=3.32U PD=3.32U
* device instance $456 m0 *1 633.44,831.43 pfet_05v0
M$456 VDD_DEC \$I2647 \$I2631 VDD_DEC pfet_05v0 L=1U W=1.22U AS=0.5368P
+ AD=0.5368P PS=3.32U PD=3.32U
* device instance $457 m0 *1 608.8,831.43 pfet_05v0
M$457 VDD_DEC \$I2636 \$I2620 VDD_DEC pfet_05v0 L=1U W=1.22U AS=0.5368P
+ AD=0.5368P PS=3.32U PD=3.32U
* device instance $458 m0 *1 622.24,831.43 pfet_05v0
M$458 VDD_DEC \$I2642 \$I2626 VDD_DEC pfet_05v0 L=1U W=1.22U AS=0.5368P
+ AD=0.5368P PS=3.32U PD=3.32U
* device instance $459 m0 *1 624.48,831.43 pfet_05v0
M$459 VDD_DEC \$I2643 \$I2627 VDD_DEC pfet_05v0 L=1U W=1.22U AS=0.5368P
+ AD=0.5368P PS=3.32U PD=3.32U
* device instance $460 m0 *1 626.72,831.43 pfet_05v0
M$460 VDD_DEC \$I2644 \$I2628 VDD_DEC pfet_05v0 L=1U W=1.22U AS=0.5368P
+ AD=0.5368P PS=3.32U PD=3.32U
* device instance $461 m0 *1 631.2,831.43 pfet_05v0
M$461 VDD_DEC \$I2646 \$I2630 VDD_DEC pfet_05v0 L=1U W=1.22U AS=0.5368P
+ AD=0.5368P PS=3.32U PD=3.32U
* device instance $462 m0 *1 637.92,831.43 pfet_05v0
M$462 VDD_DEC \$I2649 \$I2633 VDD_DEC pfet_05v0 L=1U W=1.22U AS=0.5368P
+ AD=0.5368P PS=3.32U PD=3.32U
* device instance $463 m0 *1 640.16,831.43 pfet_05v0
M$463 VDD_DEC \$I2650 \$I2634 VDD_DEC pfet_05v0 L=1U W=1.22U AS=0.5368P
+ AD=0.5368P PS=3.32U PD=3.32U
* device instance $464 m0 *1 628.96,831.43 pfet_05v0
M$464 VDD_DEC \$I2645 \$I2629 VDD_DEC pfet_05v0 L=1U W=1.22U AS=0.5368P
+ AD=0.5368P PS=3.32U PD=3.32U
* device instance $465 m0 *1 640.16,833.65 nfet_05v0
M$465 \$I2650 \$I2634 VSS VSS nfet_05v0 L=1U W=0.82U AS=0.3608P AD=0.3608P
+ PS=2.52U PD=2.52U
* device instance $466 m0 *1 608.8,833.65 nfet_05v0
M$466 \$I2636 \$I2620 VSS VSS nfet_05v0 L=1U W=0.82U AS=0.3608P AD=0.3608P
+ PS=2.52U PD=2.52U
* device instance $467 m0 *1 617.76,833.65 nfet_05v0
M$467 \$I2640 \$I2624 VSS VSS nfet_05v0 L=1U W=0.82U AS=0.3608P AD=0.3608P
+ PS=2.52U PD=2.52U
* device instance $468 m0 *1 615.52,833.65 nfet_05v0
M$468 \$I2639 \$I2623 VSS VSS nfet_05v0 L=1U W=0.82U AS=0.3608P AD=0.3608P
+ PS=2.52U PD=2.52U
* device instance $469 m0 *1 628.96,833.65 nfet_05v0
M$469 \$I2645 \$I2629 VSS VSS nfet_05v0 L=1U W=0.82U AS=0.3608P AD=0.3608P
+ PS=2.52U PD=2.52U
* device instance $470 m0 *1 613.28,833.65 nfet_05v0
M$470 \$I2638 \$I2622 VSS VSS nfet_05v0 L=1U W=0.82U AS=0.3608P AD=0.3608P
+ PS=2.52U PD=2.52U
* device instance $471 m0 *1 611.04,833.65 nfet_05v0
M$471 \$I2637 \$I2621 VSS VSS nfet_05v0 L=1U W=0.82U AS=0.3608P AD=0.3608P
+ PS=2.52U PD=2.52U
* device instance $472 m0 *1 637.92,833.65 nfet_05v0
M$472 \$I2649 \$I2633 VSS VSS nfet_05v0 L=1U W=0.82U AS=0.3608P AD=0.3608P
+ PS=2.52U PD=2.52U
* device instance $473 m0 *1 633.44,833.65 nfet_05v0
M$473 \$I2647 \$I2631 VSS VSS nfet_05v0 L=1U W=0.82U AS=0.3608P AD=0.3608P
+ PS=2.52U PD=2.52U
* device instance $474 m0 *1 606.56,833.65 nfet_05v0
M$474 \$I2635 \$I2619 VSS VSS nfet_05v0 L=1U W=0.82U AS=0.3608P AD=0.3608P
+ PS=2.52U PD=2.52U
* device instance $475 m0 *1 622.24,833.65 nfet_05v0
M$475 \$I2642 \$I2626 VSS VSS nfet_05v0 L=1U W=0.82U AS=0.3608P AD=0.3608P
+ PS=2.52U PD=2.52U
* device instance $476 m0 *1 620,833.65 nfet_05v0
M$476 \$I2641 \$I2625 VSS VSS nfet_05v0 L=1U W=0.82U AS=0.3608P AD=0.3608P
+ PS=2.52U PD=2.52U
* device instance $477 m0 *1 624.48,833.65 nfet_05v0
M$477 \$I2643 \$I2627 VSS VSS nfet_05v0 L=1U W=0.82U AS=0.3608P AD=0.3608P
+ PS=2.52U PD=2.52U
* device instance $478 m0 *1 631.2,833.65 nfet_05v0
M$478 \$I2646 \$I2630 VSS VSS nfet_05v0 L=1U W=0.82U AS=0.3608P AD=0.3608P
+ PS=2.52U PD=2.52U
* device instance $479 m0 *1 626.72,833.65 nfet_05v0
M$479 \$I2644 \$I2628 VSS VSS nfet_05v0 L=1U W=0.82U AS=0.3608P AD=0.3608P
+ PS=2.52U PD=2.52U
* device instance $480 m0 *1 635.68,833.65 nfet_05v0
M$480 \$I2648 \$I2632 VSS VSS nfet_05v0 L=1U W=0.82U AS=0.3608P AD=0.3608P
+ PS=2.52U PD=2.52U
* device instance $481 m0 *1 576.32,831.43 pfet_05v0
M$481 VDD_DEC \$I2671 \$I2655 VDD_DEC pfet_05v0 L=1U W=1.22U AS=0.5368P
+ AD=0.5368P PS=3.32U PD=3.32U
* device instance $482 m0 *1 596.48,831.43 pfet_05v0
M$482 VDD_DEC \$I2680 \$I2664 VDD_DEC pfet_05v0 L=1U W=1.22U AS=0.5368P
+ AD=0.5368P PS=3.32U PD=3.32U
* device instance $483 m0 *1 574.08,831.43 pfet_05v0
M$483 VDD_DEC \$I2670 \$I2654 VDD_DEC pfet_05v0 L=1U W=1.22U AS=0.5368P
+ AD=0.5368P PS=3.32U PD=3.32U
* device instance $484 m0 *1 578.56,831.43 pfet_05v0
M$484 VDD_DEC \$I2672 \$I2656 VDD_DEC pfet_05v0 L=1U W=1.22U AS=0.5368P
+ AD=0.5368P PS=3.32U PD=3.32U
* device instance $485 m0 *1 580.8,831.43 pfet_05v0
M$485 VDD_DEC \$I2673 \$I2657 VDD_DEC pfet_05v0 L=1U W=1.22U AS=0.5368P
+ AD=0.5368P PS=3.32U PD=3.32U
* device instance $486 m0 *1 567.36,831.43 pfet_05v0
M$486 VDD_DEC \$I2667 \$I2651 VDD_DEC pfet_05v0 L=1U W=1.22U AS=0.5368P
+ AD=0.5368P PS=3.32U PD=3.32U
* device instance $487 m0 *1 571.84,831.43 pfet_05v0
M$487 VDD_DEC \$I2669 \$I2653 VDD_DEC pfet_05v0 L=1U W=1.22U AS=0.5368P
+ AD=0.5368P PS=3.32U PD=3.32U
* device instance $488 m0 *1 594.24,831.43 pfet_05v0
M$488 VDD_DEC \$I2679 \$I2663 VDD_DEC pfet_05v0 L=1U W=1.22U AS=0.5368P
+ AD=0.5368P PS=3.32U PD=3.32U
* device instance $489 m0 *1 569.6,831.43 pfet_05v0
M$489 VDD_DEC \$I2668 \$I2652 VDD_DEC pfet_05v0 L=1U W=1.22U AS=0.5368P
+ AD=0.5368P PS=3.32U PD=3.32U
* device instance $490 m0 *1 583.04,831.43 pfet_05v0
M$490 VDD_DEC \$I2674 \$I2658 VDD_DEC pfet_05v0 L=1U W=1.22U AS=0.5368P
+ AD=0.5368P PS=3.32U PD=3.32U
* device instance $491 m0 *1 585.28,831.43 pfet_05v0
M$491 VDD_DEC \$I2675 \$I2659 VDD_DEC pfet_05v0 L=1U W=1.22U AS=0.5368P
+ AD=0.5368P PS=3.32U PD=3.32U
* device instance $492 m0 *1 587.52,831.43 pfet_05v0
M$492 VDD_DEC \$I2676 \$I2660 VDD_DEC pfet_05v0 L=1U W=1.22U AS=0.5368P
+ AD=0.5368P PS=3.32U PD=3.32U
* device instance $493 m0 *1 592,831.43 pfet_05v0
M$493 VDD_DEC \$I2678 \$I2662 VDD_DEC pfet_05v0 L=1U W=1.22U AS=0.5368P
+ AD=0.5368P PS=3.32U PD=3.32U
* device instance $494 m0 *1 598.72,831.43 pfet_05v0
M$494 VDD_DEC \$I2681 \$I2665 VDD_DEC pfet_05v0 L=1U W=1.22U AS=0.5368P
+ AD=0.5368P PS=3.32U PD=3.32U
* device instance $495 m0 *1 600.96,831.43 pfet_05v0
M$495 VDD_DEC \$I2682 \$I2666 VDD_DEC pfet_05v0 L=1U W=1.22U AS=0.5368P
+ AD=0.5368P PS=3.32U PD=3.32U
* device instance $496 m0 *1 589.76,831.43 pfet_05v0
M$496 VDD_DEC \$I2677 \$I2661 VDD_DEC pfet_05v0 L=1U W=1.22U AS=0.5368P
+ AD=0.5368P PS=3.32U PD=3.32U
* device instance $497 m0 *1 600.96,833.65 nfet_05v0
M$497 \$I2682 \$I2666 VSS VSS nfet_05v0 L=1U W=0.82U AS=0.3608P AD=0.3608P
+ PS=2.52U PD=2.52U
* device instance $498 m0 *1 569.6,833.65 nfet_05v0
M$498 \$I2668 \$I2652 VSS VSS nfet_05v0 L=1U W=0.82U AS=0.3608P AD=0.3608P
+ PS=2.52U PD=2.52U
* device instance $499 m0 *1 578.56,833.65 nfet_05v0
M$499 \$I2672 \$I2656 VSS VSS nfet_05v0 L=1U W=0.82U AS=0.3608P AD=0.3608P
+ PS=2.52U PD=2.52U
* device instance $500 m0 *1 576.32,833.65 nfet_05v0
M$500 \$I2671 \$I2655 VSS VSS nfet_05v0 L=1U W=0.82U AS=0.3608P AD=0.3608P
+ PS=2.52U PD=2.52U
* device instance $501 m0 *1 589.76,833.65 nfet_05v0
M$501 \$I2677 \$I2661 VSS VSS nfet_05v0 L=1U W=0.82U AS=0.3608P AD=0.3608P
+ PS=2.52U PD=2.52U
* device instance $502 m0 *1 574.08,833.65 nfet_05v0
M$502 \$I2670 \$I2654 VSS VSS nfet_05v0 L=1U W=0.82U AS=0.3608P AD=0.3608P
+ PS=2.52U PD=2.52U
* device instance $503 m0 *1 571.84,833.65 nfet_05v0
M$503 \$I2669 \$I2653 VSS VSS nfet_05v0 L=1U W=0.82U AS=0.3608P AD=0.3608P
+ PS=2.52U PD=2.52U
* device instance $504 m0 *1 598.72,833.65 nfet_05v0
M$504 \$I2681 \$I2665 VSS VSS nfet_05v0 L=1U W=0.82U AS=0.3608P AD=0.3608P
+ PS=2.52U PD=2.52U
* device instance $505 m0 *1 594.24,833.65 nfet_05v0
M$505 \$I2679 \$I2663 VSS VSS nfet_05v0 L=1U W=0.82U AS=0.3608P AD=0.3608P
+ PS=2.52U PD=2.52U
* device instance $506 m0 *1 567.36,833.65 nfet_05v0
M$506 \$I2667 \$I2651 VSS VSS nfet_05v0 L=1U W=0.82U AS=0.3608P AD=0.3608P
+ PS=2.52U PD=2.52U
* device instance $507 m0 *1 583.04,833.65 nfet_05v0
M$507 \$I2674 \$I2658 VSS VSS nfet_05v0 L=1U W=0.82U AS=0.3608P AD=0.3608P
+ PS=2.52U PD=2.52U
* device instance $508 m0 *1 580.8,833.65 nfet_05v0
M$508 \$I2673 \$I2657 VSS VSS nfet_05v0 L=1U W=0.82U AS=0.3608P AD=0.3608P
+ PS=2.52U PD=2.52U
* device instance $509 m0 *1 585.28,833.65 nfet_05v0
M$509 \$I2675 \$I2659 VSS VSS nfet_05v0 L=1U W=0.82U AS=0.3608P AD=0.3608P
+ PS=2.52U PD=2.52U
* device instance $510 m0 *1 592,833.65 nfet_05v0
M$510 \$I2678 \$I2662 VSS VSS nfet_05v0 L=1U W=0.82U AS=0.3608P AD=0.3608P
+ PS=2.52U PD=2.52U
* device instance $511 m0 *1 587.52,833.65 nfet_05v0
M$511 \$I2676 \$I2660 VSS VSS nfet_05v0 L=1U W=0.82U AS=0.3608P AD=0.3608P
+ PS=2.52U PD=2.52U
* device instance $512 m0 *1 596.48,833.65 nfet_05v0
M$512 \$I2680 \$I2664 VSS VSS nfet_05v0 L=1U W=0.82U AS=0.3608P AD=0.3608P
+ PS=2.52U PD=2.52U
* device instance $513 m0 *1 603.2,823.59 pfet_05v0
M$513 VDD_DEC \$I2698 \$I2690 VDD_DEC pfet_05v0 L=1U W=1.22U AS=0.5368P
+ AD=0.5368P PS=3.32U PD=3.32U
* device instance $514 m0 *1 596.48,823.59 pfet_05v0
M$514 VDD_DEC \$I2695 \$I2687 VDD_DEC pfet_05v0 L=1U W=1.22U AS=0.5368P
+ AD=0.5368P PS=3.32U PD=3.32U
* device instance $515 m0 *1 589.76,823.59 pfet_05v0
M$515 VDD_DEC \$I2692 \$I2684 VDD_DEC pfet_05v0 L=1U W=1.22U AS=0.5368P
+ AD=0.5368P PS=3.32U PD=3.32U
* device instance $516 m0 *1 598.72,823.59 pfet_05v0
M$516 VDD_DEC \$I2696 \$I2688 VDD_DEC pfet_05v0 L=1U W=1.22U AS=0.5368P
+ AD=0.5368P PS=3.32U PD=3.32U
* device instance $517 m0 *1 592,823.59 pfet_05v0
M$517 VDD_DEC \$I2693 \$I2685 VDD_DEC pfet_05v0 L=1U W=1.22U AS=0.5368P
+ AD=0.5368P PS=3.32U PD=3.32U
* device instance $518 m0 *1 600.96,823.59 pfet_05v0
M$518 VDD_DEC \$I2697 \$I2689 VDD_DEC pfet_05v0 L=1U W=1.22U AS=0.5368P
+ AD=0.5368P PS=3.32U PD=3.32U
* device instance $519 m0 *1 587.52,823.59 pfet_05v0
M$519 VDD_DEC \$I2691 \$I2683 VDD_DEC pfet_05v0 L=1U W=1.22U AS=0.5368P
+ AD=0.5368P PS=3.32U PD=3.32U
* device instance $520 m0 *1 594.24,823.59 pfet_05v0
M$520 VDD_DEC \$I2694 \$I2686 VDD_DEC pfet_05v0 L=1U W=1.22U AS=0.5368P
+ AD=0.5368P PS=3.32U PD=3.32U
* device instance $521 m0 *1 603.2,825.81 nfet_05v0
M$521 \$I2698 \$I2690 VSS VSS nfet_05v0 L=1U W=0.82U AS=0.3608P AD=0.3608P
+ PS=2.52U PD=2.52U
* device instance $522 m0 *1 600.96,825.81 nfet_05v0
M$522 \$I2697 \$I2689 VSS VSS nfet_05v0 L=1U W=0.82U AS=0.3608P AD=0.3608P
+ PS=2.52U PD=2.52U
* device instance $523 m0 *1 587.52,825.81 nfet_05v0
M$523 \$I2691 \$I2683 VSS VSS nfet_05v0 L=1U W=0.82U AS=0.3608P AD=0.3608P
+ PS=2.52U PD=2.52U
* device instance $524 m0 *1 592,825.81 nfet_05v0
M$524 \$I2693 \$I2685 VSS VSS nfet_05v0 L=1U W=0.82U AS=0.3608P AD=0.3608P
+ PS=2.52U PD=2.52U
* device instance $525 m0 *1 594.24,825.81 nfet_05v0
M$525 \$I2694 \$I2686 VSS VSS nfet_05v0 L=1U W=0.82U AS=0.3608P AD=0.3608P
+ PS=2.52U PD=2.52U
* device instance $526 m0 *1 596.48,825.81 nfet_05v0
M$526 \$I2695 \$I2687 VSS VSS nfet_05v0 L=1U W=0.82U AS=0.3608P AD=0.3608P
+ PS=2.52U PD=2.52U
* device instance $527 m0 *1 598.72,825.81 nfet_05v0
M$527 \$I2696 \$I2688 VSS VSS nfet_05v0 L=1U W=0.82U AS=0.3608P AD=0.3608P
+ PS=2.52U PD=2.52U
* device instance $528 m0 *1 589.76,825.81 nfet_05v0
M$528 \$I2692 \$I2684 VSS VSS nfet_05v0 L=1U W=0.82U AS=0.3608P AD=0.3608P
+ PS=2.52U PD=2.52U
* device instance $529 m0 *1 504.64,831.43 pfet_05v0
M$529 VDD_DEC \$I2714 \$I2706 VDD_DEC pfet_05v0 L=1U W=1.22U AS=0.5368P
+ AD=0.5368P PS=3.32U PD=3.32U
* device instance $530 m0 *1 497.92,831.43 pfet_05v0
M$530 VDD_DEC \$I2711 \$I2703 VDD_DEC pfet_05v0 L=1U W=1.22U AS=0.5368P
+ AD=0.5368P PS=3.32U PD=3.32U
* device instance $531 m0 *1 491.2,831.43 pfet_05v0
M$531 VDD_DEC \$I2708 \$I2700 VDD_DEC pfet_05v0 L=1U W=1.22U AS=0.5368P
+ AD=0.5368P PS=3.32U PD=3.32U
* device instance $532 m0 *1 500.16,831.43 pfet_05v0
M$532 VDD_DEC \$I2712 \$I2704 VDD_DEC pfet_05v0 L=1U W=1.22U AS=0.5368P
+ AD=0.5368P PS=3.32U PD=3.32U
* device instance $533 m0 *1 493.44,831.43 pfet_05v0
M$533 VDD_DEC \$I2709 \$I2701 VDD_DEC pfet_05v0 L=1U W=1.22U AS=0.5368P
+ AD=0.5368P PS=3.32U PD=3.32U
* device instance $534 m0 *1 502.4,831.43 pfet_05v0
M$534 VDD_DEC \$I2713 \$I2705 VDD_DEC pfet_05v0 L=1U W=1.22U AS=0.5368P
+ AD=0.5368P PS=3.32U PD=3.32U
* device instance $535 m0 *1 488.96,831.43 pfet_05v0
M$535 VDD_DEC \$I2707 \$I2699 VDD_DEC pfet_05v0 L=1U W=1.22U AS=0.5368P
+ AD=0.5368P PS=3.32U PD=3.32U
* device instance $536 m0 *1 495.68,831.43 pfet_05v0
M$536 VDD_DEC \$I2710 \$I2702 VDD_DEC pfet_05v0 L=1U W=1.22U AS=0.5368P
+ AD=0.5368P PS=3.32U PD=3.32U
* device instance $537 m0 *1 504.64,833.65 nfet_05v0
M$537 \$I2714 \$I2706 VSS VSS nfet_05v0 L=1U W=0.82U AS=0.3608P AD=0.3608P
+ PS=2.52U PD=2.52U
* device instance $538 m0 *1 502.4,833.65 nfet_05v0
M$538 \$I2713 \$I2705 VSS VSS nfet_05v0 L=1U W=0.82U AS=0.3608P AD=0.3608P
+ PS=2.52U PD=2.52U
* device instance $539 m0 *1 488.96,833.65 nfet_05v0
M$539 \$I2707 \$I2699 VSS VSS nfet_05v0 L=1U W=0.82U AS=0.3608P AD=0.3608P
+ PS=2.52U PD=2.52U
* device instance $540 m0 *1 493.44,833.65 nfet_05v0
M$540 \$I2709 \$I2701 VSS VSS nfet_05v0 L=1U W=0.82U AS=0.3608P AD=0.3608P
+ PS=2.52U PD=2.52U
* device instance $541 m0 *1 495.68,833.65 nfet_05v0
M$541 \$I2710 \$I2702 VSS VSS nfet_05v0 L=1U W=0.82U AS=0.3608P AD=0.3608P
+ PS=2.52U PD=2.52U
* device instance $542 m0 *1 497.92,833.65 nfet_05v0
M$542 \$I2711 \$I2703 VSS VSS nfet_05v0 L=1U W=0.82U AS=0.3608P AD=0.3608P
+ PS=2.52U PD=2.52U
* device instance $543 m0 *1 500.16,833.65 nfet_05v0
M$543 \$I2712 \$I2704 VSS VSS nfet_05v0 L=1U W=0.82U AS=0.3608P AD=0.3608P
+ PS=2.52U PD=2.52U
* device instance $544 m0 *1 491.2,833.65 nfet_05v0
M$544 \$I2708 \$I2700 VSS VSS nfet_05v0 L=1U W=0.82U AS=0.3608P AD=0.3608P
+ PS=2.52U PD=2.52U
* device instance $545 r0 *1 580.8,837.37 pfet_05v0
M$545 VDD_DEC \$I2730 \$I2722 VDD_DEC pfet_05v0 L=1U W=1.22U AS=0.5368P
+ AD=0.5368P PS=3.32U PD=3.32U
* device instance $546 r0 *1 574.08,837.37 pfet_05v0
M$546 VDD_DEC \$I2727 \$I2719 VDD_DEC pfet_05v0 L=1U W=1.22U AS=0.5368P
+ AD=0.5368P PS=3.32U PD=3.32U
* device instance $547 r0 *1 567.36,837.37 pfet_05v0
M$547 VDD_DEC \$I2724 \$I2716 VDD_DEC pfet_05v0 L=1U W=1.22U AS=0.5368P
+ AD=0.5368P PS=3.32U PD=3.32U
* device instance $548 r0 *1 576.32,837.37 pfet_05v0
M$548 VDD_DEC \$I2728 \$I2720 VDD_DEC pfet_05v0 L=1U W=1.22U AS=0.5368P
+ AD=0.5368P PS=3.32U PD=3.32U
* device instance $549 r0 *1 569.6,837.37 pfet_05v0
M$549 VDD_DEC \$I2725 \$I2717 VDD_DEC pfet_05v0 L=1U W=1.22U AS=0.5368P
+ AD=0.5368P PS=3.32U PD=3.32U
* device instance $550 r0 *1 578.56,837.37 pfet_05v0
M$550 VDD_DEC \$I2729 \$I2721 VDD_DEC pfet_05v0 L=1U W=1.22U AS=0.5368P
+ AD=0.5368P PS=3.32U PD=3.32U
* device instance $551 r0 *1 565.12,837.37 pfet_05v0
M$551 VDD_DEC \$I2723 \$I2715 VDD_DEC pfet_05v0 L=1U W=1.22U AS=0.5368P
+ AD=0.5368P PS=3.32U PD=3.32U
* device instance $552 r0 *1 571.84,837.37 pfet_05v0
M$552 VDD_DEC \$I2726 \$I2718 VDD_DEC pfet_05v0 L=1U W=1.22U AS=0.5368P
+ AD=0.5368P PS=3.32U PD=3.32U
* device instance $553 r0 *1 580.8,835.15 nfet_05v0
M$553 \$I2730 \$I2722 VSS VSS nfet_05v0 L=1U W=0.82U AS=0.3608P AD=0.3608P
+ PS=2.52U PD=2.52U
* device instance $554 r0 *1 578.56,835.15 nfet_05v0
M$554 \$I2729 \$I2721 VSS VSS nfet_05v0 L=1U W=0.82U AS=0.3608P AD=0.3608P
+ PS=2.52U PD=2.52U
* device instance $555 r0 *1 565.12,835.15 nfet_05v0
M$555 \$I2723 \$I2715 VSS VSS nfet_05v0 L=1U W=0.82U AS=0.3608P AD=0.3608P
+ PS=2.52U PD=2.52U
* device instance $556 r0 *1 569.6,835.15 nfet_05v0
M$556 \$I2725 \$I2717 VSS VSS nfet_05v0 L=1U W=0.82U AS=0.3608P AD=0.3608P
+ PS=2.52U PD=2.52U
* device instance $557 r0 *1 571.84,835.15 nfet_05v0
M$557 \$I2726 \$I2718 VSS VSS nfet_05v0 L=1U W=0.82U AS=0.3608P AD=0.3608P
+ PS=2.52U PD=2.52U
* device instance $558 r0 *1 574.08,835.15 nfet_05v0
M$558 \$I2727 \$I2719 VSS VSS nfet_05v0 L=1U W=0.82U AS=0.3608P AD=0.3608P
+ PS=2.52U PD=2.52U
* device instance $559 r0 *1 576.32,835.15 nfet_05v0
M$559 \$I2728 \$I2720 VSS VSS nfet_05v0 L=1U W=0.82U AS=0.3608P AD=0.3608P
+ PS=2.52U PD=2.52U
* device instance $560 r0 *1 567.36,835.15 nfet_05v0
M$560 \$I2724 \$I2716 VSS VSS nfet_05v0 L=1U W=0.82U AS=0.3608P AD=0.3608P
+ PS=2.52U PD=2.52U
* device instance $561 r0 *1 637.92,837.37 pfet_05v0
M$561 VDD_DEC \$I2746 \$I2738 VDD_DEC pfet_05v0 L=1U W=1.22U AS=0.5368P
+ AD=0.5368P PS=3.32U PD=3.32U
* device instance $562 r0 *1 631.2,837.37 pfet_05v0
M$562 VDD_DEC \$I2743 \$I2735 VDD_DEC pfet_05v0 L=1U W=1.22U AS=0.5368P
+ AD=0.5368P PS=3.32U PD=3.32U
* device instance $563 r0 *1 624.48,837.37 pfet_05v0
M$563 VDD_DEC \$I2740 \$I2732 VDD_DEC pfet_05v0 L=1U W=1.22U AS=0.5368P
+ AD=0.5368P PS=3.32U PD=3.32U
* device instance $564 r0 *1 633.44,837.37 pfet_05v0
M$564 VDD_DEC \$I2744 \$I2736 VDD_DEC pfet_05v0 L=1U W=1.22U AS=0.5368P
+ AD=0.5368P PS=3.32U PD=3.32U
* device instance $565 r0 *1 626.72,837.37 pfet_05v0
M$565 VDD_DEC \$I2741 \$I2733 VDD_DEC pfet_05v0 L=1U W=1.22U AS=0.5368P
+ AD=0.5368P PS=3.32U PD=3.32U
* device instance $566 r0 *1 635.68,837.37 pfet_05v0
M$566 VDD_DEC \$I2745 \$I2737 VDD_DEC pfet_05v0 L=1U W=1.22U AS=0.5368P
+ AD=0.5368P PS=3.32U PD=3.32U
* device instance $567 r0 *1 622.24,837.37 pfet_05v0
M$567 VDD_DEC \$I2739 \$I2731 VDD_DEC pfet_05v0 L=1U W=1.22U AS=0.5368P
+ AD=0.5368P PS=3.32U PD=3.32U
* device instance $568 r0 *1 628.96,837.37 pfet_05v0
M$568 VDD_DEC \$I2742 \$I2734 VDD_DEC pfet_05v0 L=1U W=1.22U AS=0.5368P
+ AD=0.5368P PS=3.32U PD=3.32U
* device instance $569 r0 *1 637.92,835.15 nfet_05v0
M$569 \$I2746 \$I2738 VSS VSS nfet_05v0 L=1U W=0.82U AS=0.3608P AD=0.3608P
+ PS=2.52U PD=2.52U
* device instance $570 r0 *1 635.68,835.15 nfet_05v0
M$570 \$I2745 \$I2737 VSS VSS nfet_05v0 L=1U W=0.82U AS=0.3608P AD=0.3608P
+ PS=2.52U PD=2.52U
* device instance $571 r0 *1 622.24,835.15 nfet_05v0
M$571 \$I2739 \$I2731 VSS VSS nfet_05v0 L=1U W=0.82U AS=0.3608P AD=0.3608P
+ PS=2.52U PD=2.52U
* device instance $572 r0 *1 626.72,835.15 nfet_05v0
M$572 \$I2741 \$I2733 VSS VSS nfet_05v0 L=1U W=0.82U AS=0.3608P AD=0.3608P
+ PS=2.52U PD=2.52U
* device instance $573 r0 *1 628.96,835.15 nfet_05v0
M$573 \$I2742 \$I2734 VSS VSS nfet_05v0 L=1U W=0.82U AS=0.3608P AD=0.3608P
+ PS=2.52U PD=2.52U
* device instance $574 r0 *1 631.2,835.15 nfet_05v0
M$574 \$I2743 \$I2735 VSS VSS nfet_05v0 L=1U W=0.82U AS=0.3608P AD=0.3608P
+ PS=2.52U PD=2.52U
* device instance $575 r0 *1 633.44,835.15 nfet_05v0
M$575 \$I2744 \$I2736 VSS VSS nfet_05v0 L=1U W=0.82U AS=0.3608P AD=0.3608P
+ PS=2.52U PD=2.52U
* device instance $576 r0 *1 624.48,835.15 nfet_05v0
M$576 \$I2740 \$I2732 VSS VSS nfet_05v0 L=1U W=0.82U AS=0.3608P AD=0.3608P
+ PS=2.52U PD=2.52U
* device instance $577 r0 *1 602.64,829.53 pfet_05v0
M$577 VDD_DEC \$I2762 \$I2754 VDD_DEC pfet_05v0 L=1U W=1.22U AS=0.5368P
+ AD=0.5368P PS=3.32U PD=3.32U
* device instance $578 r0 *1 595.92,829.53 pfet_05v0
M$578 VDD_DEC \$I2759 \$I2751 VDD_DEC pfet_05v0 L=1U W=1.22U AS=0.5368P
+ AD=0.5368P PS=3.32U PD=3.32U
* device instance $579 r0 *1 589.2,829.53 pfet_05v0
M$579 VDD_DEC \$I2756 \$I2748 VDD_DEC pfet_05v0 L=1U W=1.22U AS=0.5368P
+ AD=0.5368P PS=3.32U PD=3.32U
* device instance $580 r0 *1 598.16,829.53 pfet_05v0
M$580 VDD_DEC \$I2760 \$I2752 VDD_DEC pfet_05v0 L=1U W=1.22U AS=0.5368P
+ AD=0.5368P PS=3.32U PD=3.32U
* device instance $581 r0 *1 591.44,829.53 pfet_05v0
M$581 VDD_DEC \$I2757 \$I2749 VDD_DEC pfet_05v0 L=1U W=1.22U AS=0.5368P
+ AD=0.5368P PS=3.32U PD=3.32U
* device instance $582 r0 *1 600.4,829.53 pfet_05v0
M$582 VDD_DEC \$I2761 \$I2753 VDD_DEC pfet_05v0 L=1U W=1.22U AS=0.5368P
+ AD=0.5368P PS=3.32U PD=3.32U
* device instance $583 r0 *1 586.96,829.53 pfet_05v0
M$583 VDD_DEC \$I2755 \$I2747 VDD_DEC pfet_05v0 L=1U W=1.22U AS=0.5368P
+ AD=0.5368P PS=3.32U PD=3.32U
* device instance $584 r0 *1 593.68,829.53 pfet_05v0
M$584 VDD_DEC \$I2758 \$I2750 VDD_DEC pfet_05v0 L=1U W=1.22U AS=0.5368P
+ AD=0.5368P PS=3.32U PD=3.32U
* device instance $585 r0 *1 602.64,827.31 nfet_05v0
M$585 \$I2762 \$I2754 VSS VSS nfet_05v0 L=1U W=0.82U AS=0.3608P AD=0.3608P
+ PS=2.52U PD=2.52U
* device instance $586 r0 *1 600.4,827.31 nfet_05v0
M$586 \$I2761 \$I2753 VSS VSS nfet_05v0 L=1U W=0.82U AS=0.3608P AD=0.3608P
+ PS=2.52U PD=2.52U
* device instance $587 r0 *1 586.96,827.31 nfet_05v0
M$587 \$I2755 \$I2747 VSS VSS nfet_05v0 L=1U W=0.82U AS=0.3608P AD=0.3608P
+ PS=2.52U PD=2.52U
* device instance $588 r0 *1 591.44,827.31 nfet_05v0
M$588 \$I2757 \$I2749 VSS VSS nfet_05v0 L=1U W=0.82U AS=0.3608P AD=0.3608P
+ PS=2.52U PD=2.52U
* device instance $589 r0 *1 593.68,827.31 nfet_05v0
M$589 \$I2758 \$I2750 VSS VSS nfet_05v0 L=1U W=0.82U AS=0.3608P AD=0.3608P
+ PS=2.52U PD=2.52U
* device instance $590 r0 *1 595.92,827.31 nfet_05v0
M$590 \$I2759 \$I2751 VSS VSS nfet_05v0 L=1U W=0.82U AS=0.3608P AD=0.3608P
+ PS=2.52U PD=2.52U
* device instance $591 r0 *1 598.16,827.31 nfet_05v0
M$591 \$I2760 \$I2752 VSS VSS nfet_05v0 L=1U W=0.82U AS=0.3608P AD=0.3608P
+ PS=2.52U PD=2.52U
* device instance $592 r0 *1 589.2,827.31 nfet_05v0
M$592 \$I2756 \$I2748 VSS VSS nfet_05v0 L=1U W=0.82U AS=0.3608P AD=0.3608P
+ PS=2.52U PD=2.52U
* device instance $593 m0 *1 669.84,831.43 pfet_05v0
M$593 VDD_DEC \$I2766 \$I2765 VDD_DEC pfet_05v0 L=1U W=1.22U AS=0.5368P
+ AD=0.5368P PS=3.32U PD=3.32U
* device instance $594 m0 *1 667.6,831.43 pfet_05v0
M$594 VDD_DEC \$I2764 \$I2763 VDD_DEC pfet_05v0 L=1U W=1.22U AS=0.5368P
+ AD=0.5368P PS=3.32U PD=3.32U
* device instance $595 m0 *1 669.84,833.65 nfet_05v0
M$595 \$I2766 \$I2765 VSS VSS nfet_05v0 L=1U W=0.82U AS=0.3608P AD=0.3608P
+ PS=2.52U PD=2.52U
* device instance $596 m0 *1 667.6,833.65 nfet_05v0
M$596 \$I2764 \$I2763 VSS VSS nfet_05v0 L=1U W=0.82U AS=0.3608P AD=0.3608P
+ PS=2.52U PD=2.52U
* device instance $597 m0 *1 500.16,823.59 pfet_05v0
M$597 VDD_DEC \$I2770 \$I2769 VDD_DEC pfet_05v0 L=1U W=1.22U AS=0.5368P
+ AD=0.5368P PS=3.32U PD=3.32U
* device instance $598 m0 *1 497.92,823.59 pfet_05v0
M$598 VDD_DEC \$I2768 \$I2767 VDD_DEC pfet_05v0 L=1U W=1.22U AS=0.5368P
+ AD=0.5368P PS=3.32U PD=3.32U
* device instance $599 m0 *1 500.16,825.81 nfet_05v0
M$599 \$I2770 \$I2769 VSS VSS nfet_05v0 L=1U W=0.82U AS=0.3608P AD=0.3608P
+ PS=2.52U PD=2.52U
* device instance $600 m0 *1 497.92,825.81 nfet_05v0
M$600 \$I2768 \$I2767 VSS VSS nfet_05v0 L=1U W=0.82U AS=0.3608P AD=0.3608P
+ PS=2.52U PD=2.52U
* device instance $601 r0 *1 491.2,821.69 pfet_05v0
M$601 VDD_DEC \$I2774 \$I2773 VDD_DEC pfet_05v0 L=1U W=1.22U AS=0.5368P
+ AD=0.5368P PS=3.32U PD=3.32U
* device instance $602 r0 *1 488.96,821.69 pfet_05v0
M$602 VDD_DEC \$I2772 \$I2771 VDD_DEC pfet_05v0 L=1U W=1.22U AS=0.5368P
+ AD=0.5368P PS=3.32U PD=3.32U
* device instance $603 r0 *1 491.2,819.47 nfet_05v0
M$603 \$I2774 \$I2773 VSS VSS nfet_05v0 L=1U W=0.82U AS=0.3608P AD=0.3608P
+ PS=2.52U PD=2.52U
* device instance $604 r0 *1 488.96,819.47 nfet_05v0
M$604 \$I2772 \$I2771 VSS VSS nfet_05v0 L=1U W=0.82U AS=0.3608P AD=0.3608P
+ PS=2.52U PD=2.52U
* device instance $605 r0 *1 667.6,829.53 pfet_05v0
M$605 VDD_DEC \$I2778 \$I2777 VDD_DEC pfet_05v0 L=1U W=1.22U AS=0.5368P
+ AD=0.5368P PS=3.32U PD=3.32U
* device instance $606 r0 *1 665.36,829.53 pfet_05v0
M$606 VDD_DEC \$I2776 \$I2775 VDD_DEC pfet_05v0 L=1U W=1.22U AS=0.5368P
+ AD=0.5368P PS=3.32U PD=3.32U
* device instance $607 r0 *1 667.6,827.31 nfet_05v0
M$607 \$I2778 \$I2777 VSS VSS nfet_05v0 L=1U W=0.82U AS=0.3608P AD=0.3608P
+ PS=2.52U PD=2.52U
* device instance $608 r0 *1 665.36,827.31 nfet_05v0
M$608 \$I2776 \$I2775 VSS VSS nfet_05v0 L=1U W=0.82U AS=0.3608P AD=0.3608P
+ PS=2.52U PD=2.52U
* device instance $609 r0 *1 583.6,829.53 pfet_05v0
M$609 VDD_DEC \$I2782 \$I2781 VDD_DEC pfet_05v0 L=1U W=1.22U AS=0.5368P
+ AD=0.5368P PS=3.32U PD=3.32U
* device instance $610 r0 *1 581.36,829.53 pfet_05v0
M$610 VDD_DEC \$I2780 \$I2779 VDD_DEC pfet_05v0 L=1U W=1.22U AS=0.5368P
+ AD=0.5368P PS=3.32U PD=3.32U
* device instance $611 r0 *1 583.6,827.31 nfet_05v0
M$611 \$I2782 \$I2781 VSS VSS nfet_05v0 L=1U W=0.82U AS=0.3608P AD=0.3608P
+ PS=2.52U PD=2.52U
* device instance $612 r0 *1 581.36,827.31 nfet_05v0
M$612 \$I2780 \$I2779 VSS VSS nfet_05v0 L=1U W=0.82U AS=0.3608P AD=0.3608P
+ PS=2.52U PD=2.52U
* device instance $613 r0 *1 667.6,821.69 pfet_05v0
M$613 VDD_DEC \$I2786 \$I2785 VDD_DEC pfet_05v0 L=1U W=1.22U AS=0.5368P
+ AD=0.5368P PS=3.32U PD=3.32U
* device instance $614 r0 *1 665.36,821.69 pfet_05v0
M$614 VDD_DEC \$I2784 \$I2783 VDD_DEC pfet_05v0 L=1U W=1.22U AS=0.5368P
+ AD=0.5368P PS=3.32U PD=3.32U
* device instance $615 r0 *1 667.6,819.47 nfet_05v0
M$615 \$I2786 \$I2785 VSS VSS nfet_05v0 L=1U W=0.82U AS=0.3608P AD=0.3608P
+ PS=2.52U PD=2.52U
* device instance $616 r0 *1 665.36,819.47 nfet_05v0
M$616 \$I2784 \$I2783 VSS VSS nfet_05v0 L=1U W=0.82U AS=0.3608P AD=0.3608P
+ PS=2.52U PD=2.52U
* device instance $617 r0 *1 491.2,837.37 pfet_05v0
M$617 VDD_DEC \$I2790 \$I2789 VDD_DEC pfet_05v0 L=1U W=1.22U AS=0.5368P
+ AD=0.5368P PS=3.32U PD=3.32U
* device instance $618 r0 *1 488.96,837.37 pfet_05v0
M$618 VDD_DEC \$I2788 \$I2787 VDD_DEC pfet_05v0 L=1U W=1.22U AS=0.5368P
+ AD=0.5368P PS=3.32U PD=3.32U
* device instance $619 r0 *1 491.2,835.15 nfet_05v0
M$619 \$I2790 \$I2789 VSS VSS nfet_05v0 L=1U W=0.82U AS=0.3608P AD=0.3608P
+ PS=2.52U PD=2.52U
* device instance $620 r0 *1 488.96,835.15 nfet_05v0
M$620 \$I2788 \$I2787 VSS VSS nfet_05v0 L=1U W=0.82U AS=0.3608P AD=0.3608P
+ PS=2.52U PD=2.52U
* device instance $621 r0 *1 605.44,837.37 pfet_05v0
M$621 VDD_DEC \$I2794 \$I2793 VDD_DEC pfet_05v0 L=1U W=1.22U AS=0.5368P
+ AD=0.5368P PS=3.32U PD=3.32U
* device instance $622 r0 *1 603.2,837.37 pfet_05v0
M$622 VDD_DEC \$I2792 \$I2791 VDD_DEC pfet_05v0 L=1U W=1.22U AS=0.5368P
+ AD=0.5368P PS=3.32U PD=3.32U
* device instance $623 r0 *1 605.44,835.15 nfet_05v0
M$623 \$I2794 \$I2793 VSS VSS nfet_05v0 L=1U W=0.82U AS=0.3608P AD=0.3608P
+ PS=2.52U PD=2.52U
* device instance $624 r0 *1 603.2,835.15 nfet_05v0
M$624 \$I2792 \$I2791 VSS VSS nfet_05v0 L=1U W=0.82U AS=0.3608P AD=0.3608P
+ PS=2.52U PD=2.52U
* device instance $625 r0 *1 500.16,829.53 pfet_05v0
M$625 VDD_DEC \$I2798 \$I2797 VDD_DEC pfet_05v0 L=1U W=1.22U AS=0.5368P
+ AD=0.5368P PS=3.32U PD=3.32U
* device instance $626 r0 *1 497.92,829.53 pfet_05v0
M$626 VDD_DEC \$I2796 \$I2795 VDD_DEC pfet_05v0 L=1U W=1.22U AS=0.5368P
+ AD=0.5368P PS=3.32U PD=3.32U
* device instance $627 r0 *1 500.16,827.31 nfet_05v0
M$627 \$I2798 \$I2797 VSS VSS nfet_05v0 L=1U W=0.82U AS=0.3608P AD=0.3608P
+ PS=2.52U PD=2.52U
* device instance $628 r0 *1 497.92,827.31 nfet_05v0
M$628 \$I2796 \$I2795 VSS VSS nfet_05v0 L=1U W=0.82U AS=0.3608P AD=0.3608P
+ PS=2.52U PD=2.52U
* device instance $629 m0 *1 491.2,815.75 pfet_05v0
M$629 VDD_DEC \$I2802 \$I2801 VDD_DEC pfet_05v0 L=1U W=1.22U AS=0.5368P
+ AD=0.5368P PS=3.32U PD=3.32U
* device instance $630 m0 *1 488.96,815.75 pfet_05v0
M$630 VDD_DEC \$I2800 \$I2799 VDD_DEC pfet_05v0 L=1U W=1.22U AS=0.5368P
+ AD=0.5368P PS=3.32U PD=3.32U
* device instance $631 m0 *1 491.2,817.97 nfet_05v0
M$631 \$I2802 \$I2801 VSS VSS nfet_05v0 L=1U W=0.82U AS=0.3608P AD=0.3608P
+ PS=2.52U PD=2.52U
* device instance $632 m0 *1 488.96,817.97 nfet_05v0
M$632 \$I2800 \$I2799 VSS VSS nfet_05v0 L=1U W=0.82U AS=0.3608P AD=0.3608P
+ PS=2.52U PD=2.52U
* device instance $633 m0 *1 607.005,823.628 pfet_05v0
M$633 \$I2324 \$I2366 VDD_DEC VDD_DEC pfet_05v0 L=0.5U W=0.985U AS=0.4334P
+ AD=0.2561P PS=2.85U PD=1.505U
* device instance $634 m0 *1 608.025,823.628 pfet_05v0
M$634 VDD_DEC \$I2285 \$I2324 VDD_DEC pfet_05v0 L=0.5U W=0.985U AS=0.2561P
+ AD=0.2561P PS=1.505U PD=1.505U
* device instance $635 m0 *1 609.045,823.628 pfet_05v0
M$635 \$I2324 \$I2287 VDD_DEC VDD_DEC pfet_05v0 L=0.5U W=0.985U AS=0.2561P
+ AD=0.4334P PS=1.505U PD=2.85U
* device instance $636 m0 *1 607.055,825.81 nfet_05v0
M$636 \$I2804 \$I2366 VSS VSS nfet_05v0 L=0.6U W=0.82U AS=0.3608P AD=0.1312P
+ PS=2.52U PD=1.14U
* device instance $637 m0 *1 607.975,825.81 nfet_05v0
M$637 \$I2803 \$I2285 \$I2804 VSS nfet_05v0 L=0.6U W=0.82U AS=0.1312P
+ AD=0.1722P PS=1.14U PD=1.24U
* device instance $638 m0 *1 608.995,825.81 nfet_05v0
M$638 \$I2324 \$I2287 \$I2803 VSS nfet_05v0 L=0.6U W=0.82U AS=0.1722P
+ AD=0.3608P PS=1.24U PD=2.52U
* device instance $639 m0 *1 562.205,823.628 pfet_05v0
M$639 \$I2339 \$I2335 VDD_DEC VDD_DEC pfet_05v0 L=0.5U W=0.985U AS=0.4334P
+ AD=0.2561P PS=2.85U PD=1.505U
* device instance $640 m0 *1 563.225,823.628 pfet_05v0
M$640 VDD_DEC \$I2337 \$I2339 VDD_DEC pfet_05v0 L=0.5U W=0.985U AS=0.2561P
+ AD=0.2561P PS=1.505U PD=1.505U
* device instance $641 m0 *1 564.245,823.628 pfet_05v0
M$641 \$I2339 \$I2383 VDD_DEC VDD_DEC pfet_05v0 L=0.5U W=0.985U AS=0.2561P
+ AD=0.4334P PS=1.505U PD=2.85U
* device instance $642 m0 *1 562.255,825.81 nfet_05v0
M$642 \$I2806 \$I2335 VSS VSS nfet_05v0 L=0.6U W=0.82U AS=0.3608P AD=0.1312P
+ PS=2.52U PD=1.14U
* device instance $643 m0 *1 563.175,825.81 nfet_05v0
M$643 \$I2805 \$I2337 \$I2806 VSS nfet_05v0 L=0.6U W=0.82U AS=0.1312P
+ AD=0.1722P PS=1.14U PD=1.24U
* device instance $644 m0 *1 564.195,825.81 nfet_05v0
M$644 \$I2339 \$I2383 \$I2805 VSS nfet_05v0 L=0.6U W=0.82U AS=0.1722P
+ AD=0.3608P PS=1.24U PD=2.52U
* device instance $645 r180 *1 562.995,831.468 pfet_05v0
M$645 \$I2382 \$I2354 VDD_DEC VDD_DEC pfet_05v0 L=0.5U W=0.985U AS=0.4334P
+ AD=0.2561P PS=2.85U PD=1.505U
* device instance $646 r180 *1 561.975,831.468 pfet_05v0
M$646 VDD_DEC \$I2322 \$I2382 VDD_DEC pfet_05v0 L=0.5U W=0.985U AS=0.2561P
+ AD=0.2561P PS=1.505U PD=1.505U
* device instance $647 r180 *1 560.955,831.468 pfet_05v0
M$647 \$I2382 \$I2353 VDD_DEC VDD_DEC pfet_05v0 L=0.5U W=0.985U AS=0.2561P
+ AD=0.4334P PS=1.505U PD=2.85U
* device instance $648 r180 *1 562.945,833.65 nfet_05v0
M$648 \$I2808 \$I2354 VSS VSS nfet_05v0 L=0.6U W=0.82U AS=0.3608P AD=0.1312P
+ PS=2.52U PD=1.14U
* device instance $649 r180 *1 562.025,833.65 nfet_05v0
M$649 \$I2807 \$I2322 \$I2808 VSS nfet_05v0 L=0.6U W=0.82U AS=0.1312P
+ AD=0.1722P PS=1.14U PD=1.24U
* device instance $650 r180 *1 561.005,833.65 nfet_05v0
M$650 \$I2382 \$I2353 \$I2807 VSS nfet_05v0 L=0.6U W=0.82U AS=0.1722P
+ AD=0.3608P PS=1.24U PD=2.52U
* device instance $651 r0 *1 577.325,829.492 pfet_05v0
M$651 \$I2340 \$I2407 VDD_DEC VDD_DEC pfet_05v0 L=0.5U W=0.985U AS=0.4334P
+ AD=0.2561P PS=2.85U PD=1.505U
* device instance $652 r0 *1 578.345,829.492 pfet_05v0
M$652 VDD_DEC \$I2211 \$I2340 VDD_DEC pfet_05v0 L=0.5U W=0.985U AS=0.2561P
+ AD=0.2561P PS=1.505U PD=1.505U
* device instance $653 r0 *1 579.365,829.492 pfet_05v0
M$653 \$I2340 \$I2384 VDD_DEC VDD_DEC pfet_05v0 L=0.5U W=0.985U AS=0.2561P
+ AD=0.4334P PS=1.505U PD=2.85U
* device instance $654 r0 *1 577.375,827.31 nfet_05v0
M$654 \$I2810 \$I2407 VSS VSS nfet_05v0 L=0.6U W=0.82U AS=0.3608P AD=0.1312P
+ PS=2.52U PD=1.14U
* device instance $655 r0 *1 578.295,827.31 nfet_05v0
M$655 \$I2809 \$I2211 \$I2810 VSS nfet_05v0 L=0.6U W=0.82U AS=0.1312P
+ AD=0.1722P PS=1.14U PD=1.24U
* device instance $656 r0 *1 579.315,827.31 nfet_05v0
M$656 \$I2340 \$I2384 \$I2809 VSS nfet_05v0 L=0.6U W=0.82U AS=0.1722P
+ AD=0.3608P PS=1.24U PD=2.52U
* device instance $657 r0 *1 515.725,813.812 pfet_05v0
M$657 \$I2357 \$I2364 VDD_DEC VDD_DEC pfet_05v0 L=0.5U W=0.985U AS=0.4334P
+ AD=0.2561P PS=2.85U PD=1.505U
* device instance $658 r0 *1 516.745,813.812 pfet_05v0
M$658 VDD_DEC \$I2379 \$I2357 VDD_DEC pfet_05v0 L=0.5U W=0.985U AS=0.2561P
+ AD=0.2561P PS=1.505U PD=1.505U
* device instance $659 r0 *1 517.765,813.812 pfet_05v0
M$659 \$I2357 \$I2354 VDD_DEC VDD_DEC pfet_05v0 L=0.5U W=0.985U AS=0.2561P
+ AD=0.4334P PS=1.505U PD=2.85U
* device instance $660 r0 *1 515.775,811.63 nfet_05v0
M$660 \$I2812 \$I2364 VSS VSS nfet_05v0 L=0.6U W=0.82U AS=0.3608P AD=0.1312P
+ PS=2.52U PD=1.14U
* device instance $661 r0 *1 516.695,811.63 nfet_05v0
M$661 \$I2811 \$I2379 \$I2812 VSS nfet_05v0 L=0.6U W=0.82U AS=0.1312P
+ AD=0.1722P PS=1.14U PD=1.24U
* device instance $662 r0 *1 517.715,811.63 nfet_05v0
M$662 \$I2357 \$I2354 \$I2811 VSS nfet_05v0 L=0.6U W=0.82U AS=0.1722P
+ AD=0.3608P PS=1.24U PD=2.52U
* device instance $663 m90 *1 515.375,821.872 pfet_05v0
M$663 \$I2400 \$I2364 VDD_DEC VDD_DEC pfet_05v0 L=0.5U W=0.845U AS=0.3718P
+ AD=0.2197P PS=2.57U PD=1.365U
* device instance $664 m90 *1 514.355,821.872 pfet_05v0
M$664 VDD_DEC \$I2250 \$I2400 VDD_DEC pfet_05v0 L=0.5U W=0.845U AS=0.2197P
+ AD=0.2197P PS=1.365U PD=1.365U
* device instance $665 m90 *1 513.335,821.872 pfet_05v0
M$665 \$I2400 \$I2329 VDD_DEC VDD_DEC pfet_05v0 L=0.5U W=0.845U AS=0.2197P
+ AD=0.2197P PS=1.365U PD=1.365U
* device instance $666 m90 *1 512.315,821.872 pfet_05v0
M$666 VDD_DEC \$I2361 \$I2400 VDD_DEC pfet_05v0 L=0.5U W=0.845U AS=0.2197P
+ AD=0.3718P PS=1.365U PD=2.57U
* device instance $667 m90 *1 515.325,819.47 nfet_05v0
M$667 \$I2815 \$I2364 VSS VSS nfet_05v0 L=0.6U W=0.82U AS=0.3608P AD=0.1517P
+ PS=2.52U PD=1.19U
* device instance $668 m90 *1 514.355,819.47 nfet_05v0
M$668 \$I2814 \$I2250 \$I2815 VSS nfet_05v0 L=0.6U W=0.82U AS=0.1517P
+ AD=0.1722P PS=1.19U PD=1.24U
* device instance $669 m90 *1 513.335,819.47 nfet_05v0
M$669 \$I2813 \$I2329 \$I2814 VSS nfet_05v0 L=0.6U W=0.82U AS=0.1722P
+ AD=0.1517P PS=1.24U PD=1.19U
* device instance $670 m90 *1 512.365,819.47 nfet_05v0
M$670 \$I2400 \$I2361 \$I2813 VSS nfet_05v0 L=0.6U W=0.82U AS=0.1517P
+ AD=0.3608P PS=1.19U PD=2.52U
* device instance $671 m0 *1 516.305,815.568 pfet_05v0
M$671 \$I2431 \$I2356 VDD_DEC VDD_DEC pfet_05v0 L=0.5U W=0.845U AS=0.3718P
+ AD=0.2197P PS=2.57U PD=1.365U
* device instance $672 m0 *1 517.325,815.568 pfet_05v0
M$672 VDD_DEC \$I2250 \$I2431 VDD_DEC pfet_05v0 L=0.5U W=0.845U AS=0.2197P
+ AD=0.2197P PS=1.365U PD=1.365U
* device instance $673 m0 *1 518.345,815.568 pfet_05v0
M$673 \$I2431 \$I2329 VDD_DEC VDD_DEC pfet_05v0 L=0.5U W=0.845U AS=0.2197P
+ AD=0.2197P PS=1.365U PD=1.365U
* device instance $674 m0 *1 519.365,815.568 pfet_05v0
M$674 VDD_DEC \$I2354 \$I2431 VDD_DEC pfet_05v0 L=0.5U W=0.845U AS=0.2197P
+ AD=0.3718P PS=1.365U PD=2.57U
* device instance $675 m0 *1 516.355,817.97 nfet_05v0
M$675 \$I2818 \$I2356 VSS VSS nfet_05v0 L=0.6U W=0.82U AS=0.3608P AD=0.1517P
+ PS=2.52U PD=1.19U
* device instance $676 m0 *1 517.325,817.97 nfet_05v0
M$676 \$I2817 \$I2250 \$I2818 VSS nfet_05v0 L=0.6U W=0.82U AS=0.1517P
+ AD=0.1722P PS=1.19U PD=1.24U
* device instance $677 m0 *1 518.345,817.97 nfet_05v0
M$677 \$I2816 \$I2329 \$I2817 VSS nfet_05v0 L=0.6U W=0.82U AS=0.1722P
+ AD=0.1517P PS=1.24U PD=1.19U
* device instance $678 m0 *1 519.315,817.97 nfet_05v0
M$678 \$I2431 \$I2354 \$I2816 VSS nfet_05v0 L=0.6U W=0.82U AS=0.1517P
+ AD=0.3608P PS=1.19U PD=2.52U
* device instance $679 m0 *1 492.785,807.728 pfet_05v0
M$679 \$I2247 \$I2329 VDD_DEC VDD_DEC pfet_05v0 L=0.5U W=0.845U AS=0.3718P
+ AD=0.2197P PS=2.57U PD=1.365U
* device instance $680 m0 *1 493.805,807.728 pfet_05v0
M$680 VDD_DEC \$I2354 \$I2247 VDD_DEC pfet_05v0 L=0.5U W=0.845U AS=0.2197P
+ AD=0.2197P PS=1.365U PD=1.365U
* device instance $681 m0 *1 494.825,807.728 pfet_05v0
M$681 \$I2247 \$I2322 VDD_DEC VDD_DEC pfet_05v0 L=0.5U W=0.845U AS=0.2197P
+ AD=0.2197P PS=1.365U PD=1.365U
* device instance $682 m0 *1 495.845,807.728 pfet_05v0
M$682 VDD_DEC \$I2303 \$I2247 VDD_DEC pfet_05v0 L=0.5U W=0.845U AS=0.2197P
+ AD=0.3718P PS=1.365U PD=2.57U
* device instance $683 m0 *1 492.835,810.13 nfet_05v0
M$683 \$I2821 \$I2329 VSS VSS nfet_05v0 L=0.6U W=0.82U AS=0.3608P AD=0.1517P
+ PS=2.52U PD=1.19U
* device instance $684 m0 *1 493.805,810.13 nfet_05v0
M$684 \$I2820 \$I2354 \$I2821 VSS nfet_05v0 L=0.6U W=0.82U AS=0.1517P
+ AD=0.1722P PS=1.19U PD=1.24U
* device instance $685 m0 *1 494.825,810.13 nfet_05v0
M$685 \$I2819 \$I2322 \$I2820 VSS nfet_05v0 L=0.6U W=0.82U AS=0.1722P
+ AD=0.1517P PS=1.24U PD=1.19U
* device instance $686 m0 *1 495.795,810.13 nfet_05v0
M$686 \$I2247 \$I2303 \$I2819 VSS nfet_05v0 L=0.6U W=0.82U AS=0.1517P
+ AD=0.3608P PS=1.19U PD=2.52U
* device instance $687 m0 *1 503.985,815.568 pfet_05v0
M$687 \$I2380 \$I2379 VDD_DEC VDD_DEC pfet_05v0 L=0.5U W=0.845U AS=0.3718P
+ AD=0.2197P PS=2.57U PD=1.365U
* device instance $688 m0 *1 505.005,815.568 pfet_05v0
M$688 VDD_DEC \$I2354 \$I2380 VDD_DEC pfet_05v0 L=0.5U W=0.845U AS=0.2197P
+ AD=0.2197P PS=1.365U PD=1.365U
* device instance $689 m0 *1 506.025,815.568 pfet_05v0
M$689 \$I2380 \$I2322 VDD_DEC VDD_DEC pfet_05v0 L=0.5U W=0.845U AS=0.2197P
+ AD=0.2197P PS=1.365U PD=1.365U
* device instance $690 m0 *1 507.045,815.568 pfet_05v0
M$690 VDD_DEC \$I2303 \$I2380 VDD_DEC pfet_05v0 L=0.5U W=0.845U AS=0.2197P
+ AD=0.3718P PS=1.365U PD=2.57U
* device instance $691 m0 *1 504.035,817.97 nfet_05v0
M$691 \$I2824 \$I2379 VSS VSS nfet_05v0 L=0.6U W=0.82U AS=0.3608P AD=0.1517P
+ PS=2.52U PD=1.19U
* device instance $692 m0 *1 505.005,817.97 nfet_05v0
M$692 \$I2823 \$I2354 \$I2824 VSS nfet_05v0 L=0.6U W=0.82U AS=0.1517P
+ AD=0.1722P PS=1.19U PD=1.24U
* device instance $693 m0 *1 506.025,817.97 nfet_05v0
M$693 \$I2822 \$I2322 \$I2823 VSS nfet_05v0 L=0.6U W=0.82U AS=0.1722P
+ AD=0.1517P PS=1.24U PD=1.19U
* device instance $694 m0 *1 506.995,817.97 nfet_05v0
M$694 \$I2380 \$I2303 \$I2822 VSS nfet_05v0 L=0.6U W=0.82U AS=0.1517P
+ AD=0.3608P PS=1.19U PD=2.52U
* device instance $695 m0 *1 519.665,823.408 pfet_05v0
M$695 \$I2234 \$I2364 VDD_DEC VDD_DEC pfet_05v0 L=0.5U W=0.845U AS=0.3718P
+ AD=0.2197P PS=2.57U PD=1.365U
* device instance $696 m0 *1 520.685,823.408 pfet_05v0
M$696 VDD_DEC \$I2358 \$I2234 VDD_DEC pfet_05v0 L=0.5U W=0.845U AS=0.2197P
+ AD=0.2197P PS=1.365U PD=1.365U
* device instance $697 m0 *1 521.705,823.408 pfet_05v0
M$697 \$I2234 \$I2329 VDD_DEC VDD_DEC pfet_05v0 L=0.5U W=0.845U AS=0.2197P
+ AD=0.2197P PS=1.365U PD=1.365U
* device instance $698 m0 *1 522.725,823.408 pfet_05v0
M$698 VDD_DEC \$I2361 \$I2234 VDD_DEC pfet_05v0 L=0.5U W=0.845U AS=0.2197P
+ AD=0.3718P PS=1.365U PD=2.57U
* device instance $699 m0 *1 519.715,825.81 nfet_05v0
M$699 \$I2827 \$I2364 VSS VSS nfet_05v0 L=0.6U W=0.82U AS=0.3608P AD=0.1517P
+ PS=2.52U PD=1.19U
* device instance $700 m0 *1 520.685,825.81 nfet_05v0
M$700 \$I2826 \$I2358 \$I2827 VSS nfet_05v0 L=0.6U W=0.82U AS=0.1517P
+ AD=0.1722P PS=1.19U PD=1.24U
* device instance $701 m0 *1 521.705,825.81 nfet_05v0
M$701 \$I2825 \$I2329 \$I2826 VSS nfet_05v0 L=0.6U W=0.82U AS=0.1722P
+ AD=0.1517P PS=1.24U PD=1.19U
* device instance $702 m0 *1 522.675,825.81 nfet_05v0
M$702 \$I2234 \$I2361 \$I2825 VSS nfet_05v0 L=0.6U W=0.82U AS=0.1517P
+ AD=0.3608P PS=1.19U PD=2.52U
* device instance $703 m0 *1 493.905,815.568 pfet_05v0
M$703 \$I2330 \$I2329 VDD_DEC VDD_DEC pfet_05v0 L=0.5U W=0.845U AS=0.3718P
+ AD=0.2197P PS=2.57U PD=1.365U
* device instance $704 m0 *1 494.925,815.568 pfet_05v0
M$704 VDD_DEC \$I2354 \$I2330 VDD_DEC pfet_05v0 L=0.5U W=0.845U AS=0.2197P
+ AD=0.2197P PS=1.365U PD=1.365U
* device instance $705 m0 *1 495.945,815.568 pfet_05v0
M$705 \$I2330 \$I2302 VDD_DEC VDD_DEC pfet_05v0 L=0.5U W=0.845U AS=0.2197P
+ AD=0.2197P PS=1.365U PD=1.365U
* device instance $706 m0 *1 496.965,815.568 pfet_05v0
M$706 VDD_DEC \$I2353 \$I2330 VDD_DEC pfet_05v0 L=0.5U W=0.845U AS=0.2197P
+ AD=0.3718P PS=1.365U PD=2.57U
* device instance $707 m0 *1 493.955,817.97 nfet_05v0
M$707 \$I2830 \$I2329 VSS VSS nfet_05v0 L=0.6U W=0.82U AS=0.3608P AD=0.1517P
+ PS=2.52U PD=1.19U
* device instance $708 m0 *1 494.925,817.97 nfet_05v0
M$708 \$I2829 \$I2354 \$I2830 VSS nfet_05v0 L=0.6U W=0.82U AS=0.1517P
+ AD=0.1722P PS=1.19U PD=1.24U
* device instance $709 m0 *1 495.945,817.97 nfet_05v0
M$709 \$I2828 \$I2302 \$I2829 VSS nfet_05v0 L=0.6U W=0.82U AS=0.1722P
+ AD=0.1517P PS=1.24U PD=1.19U
* device instance $710 m0 *1 496.915,817.97 nfet_05v0
M$710 \$I2330 \$I2353 \$I2828 VSS nfet_05v0 L=0.6U W=0.82U AS=0.1517P
+ AD=0.3608P PS=1.19U PD=2.52U
* device instance $711 m0 *1 575.105,823.408 pfet_05v0
M$711 \$I2283 \$I2407 VDD_DEC VDD_DEC pfet_05v0 L=0.5U W=0.845U AS=0.3718P
+ AD=0.2197P PS=2.57U PD=1.365U
* device instance $712 m0 *1 576.125,823.408 pfet_05v0
M$712 VDD_DEC \$I2212 \$I2283 VDD_DEC pfet_05v0 L=0.5U W=0.845U AS=0.2197P
+ AD=0.2197P PS=1.365U PD=1.365U
* device instance $713 m0 *1 577.145,823.408 pfet_05v0
M$713 \$I2283 \$I2284 VDD_DEC VDD_DEC pfet_05v0 L=0.5U W=0.845U AS=0.2197P
+ AD=0.2197P PS=1.365U PD=1.365U
* device instance $714 m0 *1 578.165,823.408 pfet_05v0
M$714 VDD_DEC \$I2384 \$I2283 VDD_DEC pfet_05v0 L=0.5U W=0.845U AS=0.2197P
+ AD=0.3718P PS=1.365U PD=2.57U
* device instance $715 m0 *1 575.155,825.81 nfet_05v0
M$715 \$I2833 \$I2407 VSS VSS nfet_05v0 L=0.6U W=0.82U AS=0.3608P AD=0.1517P
+ PS=2.52U PD=1.19U
* device instance $716 m0 *1 576.125,825.81 nfet_05v0
M$716 \$I2832 \$I2212 \$I2833 VSS nfet_05v0 L=0.6U W=0.82U AS=0.1517P
+ AD=0.1722P PS=1.19U PD=1.24U
* device instance $717 m0 *1 577.145,825.81 nfet_05v0
M$717 \$I2831 \$I2284 \$I2832 VSS nfet_05v0 L=0.6U W=0.82U AS=0.1722P
+ AD=0.1517P PS=1.24U PD=1.19U
* device instance $718 m0 *1 578.115,825.81 nfet_05v0
M$718 \$I2283 \$I2384 \$I2831 VSS nfet_05v0 L=0.6U W=0.82U AS=0.1517P
+ AD=0.3608P PS=1.19U PD=2.52U
* device instance $719 m0 *1 528.625,823.408 pfet_05v0
M$719 \$I2405 \$I2356 VDD_DEC VDD_DEC pfet_05v0 L=0.5U W=0.845U AS=0.3718P
+ AD=0.2197P PS=2.57U PD=1.365U
* device instance $720 m0 *1 529.645,823.408 pfet_05v0
M$720 VDD_DEC \$I2250 \$I2405 VDD_DEC pfet_05v0 L=0.5U W=0.845U AS=0.2197P
+ AD=0.2197P PS=1.365U PD=1.365U
* device instance $721 m0 *1 530.665,823.408 pfet_05v0
M$721 \$I2405 \$I2379 VDD_DEC VDD_DEC pfet_05v0 L=0.5U W=0.845U AS=0.2197P
+ AD=0.2197P PS=1.365U PD=1.365U
* device instance $722 m0 *1 531.685,823.408 pfet_05v0
M$722 VDD_DEC \$I2417 \$I2405 VDD_DEC pfet_05v0 L=0.5U W=0.845U AS=0.2197P
+ AD=0.3718P PS=1.365U PD=2.57U
* device instance $723 m0 *1 528.675,825.81 nfet_05v0
M$723 \$I2836 \$I2356 VSS VSS nfet_05v0 L=0.6U W=0.82U AS=0.3608P AD=0.1517P
+ PS=2.52U PD=1.19U
* device instance $724 m0 *1 529.645,825.81 nfet_05v0
M$724 \$I2835 \$I2250 \$I2836 VSS nfet_05v0 L=0.6U W=0.82U AS=0.1517P
+ AD=0.1722P PS=1.19U PD=1.24U
* device instance $725 m0 *1 530.665,825.81 nfet_05v0
M$725 \$I2834 \$I2379 \$I2835 VSS nfet_05v0 L=0.6U W=0.82U AS=0.1722P
+ AD=0.1517P PS=1.24U PD=1.19U
* device instance $726 m0 *1 531.635,825.81 nfet_05v0
M$726 \$I2405 \$I2417 \$I2834 VSS nfet_05v0 L=0.6U W=0.82U AS=0.1517P
+ AD=0.3608P PS=1.19U PD=2.52U
* device instance $727 r180 *1 501.935,815.568 pfet_05v0
M$727 \$I2232 \$I2329 VDD_DEC VDD_DEC pfet_05v0 L=0.5U W=0.845U AS=0.3718P
+ AD=0.2197P PS=2.57U PD=1.365U
* device instance $728 r180 *1 500.915,815.568 pfet_05v0
M$728 VDD_DEC \$I2361 \$I2232 VDD_DEC pfet_05v0 L=0.5U W=0.845U AS=0.2197P
+ AD=0.2197P PS=1.365U PD=1.365U
* device instance $729 r180 *1 499.895,815.568 pfet_05v0
M$729 \$I2232 \$I2322 VDD_DEC VDD_DEC pfet_05v0 L=0.5U W=0.845U AS=0.2197P
+ AD=0.2197P PS=1.365U PD=1.365U
* device instance $730 r180 *1 498.875,815.568 pfet_05v0
M$730 VDD_DEC \$I2303 \$I2232 VDD_DEC pfet_05v0 L=0.5U W=0.845U AS=0.2197P
+ AD=0.3718P PS=1.365U PD=2.57U
* device instance $731 r180 *1 501.885,817.97 nfet_05v0
M$731 \$I2839 \$I2329 VSS VSS nfet_05v0 L=0.6U W=0.82U AS=0.3608P AD=0.1517P
+ PS=2.52U PD=1.19U
* device instance $732 r180 *1 500.915,817.97 nfet_05v0
M$732 \$I2838 \$I2361 \$I2839 VSS nfet_05v0 L=0.6U W=0.82U AS=0.1517P
+ AD=0.1722P PS=1.19U PD=1.24U
* device instance $733 r180 *1 499.895,817.97 nfet_05v0
M$733 \$I2837 \$I2322 \$I2838 VSS nfet_05v0 L=0.6U W=0.82U AS=0.1722P
+ AD=0.1517P PS=1.24U PD=1.19U
* device instance $734 r180 *1 498.925,817.97 nfet_05v0
M$734 \$I2232 \$I2303 \$I2837 VSS nfet_05v0 L=0.6U W=0.82U AS=0.1517P
+ AD=0.3608P PS=1.19U PD=2.52U
* device instance $735 r180 *1 514.255,815.568 pfet_05v0
M$735 \$I2427 \$I2364 VDD_DEC VDD_DEC pfet_05v0 L=0.5U W=0.845U AS=0.3718P
+ AD=0.2197P PS=2.57U PD=1.365U
* device instance $736 r180 *1 513.235,815.568 pfet_05v0
M$736 VDD_DEC \$I2250 \$I2427 VDD_DEC pfet_05v0 L=0.5U W=0.845U AS=0.2197P
+ AD=0.2197P PS=1.365U PD=1.365U
* device instance $737 r180 *1 512.215,815.568 pfet_05v0
M$737 \$I2427 \$I2379 VDD_DEC VDD_DEC pfet_05v0 L=0.5U W=0.845U AS=0.2197P
+ AD=0.2197P PS=1.365U PD=1.365U
* device instance $738 r180 *1 511.195,815.568 pfet_05v0
M$738 VDD_DEC \$I2361 \$I2427 VDD_DEC pfet_05v0 L=0.5U W=0.845U AS=0.2197P
+ AD=0.3718P PS=1.365U PD=2.57U
* device instance $739 r180 *1 514.205,817.97 nfet_05v0
M$739 \$I2842 \$I2364 VSS VSS nfet_05v0 L=0.6U W=0.82U AS=0.3608P AD=0.1517P
+ PS=2.52U PD=1.19U
* device instance $740 r180 *1 513.235,817.97 nfet_05v0
M$740 \$I2841 \$I2250 \$I2842 VSS nfet_05v0 L=0.6U W=0.82U AS=0.1517P
+ AD=0.1722P PS=1.19U PD=1.24U
* device instance $741 r180 *1 512.215,817.97 nfet_05v0
M$741 \$I2840 \$I2379 \$I2841 VSS nfet_05v0 L=0.6U W=0.82U AS=0.1722P
+ AD=0.1517P PS=1.24U PD=1.19U
* device instance $742 r180 *1 511.245,817.97 nfet_05v0
M$742 \$I2427 \$I2361 \$I2840 VSS nfet_05v0 L=0.6U W=0.82U AS=0.1517P
+ AD=0.3608P PS=1.19U PD=2.52U
* device instance $743 r0 *1 497.265,821.872 pfet_05v0
M$743 \$I2363 \$I2379 VDD_DEC VDD_DEC pfet_05v0 L=0.5U W=0.845U AS=0.3718P
+ AD=0.2197P PS=2.57U PD=1.365U
* device instance $744 r0 *1 498.285,821.872 pfet_05v0
M$744 VDD_DEC \$I2361 \$I2363 VDD_DEC pfet_05v0 L=0.5U W=0.845U AS=0.2197P
+ AD=0.2197P PS=1.365U PD=1.365U
* device instance $745 r0 *1 499.305,821.872 pfet_05v0
M$745 \$I2363 \$I2302 VDD_DEC VDD_DEC pfet_05v0 L=0.5U W=0.845U AS=0.2197P
+ AD=0.2197P PS=1.365U PD=1.365U
* device instance $746 r0 *1 500.325,821.872 pfet_05v0
M$746 VDD_DEC \$I2353 \$I2363 VDD_DEC pfet_05v0 L=0.5U W=0.845U AS=0.2197P
+ AD=0.3718P PS=1.365U PD=2.57U
* device instance $747 r0 *1 497.315,819.47 nfet_05v0
M$747 \$I2845 \$I2379 VSS VSS nfet_05v0 L=0.6U W=0.82U AS=0.3608P AD=0.1517P
+ PS=2.52U PD=1.19U
* device instance $748 r0 *1 498.285,819.47 nfet_05v0
M$748 \$I2844 \$I2361 \$I2845 VSS nfet_05v0 L=0.6U W=0.82U AS=0.1517P
+ AD=0.1722P PS=1.19U PD=1.24U
* device instance $749 r0 *1 499.305,819.47 nfet_05v0
M$749 \$I2843 \$I2302 \$I2844 VSS nfet_05v0 L=0.6U W=0.82U AS=0.1722P
+ AD=0.1517P PS=1.24U PD=1.19U
* device instance $750 r0 *1 500.275,819.47 nfet_05v0
M$750 \$I2363 \$I2353 \$I2843 VSS nfet_05v0 L=0.6U W=0.82U AS=0.1517P
+ AD=0.3608P PS=1.19U PD=2.52U
* device instance $751 r0 *1 530.305,829.712 pfet_05v0
M$751 \$I2426 \$I2356 VDD_DEC VDD_DEC pfet_05v0 L=0.5U W=0.845U AS=0.3718P
+ AD=0.2197P PS=2.57U PD=1.365U
* device instance $752 r0 *1 531.325,829.712 pfet_05v0
M$752 VDD_DEC \$I2358 \$I2426 VDD_DEC pfet_05v0 L=0.5U W=0.845U AS=0.2197P
+ AD=0.2197P PS=1.365U PD=1.365U
* device instance $753 r0 *1 532.345,829.712 pfet_05v0
M$753 \$I2426 \$I2329 VDD_DEC VDD_DEC pfet_05v0 L=0.5U W=0.845U AS=0.2197P
+ AD=0.2197P PS=1.365U PD=1.365U
* device instance $754 r0 *1 533.365,829.712 pfet_05v0
M$754 VDD_DEC \$I2417 \$I2426 VDD_DEC pfet_05v0 L=0.5U W=0.845U AS=0.2197P
+ AD=0.3718P PS=1.365U PD=2.57U
* device instance $755 r0 *1 530.355,827.31 nfet_05v0
M$755 \$I2848 \$I2356 VSS VSS nfet_05v0 L=0.6U W=0.82U AS=0.3608P AD=0.1517P
+ PS=2.52U PD=1.19U
* device instance $756 r0 *1 531.325,827.31 nfet_05v0
M$756 \$I2847 \$I2358 \$I2848 VSS nfet_05v0 L=0.6U W=0.82U AS=0.1517P
+ AD=0.1722P PS=1.19U PD=1.24U
* device instance $757 r0 *1 532.345,827.31 nfet_05v0
M$757 \$I2846 \$I2329 \$I2847 VSS nfet_05v0 L=0.6U W=0.82U AS=0.1722P
+ AD=0.1517P PS=1.24U PD=1.19U
* device instance $758 r0 *1 533.315,827.31 nfet_05v0
M$758 \$I2426 \$I2417 \$I2846 VSS nfet_05v0 L=0.6U W=0.82U AS=0.1517P
+ AD=0.3608P PS=1.19U PD=2.52U
* device instance $759 r0 *1 579.025,821.872 pfet_05v0
M$759 \$I2403 \$I2407 VDD_DEC VDD_DEC pfet_05v0 L=0.5U W=0.845U AS=0.3718P
+ AD=0.2197P PS=2.57U PD=1.365U
* device instance $760 r0 *1 580.045,821.872 pfet_05v0
M$760 VDD_DEC \$I2212 \$I2403 VDD_DEC pfet_05v0 L=0.5U W=0.845U AS=0.2197P
+ AD=0.2197P PS=1.365U PD=1.365U
* device instance $761 r0 *1 581.065,821.872 pfet_05v0
M$761 \$I2403 \$I2170 VDD_DEC VDD_DEC pfet_05v0 L=0.5U W=0.845U AS=0.2197P
+ AD=0.2197P PS=1.365U PD=1.365U
* device instance $762 r0 *1 582.085,821.872 pfet_05v0
M$762 VDD_DEC \$I2384 \$I2403 VDD_DEC pfet_05v0 L=0.5U W=0.845U AS=0.2197P
+ AD=0.3718P PS=1.365U PD=2.57U
* device instance $763 r0 *1 579.075,819.47 nfet_05v0
M$763 \$I2851 \$I2407 VSS VSS nfet_05v0 L=0.6U W=0.82U AS=0.3608P AD=0.1517P
+ PS=2.52U PD=1.19U
* device instance $764 r0 *1 580.045,819.47 nfet_05v0
M$764 \$I2850 \$I2212 \$I2851 VSS nfet_05v0 L=0.6U W=0.82U AS=0.1517P
+ AD=0.1722P PS=1.19U PD=1.24U
* device instance $765 r0 *1 581.065,819.47 nfet_05v0
M$765 \$I2849 \$I2170 \$I2850 VSS nfet_05v0 L=0.6U W=0.82U AS=0.1722P
+ AD=0.1517P PS=1.24U PD=1.19U
* device instance $766 r0 *1 582.035,819.47 nfet_05v0
M$766 \$I2403 \$I2384 \$I2849 VSS nfet_05v0 L=0.6U W=0.82U AS=0.1517P
+ AD=0.3608P PS=1.19U PD=2.52U
* device instance $767 r0 *1 535.345,829.712 pfet_05v0
M$767 \$I2277 \$I2356 VDD_DEC VDD_DEC pfet_05v0 L=0.5U W=0.845U AS=0.3718P
+ AD=0.2197P PS=2.57U PD=1.365U
* device instance $768 r0 *1 536.365,829.712 pfet_05v0
M$768 VDD_DEC \$I2358 \$I2277 VDD_DEC pfet_05v0 L=0.5U W=0.845U AS=0.2197P
+ AD=0.2197P PS=1.365U PD=1.365U
* device instance $769 r0 *1 537.385,829.712 pfet_05v0
M$769 \$I2277 \$I2379 VDD_DEC VDD_DEC pfet_05v0 L=0.5U W=0.845U AS=0.2197P
+ AD=0.2197P PS=1.365U PD=1.365U
* device instance $770 r0 *1 538.405,829.712 pfet_05v0
M$770 VDD_DEC \$I2417 \$I2277 VDD_DEC pfet_05v0 L=0.5U W=0.845U AS=0.2197P
+ AD=0.3718P PS=1.365U PD=2.57U
* device instance $771 r0 *1 535.395,827.31 nfet_05v0
M$771 \$I2854 \$I2356 VSS VSS nfet_05v0 L=0.6U W=0.82U AS=0.3608P AD=0.1517P
+ PS=2.52U PD=1.19U
* device instance $772 r0 *1 536.365,827.31 nfet_05v0
M$772 \$I2853 \$I2358 \$I2854 VSS nfet_05v0 L=0.6U W=0.82U AS=0.1517P
+ AD=0.1722P PS=1.19U PD=1.24U
* device instance $773 r0 *1 537.385,827.31 nfet_05v0
M$773 \$I2852 \$I2379 \$I2853 VSS nfet_05v0 L=0.6U W=0.82U AS=0.1722P
+ AD=0.1517P PS=1.24U PD=1.19U
* device instance $774 r0 *1 538.355,827.31 nfet_05v0
M$774 \$I2277 \$I2417 \$I2852 VSS nfet_05v0 L=0.6U W=0.82U AS=0.1517P
+ AD=0.3608P PS=1.19U PD=2.52U
* device instance $775 r0 *1 517.425,821.872 pfet_05v0
M$775 \$I2406 \$I2364 VDD_DEC VDD_DEC pfet_05v0 L=0.5U W=0.845U AS=0.3718P
+ AD=0.2197P PS=2.57U PD=1.365U
* device instance $776 r0 *1 518.445,821.872 pfet_05v0
M$776 VDD_DEC \$I2358 \$I2406 VDD_DEC pfet_05v0 L=0.5U W=0.845U AS=0.2197P
+ AD=0.2197P PS=1.365U PD=1.365U
* device instance $777 r0 *1 519.465,821.872 pfet_05v0
M$777 \$I2406 \$I2379 VDD_DEC VDD_DEC pfet_05v0 L=0.5U W=0.845U AS=0.2197P
+ AD=0.2197P PS=1.365U PD=1.365U
* device instance $778 r0 *1 520.485,821.872 pfet_05v0
M$778 VDD_DEC \$I2361 \$I2406 VDD_DEC pfet_05v0 L=0.5U W=0.845U AS=0.2197P
+ AD=0.3718P PS=1.365U PD=2.57U
* device instance $779 r0 *1 517.475,819.47 nfet_05v0
M$779 \$I2857 \$I2364 VSS VSS nfet_05v0 L=0.6U W=0.82U AS=0.3608P AD=0.1517P
+ PS=2.52U PD=1.19U
* device instance $780 r0 *1 518.445,819.47 nfet_05v0
M$780 \$I2856 \$I2358 \$I2857 VSS nfet_05v0 L=0.6U W=0.82U AS=0.1517P
+ AD=0.1722P PS=1.19U PD=1.24U
* device instance $781 r0 *1 519.465,819.47 nfet_05v0
M$781 \$I2855 \$I2379 \$I2856 VSS nfet_05v0 L=0.6U W=0.82U AS=0.1722P
+ AD=0.1517P PS=1.24U PD=1.19U
* device instance $782 r0 *1 520.435,819.47 nfet_05v0
M$782 \$I2406 \$I2361 \$I2855 VSS nfet_05v0 L=0.6U W=0.82U AS=0.1517P
+ AD=0.3608P PS=1.19U PD=2.52U
* device instance $783 r0 *1 489.425,814.032 pfet_05v0
M$783 \$I2362 \$I2329 VDD_DEC VDD_DEC pfet_05v0 L=0.5U W=0.845U AS=0.3718P
+ AD=0.2197P PS=2.57U PD=1.365U
* device instance $784 r0 *1 490.445,814.032 pfet_05v0
M$784 VDD_DEC \$I2361 \$I2362 VDD_DEC pfet_05v0 L=0.5U W=0.845U AS=0.2197P
+ AD=0.2197P PS=1.365U PD=1.365U
* device instance $785 r0 *1 491.465,814.032 pfet_05v0
M$785 \$I2362 \$I2302 VDD_DEC VDD_DEC pfet_05v0 L=0.5U W=0.845U AS=0.2197P
+ AD=0.2197P PS=1.365U PD=1.365U
* device instance $786 r0 *1 492.485,814.032 pfet_05v0
M$786 VDD_DEC \$I2353 \$I2362 VDD_DEC pfet_05v0 L=0.5U W=0.845U AS=0.2197P
+ AD=0.3718P PS=1.365U PD=2.57U
* device instance $787 r0 *1 489.475,811.63 nfet_05v0
M$787 \$I2860 \$I2329 VSS VSS nfet_05v0 L=0.6U W=0.82U AS=0.3608P AD=0.1517P
+ PS=2.52U PD=1.19U
* device instance $788 r0 *1 490.445,811.63 nfet_05v0
M$788 \$I2859 \$I2361 \$I2860 VSS nfet_05v0 L=0.6U W=0.82U AS=0.1517P
+ AD=0.1722P PS=1.19U PD=1.24U
* device instance $789 r0 *1 491.465,811.63 nfet_05v0
M$789 \$I2858 \$I2302 \$I2859 VSS nfet_05v0 L=0.6U W=0.82U AS=0.1722P
+ AD=0.1517P PS=1.24U PD=1.19U
* device instance $790 r0 *1 492.435,811.63 nfet_05v0
M$790 \$I2362 \$I2353 \$I2858 VSS nfet_05v0 L=0.6U W=0.82U AS=0.1517P
+ AD=0.3608P PS=1.19U PD=2.52U
* device instance $791 r0 *1 494.465,814.032 pfet_05v0
M$791 \$I2323 \$I2379 VDD_DEC VDD_DEC pfet_05v0 L=0.5U W=0.845U AS=0.3718P
+ AD=0.2197P PS=2.57U PD=1.365U
* device instance $792 r0 *1 495.485,814.032 pfet_05v0
M$792 VDD_DEC \$I2354 \$I2323 VDD_DEC pfet_05v0 L=0.5U W=0.845U AS=0.2197P
+ AD=0.2197P PS=1.365U PD=1.365U
* device instance $793 r0 *1 496.505,814.032 pfet_05v0
M$793 \$I2323 \$I2302 VDD_DEC VDD_DEC pfet_05v0 L=0.5U W=0.845U AS=0.2197P
+ AD=0.2197P PS=1.365U PD=1.365U
* device instance $794 r0 *1 497.525,814.032 pfet_05v0
M$794 VDD_DEC \$I2353 \$I2323 VDD_DEC pfet_05v0 L=0.5U W=0.845U AS=0.2197P
+ AD=0.3718P PS=1.365U PD=2.57U
* device instance $795 r0 *1 494.515,811.63 nfet_05v0
M$795 \$I2863 \$I2379 VSS VSS nfet_05v0 L=0.6U W=0.82U AS=0.3608P AD=0.1517P
+ PS=2.52U PD=1.19U
* device instance $796 r0 *1 495.485,811.63 nfet_05v0
M$796 \$I2862 \$I2354 \$I2863 VSS nfet_05v0 L=0.6U W=0.82U AS=0.1517P
+ AD=0.1722P PS=1.19U PD=1.24U
* device instance $797 r0 *1 496.505,811.63 nfet_05v0
M$797 \$I2861 \$I2302 \$I2862 VSS nfet_05v0 L=0.6U W=0.82U AS=0.1722P
+ AD=0.1517P PS=1.24U PD=1.19U
* device instance $798 r0 *1 497.475,811.63 nfet_05v0
M$798 \$I2323 \$I2353 \$I2861 VSS nfet_05v0 L=0.6U W=0.82U AS=0.1517P
+ AD=0.3608P PS=1.19U PD=2.52U
* device instance $799 r0 *1 491.105,806.192 pfet_05v0
M$799 \$I2305 \$I2379 VDD_DEC VDD_DEC pfet_05v0 L=0.5U W=0.845U AS=0.3718P
+ AD=0.2197P PS=2.57U PD=1.365U
* device instance $800 r0 *1 492.125,806.192 pfet_05v0
M$800 VDD_DEC \$I2361 \$I2305 VDD_DEC pfet_05v0 L=0.5U W=0.845U AS=0.2197P
+ AD=0.2197P PS=1.365U PD=1.365U
* device instance $801 r0 *1 493.145,806.192 pfet_05v0
M$801 \$I2305 \$I2322 VDD_DEC VDD_DEC pfet_05v0 L=0.5U W=0.845U AS=0.2197P
+ AD=0.2197P PS=1.365U PD=1.365U
* device instance $802 r0 *1 494.165,806.192 pfet_05v0
M$802 VDD_DEC \$I2303 \$I2305 VDD_DEC pfet_05v0 L=0.5U W=0.845U AS=0.2197P
+ AD=0.3718P PS=1.365U PD=2.57U
* device instance $803 r0 *1 491.155,803.79 nfet_05v0
M$803 \$I2866 \$I2379 VSS VSS nfet_05v0 L=0.6U W=0.82U AS=0.3608P AD=0.1517P
+ PS=2.52U PD=1.19U
* device instance $804 r0 *1 492.125,803.79 nfet_05v0
M$804 \$I2865 \$I2361 \$I2866 VSS nfet_05v0 L=0.6U W=0.82U AS=0.1517P
+ AD=0.1722P PS=1.19U PD=1.24U
* device instance $805 r0 *1 493.145,803.79 nfet_05v0
M$805 \$I2864 \$I2322 \$I2865 VSS nfet_05v0 L=0.6U W=0.82U AS=0.1722P
+ AD=0.1517P PS=1.24U PD=1.19U
* device instance $806 r0 *1 494.115,803.79 nfet_05v0
M$806 \$I2305 \$I2303 \$I2864 VSS nfet_05v0 L=0.6U W=0.82U AS=0.1517P
+ AD=0.3608P PS=1.19U PD=2.52U
* device instance $807 m90 *1 508.81,806.01 pfet_05v0
M$807 \$I2361 \$I2354 VDD_DEC VDD_DEC pfet_05v0 L=0.5U W=1.22U AS=0.5368P
+ AD=0.5368P PS=3.32U PD=3.32U
* device instance $808 m90 *1 508.76,803.96 nfet_05v0
M$808 \$I2361 \$I2354 VSS VSS nfet_05v0 L=0.6U W=0.48U AS=0.2112P AD=0.2112P
+ PS=1.84U PD=1.84U
* device instance $809 m90 *1 637.61,821.69 pfet_05v0
M$809 \$I2176 \$I2237 VDD_DEC VDD_DEC pfet_05v0 L=0.5U W=1.22U AS=0.5368P
+ AD=0.5368P PS=3.32U PD=3.32U
* device instance $810 m90 *1 637.56,819.64 nfet_05v0
M$810 \$I2176 \$I2237 VSS VSS nfet_05v0 L=0.6U W=0.48U AS=0.2112P AD=0.2112P
+ PS=1.84U PD=1.84U
* device instance $811 m0 *1 642.15,823.59 pfet_05v0
M$811 \$I2385 \$I2287 VDD_DEC VDD_DEC pfet_05v0 L=0.5U W=1.22U AS=0.5368P
+ AD=0.5368P PS=3.32U PD=3.32U
* device instance $812 m0 *1 642.2,825.64 nfet_05v0
M$812 \$I2385 \$I2287 VSS VSS nfet_05v0 L=0.6U W=0.48U AS=0.2112P AD=0.2112P
+ PS=1.84U PD=1.84U
* device instance $813 r180 *1 642.09,807.91 pfet_05v0
M$813 \$I2310 \$I2241 VDD_DEC VDD_DEC pfet_05v0 L=0.5U W=1.22U AS=0.5368P
+ AD=0.5368P PS=3.32U PD=3.32U
* device instance $814 r180 *1 642.04,809.96 nfet_05v0
M$814 \$I2310 \$I2241 VSS VSS nfet_05v0 L=0.6U W=0.48U AS=0.2112P AD=0.2112P
+ PS=1.84U PD=1.84U
* device instance $815 r180 *1 490.89,807.91 pfet_05v0
M$815 \$I2329 \$I2379 VDD_DEC VDD_DEC pfet_05v0 L=0.5U W=1.22U AS=0.5368P
+ AD=0.5368P PS=3.32U PD=3.32U
* device instance $816 r180 *1 490.84,809.96 nfet_05v0
M$816 \$I2329 \$I2379 VSS VSS nfet_05v0 L=0.6U W=0.48U AS=0.2112P AD=0.2112P
+ PS=1.84U PD=1.84U
* device instance $817 r0 *1 504.95,813.85 pfet_05v0
M$817 \$I2303 \$I2353 VDD_DEC VDD_DEC pfet_05v0 L=0.5U W=1.22U AS=0.5368P
+ AD=0.5368P PS=3.32U PD=3.32U
* device instance $818 r0 *1 505,811.8 nfet_05v0
M$818 \$I2303 \$I2353 VSS VSS nfet_05v0 L=0.6U W=0.48U AS=0.2112P AD=0.2112P
+ PS=1.84U PD=1.84U
* device instance $819 r0 *1 488.71,806.01 pfet_05v0
M$819 \$I2302 \$I2322 VDD_DEC VDD_DEC pfet_05v0 L=0.5U W=1.22U AS=0.5368P
+ AD=0.5368P PS=3.32U PD=3.32U
* device instance $820 r0 *1 488.76,803.96 nfet_05v0
M$820 \$I2302 \$I2322 VSS VSS nfet_05v0 L=0.6U W=0.48U AS=0.2112P AD=0.2112P
+ PS=1.84U PD=1.84U
* device instance $821 m90 *1 519.45,837.37 pfet_05v0
M$821 \$I2867 \$I2419 VDD_DEC VDD_DEC pfet_05v0 L=0.5U W=1.22U AS=0.5368P
+ AD=0.4087P PS=3.32U PD=1.89U
* device instance $822 m90 *1 518.28,837.37 pfet_05v0
M$822 \$I2160 \$I2331 \$I2867 VDD_DEC pfet_05v0 L=0.5U W=1.22U AS=0.4087P
+ AD=0.5368P PS=1.89U PD=3.32U
* device instance $823 m90 *1 519.4,835.207 nfet_05v0
M$823 \$I2160 \$I2419 VSS VSS nfet_05v0 L=0.6U W=0.565U AS=0.2486P AD=0.1469P
+ PS=2.01U PD=1.085U
* device instance $824 m90 *1 518.28,835.207 nfet_05v0
M$824 VSS \$I2331 \$I2160 VSS nfet_05v0 L=0.6U W=0.565U AS=0.1469P AD=0.2486P
+ PS=1.085U PD=2.01U
* device instance $825 m90 *1 574.89,806.01 pfet_05v0
M$825 \$I2868 \$I2283 VDD_DEC VDD_DEC pfet_05v0 L=0.5U W=1.22U AS=0.5368P
+ AD=0.4087P PS=3.32U PD=1.89U
* device instance $826 m90 *1 573.72,806.01 pfet_05v0
M$826 \$I2064 \$I2237 \$I2868 VDD_DEC pfet_05v0 L=0.5U W=1.22U AS=0.4087P
+ AD=0.5368P PS=1.89U PD=3.32U
* device instance $827 m90 *1 574.84,803.847 nfet_05v0
M$827 \$I2064 \$I2283 VSS VSS nfet_05v0 L=0.6U W=0.565U AS=0.2486P AD=0.1469P
+ PS=2.01U PD=1.085U
* device instance $828 m90 *1 573.72,803.847 nfet_05v0
M$828 VSS \$I2237 \$I2064 VSS nfet_05v0 L=0.6U W=0.565U AS=0.1469P AD=0.2486P
+ PS=1.085U PD=2.01U
* device instance $829 m90 *1 611.85,806.01 pfet_05v0
M$829 \$I2869 \$I2324 VDD_DEC VDD_DEC pfet_05v0 L=0.5U W=1.22U AS=0.5368P
+ AD=0.4087P PS=3.32U PD=1.89U
* device instance $830 m90 *1 610.68,806.01 pfet_05v0
M$830 \$I2066 \$I2342 \$I2869 VDD_DEC pfet_05v0 L=0.5U W=1.22U AS=0.4087P
+ AD=0.5368P PS=1.89U PD=3.32U
* device instance $831 m90 *1 611.8,803.847 nfet_05v0
M$831 \$I2066 \$I2324 VSS VSS nfet_05v0 L=0.6U W=0.565U AS=0.2486P AD=0.1469P
+ PS=2.01U PD=1.085U
* device instance $832 m90 *1 610.68,803.847 nfet_05v0
M$832 VSS \$I2342 \$I2066 VSS nfet_05v0 L=0.6U W=0.565U AS=0.1469P AD=0.2486P
+ PS=1.085U PD=2.01U
* device instance $833 m0 *1 512.23,807.91 pfet_05v0
M$833 \$I2870 \$I2322 VDD_DEC VDD_DEC pfet_05v0 L=0.5U W=1.22U AS=0.5368P
+ AD=0.4087P PS=3.32U PD=1.89U
* device instance $834 m0 *1 513.4,807.91 pfet_05v0
M$834 \$I2356 \$I2353 \$I2870 VDD_DEC pfet_05v0 L=0.5U W=1.22U AS=0.4087P
+ AD=0.5368P PS=1.89U PD=3.32U
* device instance $835 m0 *1 512.28,810.073 nfet_05v0
M$835 \$I2356 \$I2322 VSS VSS nfet_05v0 L=0.6U W=0.565U AS=0.2486P AD=0.1469P
+ PS=2.01U PD=1.085U
* device instance $836 m0 *1 513.4,810.073 nfet_05v0
M$836 VSS \$I2353 \$I2356 VSS nfet_05v0 L=0.6U W=0.565U AS=0.1469P AD=0.2486P
+ PS=1.085U PD=2.01U
* device instance $837 m0 *1 646.07,831.43 pfet_05v0
M$837 \$I2871 \$I2324 VDD_DEC VDD_DEC pfet_05v0 L=0.5U W=1.22U AS=0.5368P
+ AD=0.4087P PS=3.32U PD=1.89U
* device instance $838 m0 *1 647.24,831.43 pfet_05v0
M$838 \$I2421 \$I2139 \$I2871 VDD_DEC pfet_05v0 L=0.5U W=1.22U AS=0.4087P
+ AD=0.5368P PS=1.89U PD=3.32U
* device instance $839 m0 *1 646.12,833.593 nfet_05v0
M$839 \$I2421 \$I2324 VSS VSS nfet_05v0 L=0.6U W=0.565U AS=0.2486P AD=0.1469P
+ PS=2.01U PD=1.085U
* device instance $840 m0 *1 647.24,833.593 nfet_05v0
M$840 VSS \$I2139 \$I2421 VSS nfet_05v0 L=0.6U W=0.565U AS=0.1469P AD=0.2486P
+ PS=1.085U PD=2.01U
* device instance $841 r180 *1 568.73,823.59 pfet_05v0
M$841 \$I2872 \$I2403 VDD_DEC VDD_DEC pfet_05v0 L=0.5U W=1.22U AS=0.5368P
+ AD=0.4087P PS=3.32U PD=1.89U
* device instance $842 r180 *1 567.56,823.59 pfet_05v0
M$842 \$I2129 \$I2280 \$I2872 VDD_DEC pfet_05v0 L=0.5U W=1.22U AS=0.4087P
+ AD=0.5368P PS=1.89U PD=3.32U
* device instance $843 r180 *1 568.68,825.753 nfet_05v0
M$843 \$I2129 \$I2403 VSS VSS nfet_05v0 L=0.6U W=0.565U AS=0.2486P AD=0.1469P
+ PS=2.01U PD=1.085U
* device instance $844 r180 *1 567.56,825.753 nfet_05v0
M$844 VSS \$I2280 \$I2129 VSS nfet_05v0 L=0.6U W=0.565U AS=0.1469P AD=0.2486P
+ PS=1.085U PD=2.01U
* device instance $845 r180 *1 529.53,815.75 pfet_05v0
M$845 \$I2873 \$I2382 VDD_DEC VDD_DEC pfet_05v0 L=0.5U W=1.22U AS=0.5368P
+ AD=0.4087P PS=3.32U PD=1.89U
* device instance $846 r180 *1 528.36,815.75 pfet_05v0
M$846 \$I2336 \$I2384 \$I2873 VDD_DEC pfet_05v0 L=0.5U W=1.22U AS=0.4087P
+ AD=0.5368P PS=1.89U PD=3.32U
* device instance $847 r180 *1 529.48,817.913 nfet_05v0
M$847 \$I2336 \$I2382 VSS VSS nfet_05v0 L=0.6U W=0.565U AS=0.2486P AD=0.1469P
+ PS=2.01U PD=1.085U
* device instance $848 r180 *1 528.36,817.913 nfet_05v0
M$848 VSS \$I2384 \$I2336 VSS nfet_05v0 L=0.6U W=0.565U AS=0.1469P AD=0.2486P
+ PS=1.085U PD=2.01U
* device instance $849 r180 *1 563.69,807.91 pfet_05v0
M$849 \$I2874 \$I2339 VDD_DEC VDD_DEC pfet_05v0 L=0.5U W=1.22U AS=0.5368P
+ AD=0.4087P PS=3.32U PD=1.89U
* device instance $850 r180 *1 562.52,807.91 pfet_05v0
M$850 \$I2281 \$I2280 \$I2874 VDD_DEC pfet_05v0 L=0.5U W=1.22U AS=0.4087P
+ AD=0.5368P PS=1.89U PD=3.32U
* device instance $851 r180 *1 563.64,810.073 nfet_05v0
M$851 \$I2281 \$I2339 VSS VSS nfet_05v0 L=0.6U W=0.565U AS=0.2486P AD=0.1469P
+ PS=2.01U PD=1.085U
* device instance $852 r180 *1 562.52,810.073 nfet_05v0
M$852 VSS \$I2280 \$I2281 VSS nfet_05v0 L=0.6U W=0.565U AS=0.1469P AD=0.2486P
+ PS=1.085U PD=2.01U
* device instance $853 r0 *1 586.71,821.69 pfet_05v0
M$853 \$I2875 \$I2419 VDD_DEC VDD_DEC pfet_05v0 L=0.5U W=1.22U AS=0.5368P
+ AD=0.4087P PS=3.32U PD=1.89U
* device instance $854 r0 *1 587.88,821.69 pfet_05v0
M$854 \$I2069 \$I2252 \$I2875 VDD_DEC pfet_05v0 L=0.5U W=1.22U AS=0.4087P
+ AD=0.5368P PS=1.89U PD=3.32U
* device instance $855 r0 *1 586.76,819.527 nfet_05v0
M$855 \$I2069 \$I2419 VSS VSS nfet_05v0 L=0.6U W=0.565U AS=0.2486P AD=0.1469P
+ PS=2.01U PD=1.085U
* device instance $856 r0 *1 587.88,819.527 nfet_05v0
M$856 VSS \$I2252 \$I2069 VSS nfet_05v0 L=0.6U W=0.565U AS=0.1469P AD=0.2486P
+ PS=1.085U PD=2.01U
* device instance $857 r0 *1 630.39,829.53 pfet_05v0
M$857 \$I2876 \$I2339 VDD_DEC VDD_DEC pfet_05v0 L=0.5U W=1.22U AS=0.5368P
+ AD=0.4087P PS=3.32U PD=1.89U
* device instance $858 r0 *1 631.56,829.53 pfet_05v0
M$858 \$I2408 \$I2139 \$I2876 VDD_DEC pfet_05v0 L=0.5U W=1.22U AS=0.4087P
+ AD=0.5368P PS=1.89U PD=3.32U
* device instance $859 r0 *1 630.44,827.367 nfet_05v0
M$859 \$I2408 \$I2339 VSS VSS nfet_05v0 L=0.6U W=0.565U AS=0.2486P AD=0.1469P
+ PS=2.01U PD=1.085U
* device instance $860 r0 *1 631.56,827.367 nfet_05v0
M$860 VSS \$I2139 \$I2408 VSS nfet_05v0 L=0.6U W=0.565U AS=0.1469P AD=0.2486P
+ PS=1.085U PD=2.01U
* device instance $861 r0 *1 643.83,806.01 pfet_05v0
M$861 \$I2877 \$I2283 VDD_DEC VDD_DEC pfet_05v0 L=0.5U W=1.22U AS=0.5368P
+ AD=0.4087P PS=3.32U PD=1.89U
* device instance $862 r0 *1 645,806.01 pfet_05v0
M$862 \$I2326 \$I2139 \$I2877 VDD_DEC pfet_05v0 L=0.5U W=1.22U AS=0.4087P
+ AD=0.5368P PS=1.89U PD=3.32U
* device instance $863 r0 *1 643.88,803.847 nfet_05v0
M$863 \$I2326 \$I2283 VSS VSS nfet_05v0 L=0.6U W=0.565U AS=0.2486P AD=0.1469P
+ PS=2.01U PD=1.085U
* device instance $864 r0 *1 645,803.847 nfet_05v0
M$864 VSS \$I2139 \$I2326 VSS nfet_05v0 L=0.6U W=0.565U AS=0.1469P AD=0.2486P
+ PS=1.085U PD=2.01U
* device instance $865 r0 *1 621.43,790.33 pfet_05v0
M$865 \$I2878 \$I2403 VDD_DEC VDD_DEC pfet_05v0 L=0.5U W=1.22U AS=0.5368P
+ AD=0.4087P PS=3.32U PD=1.89U
* device instance $866 r0 *1 622.6,790.33 pfet_05v0
M$866 \$I2175 \$I2176 \$I2878 VDD_DEC pfet_05v0 L=0.5U W=1.22U AS=0.4087P
+ AD=0.5368P PS=1.89U PD=3.32U
* device instance $867 r0 *1 621.48,788.167 nfet_05v0
M$867 \$I2175 \$I2403 VSS VSS nfet_05v0 L=0.6U W=0.565U AS=0.2486P AD=0.1469P
+ PS=2.01U PD=1.085U
* device instance $868 r0 *1 622.6,788.167 nfet_05v0
M$868 VSS \$I2176 \$I2175 VSS nfet_05v0 L=0.6U W=0.565U AS=0.1469P AD=0.2486P
+ PS=1.085U PD=2.01U
* device instance $869 m90 *1 590.47,790.33 pfet_05v0
M$869 \$I2881 \$I2166 VDD_DEC VDD_DEC pfet_05v0 L=0.5U W=1.22U AS=0.5368P
+ AD=0.3172P PS=3.32U PD=1.74U
* device instance $870 m90 *1 589.45,790.33 pfet_05v0
M$870 \$I2880 \$I2173 \$I2881 VDD_DEC pfet_05v0 L=0.5U W=1.22U AS=0.3172P
+ AD=0.3782P PS=1.74U PD=1.84U
* device instance $871 m90 *1 588.33,790.33 pfet_05v0
M$871 \$I2879 \$I2211 \$I2880 VDD_DEC pfet_05v0 L=0.5U W=1.22U AS=0.3782P
+ AD=0.3782P PS=1.84U PD=1.84U
* device instance $872 m90 *1 587.21,790.33 pfet_05v0
M$872 \$I2070 \$I2172 \$I2879 VDD_DEC pfet_05v0 L=0.5U W=1.22U AS=0.3782P
+ AD=0.5368P PS=1.84U PD=3.32U
* device instance $873 m90 *1 590.52,788.02 nfet_05v0
M$873 \$I2070 \$I2166 VSS VSS nfet_05v0 L=0.6U W=0.36U AS=0.1584P AD=0.0936P
+ PS=1.6U PD=0.88U
* device instance $874 m90 *1 589.4,788.02 nfet_05v0
M$874 VSS \$I2173 \$I2070 VSS nfet_05v0 L=0.6U W=0.36U AS=0.0936P AD=0.0936P
+ PS=0.88U PD=0.88U
* device instance $875 m90 *1 588.28,788.02 nfet_05v0
M$875 \$I2070 \$I2211 VSS VSS nfet_05v0 L=0.6U W=0.36U AS=0.0936P AD=0.0936P
+ PS=0.88U PD=0.88U
* device instance $876 m90 *1 587.16,788.02 nfet_05v0
M$876 VSS \$I2172 \$I2070 VSS nfet_05v0 L=0.6U W=0.36U AS=0.0936P AD=0.1584P
+ PS=0.88U PD=1.6U
* device instance $877 m90 *1 544.55,813.85 pfet_05v0
M$877 \$I2884 \$I2308 VDD_DEC VDD_DEC pfet_05v0 L=0.5U W=1.22U AS=0.5368P
+ AD=0.3172P PS=3.32U PD=1.74U
* device instance $878 m90 *1 543.53,813.85 pfet_05v0
M$878 \$I2883 \$I2203 \$I2884 VDD_DEC pfet_05v0 L=0.5U W=1.22U AS=0.3172P
+ AD=0.3782P PS=1.74U PD=1.84U
* device instance $879 m90 *1 542.41,813.85 pfet_05v0
M$879 \$I2882 \$I2333 \$I2883 VDD_DEC pfet_05v0 L=0.5U W=1.22U AS=0.3782P
+ AD=0.3782P PS=1.84U PD=1.84U
* device instance $880 m90 *1 541.29,813.85 pfet_05v0
M$880 \$I2059 \$I2359 \$I2882 VDD_DEC pfet_05v0 L=0.5U W=1.22U AS=0.3782P
+ AD=0.5368P PS=1.84U PD=3.32U
* device instance $881 m90 *1 544.6,811.54 nfet_05v0
M$881 \$I2059 \$I2308 VSS VSS nfet_05v0 L=0.6U W=0.36U AS=0.1584P AD=0.0936P
+ PS=1.6U PD=0.88U
* device instance $882 m90 *1 543.48,811.54 nfet_05v0
M$882 VSS \$I2203 \$I2059 VSS nfet_05v0 L=0.6U W=0.36U AS=0.0936P AD=0.0936P
+ PS=0.88U PD=0.88U
* device instance $883 m90 *1 542.36,811.54 nfet_05v0
M$883 \$I2059 \$I2333 VSS VSS nfet_05v0 L=0.6U W=0.36U AS=0.0936P AD=0.0936P
+ PS=0.88U PD=0.88U
* device instance $884 m90 *1 541.24,811.54 nfet_05v0
M$884 VSS \$I2359 \$I2059 VSS nfet_05v0 L=0.6U W=0.36U AS=0.0936P AD=0.1584P
+ PS=0.88U PD=1.6U
* device instance $885 m90 *1 559.11,813.85 pfet_05v0
M$885 \$I2887 \$I2251 VDD_DEC VDD_DEC pfet_05v0 L=0.5U W=1.22U AS=0.5368P
+ AD=0.3172P PS=3.32U PD=1.74U
* device instance $886 m90 *1 558.09,813.85 pfet_05v0
M$886 \$I2886 \$I2203 \$I2887 VDD_DEC pfet_05v0 L=0.5U W=1.22U AS=0.3172P
+ AD=0.3782P PS=1.74U PD=1.84U
* device instance $887 m90 *1 556.97,813.85 pfet_05v0
M$887 \$I2885 \$I2383 \$I2886 VDD_DEC pfet_05v0 L=0.5U W=1.22U AS=0.3782P
+ AD=0.3782P PS=1.84U PD=1.84U
* device instance $888 m90 *1 555.85,813.85 pfet_05v0
M$888 \$I2024 \$I2280 \$I2885 VDD_DEC pfet_05v0 L=0.5U W=1.22U AS=0.3782P
+ AD=0.5368P PS=1.84U PD=3.32U
* device instance $889 m90 *1 559.16,811.54 nfet_05v0
M$889 \$I2024 \$I2251 VSS VSS nfet_05v0 L=0.6U W=0.36U AS=0.1584P AD=0.0936P
+ PS=1.6U PD=0.88U
* device instance $890 m90 *1 558.04,811.54 nfet_05v0
M$890 VSS \$I2203 \$I2024 VSS nfet_05v0 L=0.6U W=0.36U AS=0.0936P AD=0.0936P
+ PS=0.88U PD=0.88U
* device instance $891 m90 *1 556.92,811.54 nfet_05v0
M$891 \$I2024 \$I2383 VSS VSS nfet_05v0 L=0.6U W=0.36U AS=0.0936P AD=0.0936P
+ PS=0.88U PD=0.88U
* device instance $892 m90 *1 555.8,811.54 nfet_05v0
M$892 VSS \$I2280 \$I2024 VSS nfet_05v0 L=0.6U W=0.36U AS=0.0936P AD=0.1584P
+ PS=0.88U PD=1.6U
* device instance $893 m90 *1 573.67,813.85 pfet_05v0
M$893 \$I2890 \$I2209 VDD_DEC VDD_DEC pfet_05v0 L=0.5U W=1.22U AS=0.5368P
+ AD=0.3172P PS=3.32U PD=1.74U
* device instance $894 m90 *1 572.65,813.85 pfet_05v0
M$894 \$I2889 \$I2207 \$I2890 VDD_DEC pfet_05v0 L=0.5U W=1.22U AS=0.3172P
+ AD=0.3782P PS=1.74U PD=1.84U
* device instance $895 m90 *1 571.53,813.85 pfet_05v0
M$895 \$I2888 \$I2170 \$I2889 VDD_DEC pfet_05v0 L=0.5U W=1.22U AS=0.3782P
+ AD=0.3782P PS=1.84U PD=1.84U
* device instance $896 m90 *1 570.41,813.85 pfet_05v0
M$896 \$I2164 \$I2204 \$I2888 VDD_DEC pfet_05v0 L=0.5U W=1.22U AS=0.3782P
+ AD=0.5368P PS=1.84U PD=3.32U
* device instance $897 m90 *1 573.72,811.54 nfet_05v0
M$897 \$I2164 \$I2209 VSS VSS nfet_05v0 L=0.6U W=0.36U AS=0.1584P AD=0.0936P
+ PS=1.6U PD=0.88U
* device instance $898 m90 *1 572.6,811.54 nfet_05v0
M$898 VSS \$I2207 \$I2164 VSS nfet_05v0 L=0.6U W=0.36U AS=0.0936P AD=0.0936P
+ PS=0.88U PD=0.88U
* device instance $899 m90 *1 571.48,811.54 nfet_05v0
M$899 \$I2164 \$I2170 VSS VSS nfet_05v0 L=0.6U W=0.36U AS=0.0936P AD=0.0936P
+ PS=0.88U PD=0.88U
* device instance $900 m90 *1 570.36,811.54 nfet_05v0
M$900 VSS \$I2204 \$I2164 VSS nfet_05v0 L=0.6U W=0.36U AS=0.0936P AD=0.1584P
+ PS=0.88U PD=1.6U
* device instance $901 m90 *1 503.11,813.85 pfet_05v0
M$901 \$I2893 \$I2363 VDD_DEC VDD_DEC pfet_05v0 L=0.5U W=1.22U AS=0.5368P
+ AD=0.3172P PS=3.32U PD=1.74U
* device instance $902 m90 *1 502.09,813.85 pfet_05v0
M$902 \$I2892 \$I2197 \$I2893 VDD_DEC pfet_05v0 L=0.5U W=1.22U AS=0.3172P
+ AD=0.3782P PS=1.74U PD=1.84U
* device instance $903 m90 *1 500.97,813.85 pfet_05v0
M$903 \$I2891 \$I2249 \$I2892 VDD_DEC pfet_05v0 L=0.5U W=1.22U AS=0.3782P
+ AD=0.3782P PS=1.84U PD=1.84U
* device instance $904 m90 *1 499.85,813.85 pfet_05v0
M$904 \$I2124 \$I2196 \$I2891 VDD_DEC pfet_05v0 L=0.5U W=1.22U AS=0.3782P
+ AD=0.5368P PS=1.84U PD=3.32U
* device instance $905 m90 *1 503.16,811.54 nfet_05v0
M$905 \$I2124 \$I2363 VSS VSS nfet_05v0 L=0.6U W=0.36U AS=0.1584P AD=0.0936P
+ PS=1.6U PD=0.88U
* device instance $906 m90 *1 502.04,811.54 nfet_05v0
M$906 VSS \$I2197 \$I2124 VSS nfet_05v0 L=0.6U W=0.36U AS=0.0936P AD=0.0936P
+ PS=0.88U PD=0.88U
* device instance $907 m90 *1 500.92,811.54 nfet_05v0
M$907 \$I2124 \$I2249 VSS VSS nfet_05v0 L=0.6U W=0.36U AS=0.0936P AD=0.0936P
+ PS=0.88U PD=0.88U
* device instance $908 m90 *1 499.8,811.54 nfet_05v0
M$908 VSS \$I2196 \$I2124 VSS nfet_05v0 L=0.6U W=0.36U AS=0.0936P AD=0.1584P
+ PS=0.88U PD=1.6U
* device instance $909 m90 *1 661.03,813.85 pfet_05v0
M$909 \$I2896 \$I2238 VDD_DEC VDD_DEC pfet_05v0 L=0.5U W=1.22U AS=0.5368P
+ AD=0.3172P PS=3.32U PD=1.74U
* device instance $910 m90 *1 660.01,813.85 pfet_05v0
M$910 \$I2895 \$I2177 \$I2896 VDD_DEC pfet_05v0 L=0.5U W=1.22U AS=0.3172P
+ AD=0.3782P PS=1.74U PD=1.84U
* device instance $911 m90 *1 658.89,813.85 pfet_05v0
M$911 \$I2894 \$I2179 \$I2895 VDD_DEC pfet_05v0 L=0.5U W=1.22U AS=0.3782P
+ AD=0.3782P PS=1.84U PD=1.84U
* device instance $912 m90 *1 657.77,813.85 pfet_05v0
M$912 \$I2369 \$I2178 \$I2894 VDD_DEC pfet_05v0 L=0.5U W=1.22U AS=0.3782P
+ AD=0.5368P PS=1.84U PD=3.32U
* device instance $913 m90 *1 661.08,811.54 nfet_05v0
M$913 \$I2369 \$I2238 VSS VSS nfet_05v0 L=0.6U W=0.36U AS=0.1584P AD=0.0936P
+ PS=1.6U PD=0.88U
* device instance $914 m90 *1 659.96,811.54 nfet_05v0
M$914 VSS \$I2177 \$I2369 VSS nfet_05v0 L=0.6U W=0.36U AS=0.0936P AD=0.0936P
+ PS=0.88U PD=0.88U
* device instance $915 m90 *1 658.84,811.54 nfet_05v0
M$915 \$I2369 \$I2179 VSS VSS nfet_05v0 L=0.6U W=0.36U AS=0.0936P AD=0.0936P
+ PS=0.88U PD=0.88U
* device instance $916 m90 *1 657.72,811.54 nfet_05v0
M$916 VSS \$I2178 \$I2369 VSS nfet_05v0 L=0.6U W=0.36U AS=0.0936P AD=0.1584P
+ PS=0.88U PD=1.6U
* device instance $917 m90 *1 564.71,829.53 pfet_05v0
M$917 \$I2899 \$I2360 VDD_DEC VDD_DEC pfet_05v0 L=0.5U W=1.22U AS=0.5368P
+ AD=0.3172P PS=3.32U PD=1.74U
* device instance $918 m90 *1 563.69,829.53 pfet_05v0
M$918 \$I2898 \$I2418 \$I2899 VDD_DEC pfet_05v0 L=0.5U W=1.22U AS=0.3172P
+ AD=0.3782P PS=1.74U PD=1.84U
* device instance $919 m90 *1 562.57,829.53 pfet_05v0
M$919 \$I2897 \$I2170 \$I2898 VDD_DEC pfet_05v0 L=0.5U W=1.22U AS=0.3782P
+ AD=0.3782P PS=1.84U PD=1.84U
* device instance $920 m90 *1 561.45,829.53 pfet_05v0
M$920 \$I2063 \$I2204 \$I2897 VDD_DEC pfet_05v0 L=0.5U W=1.22U AS=0.3782P
+ AD=0.5368P PS=1.84U PD=3.32U
* device instance $921 m90 *1 564.76,827.22 nfet_05v0
M$921 \$I2063 \$I2360 VSS VSS nfet_05v0 L=0.6U W=0.36U AS=0.1584P AD=0.0936P
+ PS=1.6U PD=0.88U
* device instance $922 m90 *1 563.64,827.22 nfet_05v0
M$922 VSS \$I2418 \$I2063 VSS nfet_05v0 L=0.6U W=0.36U AS=0.0936P AD=0.0936P
+ PS=0.88U PD=0.88U
* device instance $923 m90 *1 562.52,827.22 nfet_05v0
M$923 \$I2063 \$I2170 VSS VSS nfet_05v0 L=0.6U W=0.36U AS=0.0936P AD=0.0936P
+ PS=0.88U PD=0.88U
* device instance $924 m90 *1 561.4,827.22 nfet_05v0
M$924 VSS \$I2204 \$I2063 VSS nfet_05v0 L=0.6U W=0.36U AS=0.0936P AD=0.1584P
+ PS=0.88U PD=1.6U
* device instance $925 m90 *1 580.39,798.17 pfet_05v0
M$925 \$I2902 \$I2251 VDD_DEC VDD_DEC pfet_05v0 L=0.5U W=1.22U AS=0.5368P
+ AD=0.3172P PS=3.32U PD=1.74U
* device instance $926 m90 *1 579.37,798.17 pfet_05v0
M$926 \$I2901 \$I2207 \$I2902 VDD_DEC pfet_05v0 L=0.5U W=1.22U AS=0.3172P
+ AD=0.3782P PS=1.74U PD=1.84U
* device instance $927 m90 *1 578.25,798.17 pfet_05v0
M$927 \$I2900 \$I2208 \$I2901 VDD_DEC pfet_05v0 L=0.5U W=1.22U AS=0.3782P
+ AD=0.3782P PS=1.84U PD=1.84U
* device instance $928 m90 *1 577.13,798.17 pfet_05v0
M$928 \$I2027 \$I2237 \$I2900 VDD_DEC pfet_05v0 L=0.5U W=1.22U AS=0.3782P
+ AD=0.5368P PS=1.84U PD=3.32U
* device instance $929 m90 *1 580.44,795.86 nfet_05v0
M$929 \$I2027 \$I2251 VSS VSS nfet_05v0 L=0.6U W=0.36U AS=0.1584P AD=0.0936P
+ PS=1.6U PD=0.88U
* device instance $930 m90 *1 579.32,795.86 nfet_05v0
M$930 VSS \$I2207 \$I2027 VSS nfet_05v0 L=0.6U W=0.36U AS=0.0936P AD=0.0936P
+ PS=0.88U PD=0.88U
* device instance $931 m90 *1 578.2,795.86 nfet_05v0
M$931 \$I2027 \$I2208 VSS VSS nfet_05v0 L=0.6U W=0.36U AS=0.0936P AD=0.0936P
+ PS=0.88U PD=0.88U
* device instance $932 m90 *1 577.08,795.86 nfet_05v0
M$932 VSS \$I2237 \$I2027 VSS nfet_05v0 L=0.6U W=0.36U AS=0.0936P AD=0.1584P
+ PS=0.88U PD=1.6U
* device instance $933 m90 *1 505.35,806.01 pfet_05v0
M$933 \$I2905 \$I2305 VDD_DEC VDD_DEC pfet_05v0 L=0.5U W=1.22U AS=0.5368P
+ AD=0.3172P PS=3.32U PD=1.74U
* device instance $934 m90 *1 504.33,806.01 pfet_05v0
M$934 \$I2904 \$I2200 \$I2905 VDD_DEC pfet_05v0 L=0.5U W=1.22U AS=0.3172P
+ AD=0.3782P PS=1.74U PD=1.84U
* device instance $935 m90 *1 503.21,806.01 pfet_05v0
M$935 \$I2903 \$I2249 \$I2904 VDD_DEC pfet_05v0 L=0.5U W=1.22U AS=0.3782P
+ AD=0.3782P PS=1.84U PD=1.84U
* device instance $936 m90 *1 502.09,806.01 pfet_05v0
M$936 \$I2304 \$I2201 \$I2903 VDD_DEC pfet_05v0 L=0.5U W=1.22U AS=0.3782P
+ AD=0.5368P PS=1.84U PD=3.32U
* device instance $937 m90 *1 505.4,803.7 nfet_05v0
M$937 \$I2304 \$I2305 VSS VSS nfet_05v0 L=0.6U W=0.36U AS=0.1584P AD=0.0936P
+ PS=1.6U PD=0.88U
* device instance $938 m90 *1 504.28,803.7 nfet_05v0
M$938 VSS \$I2200 \$I2304 VSS nfet_05v0 L=0.6U W=0.36U AS=0.0936P AD=0.0936P
+ PS=0.88U PD=0.88U
* device instance $939 m90 *1 503.16,803.7 nfet_05v0
M$939 \$I2304 \$I2249 VSS VSS nfet_05v0 L=0.6U W=0.36U AS=0.0936P AD=0.0936P
+ PS=0.88U PD=0.88U
* device instance $940 m90 *1 502.04,803.7 nfet_05v0
M$940 VSS \$I2201 \$I2304 VSS nfet_05v0 L=0.6U W=0.36U AS=0.0936P AD=0.1584P
+ PS=0.88U PD=1.6U
* device instance $941 m90 *1 562.47,806.01 pfet_05v0
M$941 \$I2908 \$I2357 VDD_DEC VDD_DEC pfet_05v0 L=0.5U W=1.22U AS=0.5368P
+ AD=0.3172P PS=3.32U PD=1.74U
* device instance $942 m90 *1 561.45,806.01 pfet_05v0
M$942 \$I2907 \$I2203 \$I2908 VDD_DEC pfet_05v0 L=0.5U W=1.22U AS=0.3172P
+ AD=0.3782P PS=1.74U PD=1.84U
* device instance $943 m90 *1 560.33,806.01 pfet_05v0
M$943 \$I2906 \$I2383 \$I2907 VDD_DEC pfet_05v0 L=0.5U W=1.22U AS=0.3782P
+ AD=0.3782P PS=1.84U PD=1.84U
* device instance $944 m90 *1 559.21,806.01 pfet_05v0
M$944 \$I2130 \$I2280 \$I2906 VDD_DEC pfet_05v0 L=0.5U W=1.22U AS=0.3782P
+ AD=0.5368P PS=1.84U PD=3.32U
* device instance $945 m90 *1 562.52,803.7 nfet_05v0
M$945 \$I2130 \$I2357 VSS VSS nfet_05v0 L=0.6U W=0.36U AS=0.1584P AD=0.0936P
+ PS=1.6U PD=0.88U
* device instance $946 m90 *1 561.4,803.7 nfet_05v0
M$946 VSS \$I2203 \$I2130 VSS nfet_05v0 L=0.6U W=0.36U AS=0.0936P AD=0.0936P
+ PS=0.88U PD=0.88U
* device instance $947 m90 *1 560.28,803.7 nfet_05v0
M$947 \$I2130 \$I2383 VSS VSS nfet_05v0 L=0.6U W=0.36U AS=0.0936P AD=0.0936P
+ PS=0.88U PD=0.88U
* device instance $948 m90 *1 559.16,803.7 nfet_05v0
M$948 VSS \$I2280 \$I2130 VSS nfet_05v0 L=0.6U W=0.36U AS=0.0936P AD=0.1584P
+ PS=0.88U PD=1.6U
* device instance $949 m90 *1 496.39,798.17 pfet_05v0
M$949 \$I2911 \$I2232 VDD_DEC VDD_DEC pfet_05v0 L=0.5U W=1.22U AS=0.5368P
+ AD=0.3172P PS=3.32U PD=1.74U
* device instance $950 m90 *1 495.37,798.17 pfet_05v0
M$950 \$I2910 \$I2197 \$I2911 VDD_DEC pfet_05v0 L=0.5U W=1.22U AS=0.3172P
+ AD=0.3782P PS=1.74U PD=1.84U
* device instance $951 m90 *1 494.25,798.17 pfet_05v0
M$951 \$I2909 \$I2249 \$I2910 VDD_DEC pfet_05v0 L=0.5U W=1.22U AS=0.3782P
+ AD=0.3782P PS=1.84U PD=1.84U
* device instance $952 m90 *1 493.13,798.17 pfet_05v0
M$952 \$I2198 \$I2196 \$I2909 VDD_DEC pfet_05v0 L=0.5U W=1.22U AS=0.3782P
+ AD=0.5368P PS=1.84U PD=3.32U
* device instance $953 m90 *1 496.44,795.86 nfet_05v0
M$953 \$I2198 \$I2232 VSS VSS nfet_05v0 L=0.6U W=0.36U AS=0.1584P AD=0.0936P
+ PS=1.6U PD=0.88U
* device instance $954 m90 *1 495.32,795.86 nfet_05v0
M$954 VSS \$I2197 \$I2198 VSS nfet_05v0 L=0.6U W=0.36U AS=0.0936P AD=0.0936P
+ PS=0.88U PD=0.88U
* device instance $955 m90 *1 494.2,795.86 nfet_05v0
M$955 \$I2198 \$I2249 VSS VSS nfet_05v0 L=0.6U W=0.36U AS=0.0936P AD=0.0936P
+ PS=0.88U PD=0.88U
* device instance $956 m90 *1 493.08,795.86 nfet_05v0
M$956 VSS \$I2196 \$I2198 VSS nfet_05v0 L=0.6U W=0.36U AS=0.0936P AD=0.1584P
+ PS=0.88U PD=1.6U
* device instance $957 m90 *1 590.47,806.01 pfet_05v0
M$957 \$I2914 \$I2274 VDD_DEC VDD_DEC pfet_05v0 L=0.5U W=1.22U AS=0.5368P
+ AD=0.3172P PS=3.32U PD=1.74U
* device instance $958 m90 *1 589.45,806.01 pfet_05v0
M$958 \$I2913 \$I2207 \$I2914 VDD_DEC pfet_05v0 L=0.5U W=1.22U AS=0.3172P
+ AD=0.3782P PS=1.74U PD=1.84U
* device instance $959 m90 *1 588.33,806.01 pfet_05v0
M$959 \$I2912 \$I2170 \$I2913 VDD_DEC pfet_05v0 L=0.5U W=1.22U AS=0.3782P
+ AD=0.3782P PS=1.84U PD=1.84U
* device instance $960 m90 *1 587.21,806.01 pfet_05v0
M$960 \$I2026 \$I2280 \$I2912 VDD_DEC pfet_05v0 L=0.5U W=1.22U AS=0.3782P
+ AD=0.5368P PS=1.84U PD=3.32U
* device instance $961 m90 *1 590.52,803.7 nfet_05v0
M$961 \$I2026 \$I2274 VSS VSS nfet_05v0 L=0.6U W=0.36U AS=0.1584P AD=0.0936P
+ PS=1.6U PD=0.88U
* device instance $962 m90 *1 589.4,803.7 nfet_05v0
M$962 VSS \$I2207 \$I2026 VSS nfet_05v0 L=0.6U W=0.36U AS=0.0936P AD=0.0936P
+ PS=0.88U PD=0.88U
* device instance $963 m90 *1 588.28,803.7 nfet_05v0
M$963 \$I2026 \$I2170 VSS VSS nfet_05v0 L=0.6U W=0.36U AS=0.0936P AD=0.0936P
+ PS=0.88U PD=0.88U
* device instance $964 m90 *1 587.16,803.7 nfet_05v0
M$964 VSS \$I2280 \$I2026 VSS nfet_05v0 L=0.6U W=0.36U AS=0.0936P AD=0.1584P
+ PS=0.88U PD=1.6U
* device instance $965 m90 *1 570.87,806.01 pfet_05v0
M$965 \$I2917 \$I2308 VDD_DEC VDD_DEC pfet_05v0 L=0.5U W=1.22U AS=0.5368P
+ AD=0.3172P PS=3.32U PD=1.74U
* device instance $966 m90 *1 569.85,806.01 pfet_05v0
M$966 \$I2916 \$I2207 \$I2917 VDD_DEC pfet_05v0 L=0.5U W=1.22U AS=0.3172P
+ AD=0.3782P PS=1.74U PD=1.84U
* device instance $967 m90 *1 568.73,806.01 pfet_05v0
M$967 \$I2915 \$I2170 \$I2916 VDD_DEC pfet_05v0 L=0.5U W=1.22U AS=0.3782P
+ AD=0.3782P PS=1.84U PD=1.84U
* device instance $968 m90 *1 567.61,806.01 pfet_05v0
M$968 \$I2065 \$I2204 \$I2915 VDD_DEC pfet_05v0 L=0.5U W=1.22U AS=0.3782P
+ AD=0.5368P PS=1.84U PD=3.32U
* device instance $969 m90 *1 570.92,803.7 nfet_05v0
M$969 \$I2065 \$I2308 VSS VSS nfet_05v0 L=0.6U W=0.36U AS=0.1584P AD=0.0936P
+ PS=1.6U PD=0.88U
* device instance $970 m90 *1 569.8,803.7 nfet_05v0
M$970 VSS \$I2207 \$I2065 VSS nfet_05v0 L=0.6U W=0.36U AS=0.0936P AD=0.0936P
+ PS=0.88U PD=0.88U
* device instance $971 m90 *1 568.68,803.7 nfet_05v0
M$971 \$I2065 \$I2170 VSS VSS nfet_05v0 L=0.6U W=0.36U AS=0.0936P AD=0.0936P
+ PS=0.88U PD=0.88U
* device instance $972 m90 *1 567.56,803.7 nfet_05v0
M$972 VSS \$I2204 \$I2065 VSS nfet_05v0 L=0.6U W=0.36U AS=0.0936P AD=0.1584P
+ PS=0.88U PD=1.6U
* device instance $973 m90 *1 668.87,798.17 pfet_05v0
M$973 \$I2920 \$I2251 VDD_DEC VDD_DEC pfet_05v0 L=0.5U W=1.22U AS=0.5368P
+ AD=0.3172P PS=3.32U PD=1.74U
* device instance $974 m90 *1 667.85,798.17 pfet_05v0
M$974 \$I2919 \$I2215 \$I2920 VDD_DEC pfet_05v0 L=0.5U W=1.22U AS=0.3172P
+ AD=0.3782P PS=1.74U PD=1.84U
* device instance $975 m90 *1 666.73,798.17 pfet_05v0
M$975 \$I2918 \$I2243 \$I2919 VDD_DEC pfet_05v0 L=0.5U W=1.22U AS=0.3782P
+ AD=0.3782P PS=1.84U PD=1.84U
* device instance $976 m90 *1 665.61,798.17 pfet_05v0
M$976 \$I2259 \$I2139 \$I2918 VDD_DEC pfet_05v0 L=0.5U W=1.22U AS=0.3782P
+ AD=0.5368P PS=1.84U PD=3.32U
* device instance $977 m90 *1 668.92,795.86 nfet_05v0
M$977 \$I2259 \$I2251 VSS VSS nfet_05v0 L=0.6U W=0.36U AS=0.1584P AD=0.0936P
+ PS=1.6U PD=0.88U
* device instance $978 m90 *1 667.8,795.86 nfet_05v0
M$978 VSS \$I2215 \$I2259 VSS nfet_05v0 L=0.6U W=0.36U AS=0.0936P AD=0.0936P
+ PS=0.88U PD=0.88U
* device instance $979 m90 *1 666.68,795.86 nfet_05v0
M$979 \$I2259 \$I2243 VSS VSS nfet_05v0 L=0.6U W=0.36U AS=0.0936P AD=0.0936P
+ PS=0.88U PD=0.88U
* device instance $980 m90 *1 665.56,795.86 nfet_05v0
M$980 VSS \$I2139 \$I2259 VSS nfet_05v0 L=0.6U W=0.36U AS=0.0936P AD=0.1584P
+ PS=0.88U PD=1.6U
* device instance $981 m90 *1 577.03,821.69 pfet_05v0
M$981 \$I2923 \$I2402 VDD_DEC VDD_DEC pfet_05v0 L=0.5U W=1.22U AS=0.5368P
+ AD=0.3172P PS=3.32U PD=1.74U
* device instance $982 m90 *1 576.01,821.69 pfet_05v0
M$982 \$I2922 \$I2212 \$I2923 VDD_DEC pfet_05v0 L=0.5U W=1.22U AS=0.3172P
+ AD=0.3782P PS=1.74U PD=1.84U
* device instance $983 m90 *1 574.89,821.69 pfet_05v0
M$983 \$I2921 \$I2211 \$I2922 VDD_DEC pfet_05v0 L=0.5U W=1.22U AS=0.3782P
+ AD=0.3782P PS=1.84U PD=1.84U
* device instance $984 m90 *1 573.77,821.69 pfet_05v0
M$984 \$I2282 \$I2237 \$I2921 VDD_DEC pfet_05v0 L=0.5U W=1.22U AS=0.3782P
+ AD=0.5368P PS=1.84U PD=3.32U
* device instance $985 m90 *1 577.08,819.38 nfet_05v0
M$985 \$I2282 \$I2402 VSS VSS nfet_05v0 L=0.6U W=0.36U AS=0.1584P AD=0.0936P
+ PS=1.6U PD=0.88U
* device instance $986 m90 *1 575.96,819.38 nfet_05v0
M$986 VSS \$I2212 \$I2282 VSS nfet_05v0 L=0.6U W=0.36U AS=0.0936P AD=0.0936P
+ PS=0.88U PD=0.88U
* device instance $987 m90 *1 574.84,819.38 nfet_05v0
M$987 \$I2282 \$I2211 VSS VSS nfet_05v0 L=0.6U W=0.36U AS=0.0936P AD=0.0936P
+ PS=0.88U PD=0.88U
* device instance $988 m90 *1 573.72,819.38 nfet_05v0
M$988 VSS \$I2237 \$I2282 VSS nfet_05v0 L=0.6U W=0.36U AS=0.0936P AD=0.1584P
+ PS=0.88U PD=1.6U
* device instance $989 m90 *1 523.27,813.85 pfet_05v0
M$989 \$I2926 \$I2380 VDD_DEC VDD_DEC pfet_05v0 L=0.5U W=1.22U AS=0.5368P
+ AD=0.3172P PS=3.32U PD=1.74U
* device instance $990 m90 *1 522.25,813.85 pfet_05v0
M$990 \$I2925 \$I2200 \$I2926 VDD_DEC pfet_05v0 L=0.5U W=1.22U AS=0.3172P
+ AD=0.3782P PS=1.74U PD=1.84U
* device instance $991 m90 *1 521.13,813.85 pfet_05v0
M$991 \$I2924 \$I2249 \$I2925 VDD_DEC pfet_05v0 L=0.5U W=1.22U AS=0.3782P
+ AD=0.3782P PS=1.84U PD=1.84U
* device instance $992 m90 *1 520.01,813.85 pfet_05v0
M$992 \$I2054 \$I2201 \$I2924 VDD_DEC pfet_05v0 L=0.5U W=1.22U AS=0.3782P
+ AD=0.5368P PS=1.84U PD=3.32U
* device instance $993 m90 *1 523.32,811.54 nfet_05v0
M$993 \$I2054 \$I2380 VSS VSS nfet_05v0 L=0.6U W=0.36U AS=0.1584P AD=0.0936P
+ PS=1.6U PD=0.88U
* device instance $994 m90 *1 522.2,811.54 nfet_05v0
M$994 VSS \$I2200 \$I2054 VSS nfet_05v0 L=0.6U W=0.36U AS=0.0936P AD=0.0936P
+ PS=0.88U PD=0.88U
* device instance $995 m90 *1 521.08,811.54 nfet_05v0
M$995 \$I2054 \$I2249 VSS VSS nfet_05v0 L=0.6U W=0.36U AS=0.0936P AD=0.0936P
+ PS=0.88U PD=0.88U
* device instance $996 m90 *1 519.96,811.54 nfet_05v0
M$996 VSS \$I2201 \$I2054 VSS nfet_05v0 L=0.6U W=0.36U AS=0.0936P AD=0.1584P
+ PS=0.88U PD=1.6U
* device instance $997 m0 *1 593.53,807.91 pfet_05v0
M$997 \$I2929 \$I2360 VDD_DEC VDD_DEC pfet_05v0 L=0.5U W=1.22U AS=0.5368P
+ AD=0.3172P PS=3.32U PD=1.74U
* device instance $998 m0 *1 594.55,807.91 pfet_05v0
M$998 \$I2928 \$I2212 \$I2929 VDD_DEC pfet_05v0 L=0.5U W=1.22U AS=0.3172P
+ AD=0.3782P PS=1.74U PD=1.84U
* device instance $999 m0 *1 595.67,807.91 pfet_05v0
M$999 \$I2927 \$I2243 \$I2928 VDD_DEC pfet_05v0 L=0.5U W=1.22U AS=0.3782P
+ AD=0.3782P PS=1.84U PD=1.84U
* device instance $1000 m0 *1 596.79,807.91 pfet_05v0
M$1000 \$I2254 \$I2240 \$I2927 VDD_DEC pfet_05v0 L=0.5U W=1.22U AS=0.3782P
+ AD=0.5368P PS=1.84U PD=3.32U
* device instance $1001 m0 *1 593.48,810.22 nfet_05v0
M$1001 \$I2254 \$I2360 VSS VSS nfet_05v0 L=0.6U W=0.36U AS=0.1584P AD=0.0936P
+ PS=1.6U PD=0.88U
* device instance $1002 m0 *1 594.6,810.22 nfet_05v0
M$1002 VSS \$I2212 \$I2254 VSS nfet_05v0 L=0.6U W=0.36U AS=0.0936P AD=0.0936P
+ PS=0.88U PD=0.88U
* device instance $1003 m0 *1 595.72,810.22 nfet_05v0
M$1003 \$I2254 \$I2243 VSS VSS nfet_05v0 L=0.6U W=0.36U AS=0.0936P AD=0.0936P
+ PS=0.88U PD=0.88U
* device instance $1004 m0 *1 596.84,810.22 nfet_05v0
M$1004 VSS \$I2240 \$I2254 VSS nfet_05v0 L=0.6U W=0.36U AS=0.0936P AD=0.1584P
+ PS=0.88U PD=1.6U
* device instance $1005 m0 *1 545.37,831.43 pfet_05v0
M$1005 \$I2932 \$I2166 VDD_DEC VDD_DEC pfet_05v0 L=0.5U W=1.22U AS=0.5368P
+ AD=0.3172P PS=3.32U PD=1.74U
* device instance $1006 m0 *1 546.39,831.43 pfet_05v0
M$1006 \$I2931 \$I2418 \$I2932 VDD_DEC pfet_05v0 L=0.5U W=1.22U AS=0.3172P
+ AD=0.3782P PS=1.74U PD=1.84U
* device instance $1007 m0 *1 547.51,831.43 pfet_05v0
M$1007 \$I2930 \$I2333 \$I2931 VDD_DEC pfet_05v0 L=0.5U W=1.22U AS=0.3782P
+ AD=0.3782P PS=1.84U PD=1.84U
* device instance $1008 m0 *1 548.63,831.43 pfet_05v0
M$1008 \$I2278 \$I2359 \$I2930 VDD_DEC pfet_05v0 L=0.5U W=1.22U AS=0.3782P
+ AD=0.5368P PS=1.84U PD=3.32U
* device instance $1009 m0 *1 545.32,833.74 nfet_05v0
M$1009 \$I2278 \$I2166 VSS VSS nfet_05v0 L=0.6U W=0.36U AS=0.1584P AD=0.0936P
+ PS=1.6U PD=0.88U
* device instance $1010 m0 *1 546.44,833.74 nfet_05v0
M$1010 VSS \$I2418 \$I2278 VSS nfet_05v0 L=0.6U W=0.36U AS=0.0936P AD=0.0936P
+ PS=0.88U PD=0.88U
* device instance $1011 m0 *1 547.56,833.74 nfet_05v0
M$1011 \$I2278 \$I2333 VSS VSS nfet_05v0 L=0.6U W=0.36U AS=0.0936P AD=0.0936P
+ PS=0.88U PD=0.88U
* device instance $1012 m0 *1 548.68,833.74 nfet_05v0
M$1012 VSS \$I2359 \$I2278 VSS nfet_05v0 L=0.6U W=0.36U AS=0.0936P AD=0.1584P
+ PS=0.88U PD=1.6U
* device instance $1013 m0 *1 636.09,823.59 pfet_05v0
M$1013 \$I2935 \$I2251 VDD_DEC VDD_DEC pfet_05v0 L=0.5U W=1.22U AS=0.5368P
+ AD=0.3172P PS=3.32U PD=1.74U
* device instance $1014 m0 *1 637.11,823.59 pfet_05v0
M$1014 \$I2934 \$I2215 \$I2935 VDD_DEC pfet_05v0 L=0.5U W=1.22U AS=0.3172P
+ AD=0.3782P PS=1.74U PD=1.84U
* device instance $1015 m0 *1 638.23,823.59 pfet_05v0
M$1015 \$I2933 \$I2341 \$I2934 VDD_DEC pfet_05v0 L=0.5U W=1.22U AS=0.3782P
+ AD=0.3782P PS=1.84U PD=1.84U
* device instance $1016 m0 *1 639.35,823.59 pfet_05v0
M$1016 \$I2169 \$I2139 \$I2933 VDD_DEC pfet_05v0 L=0.5U W=1.22U AS=0.3782P
+ AD=0.5368P PS=1.84U PD=3.32U
* device instance $1017 m0 *1 636.04,825.9 nfet_05v0
M$1017 \$I2169 \$I2251 VSS VSS nfet_05v0 L=0.6U W=0.36U AS=0.1584P AD=0.0936P
+ PS=1.6U PD=0.88U
* device instance $1018 m0 *1 637.16,825.9 nfet_05v0
M$1018 VSS \$I2215 \$I2169 VSS nfet_05v0 L=0.6U W=0.36U AS=0.0936P AD=0.0936P
+ PS=0.88U PD=0.88U
* device instance $1019 m0 *1 638.28,825.9 nfet_05v0
M$1019 \$I2169 \$I2341 VSS VSS nfet_05v0 L=0.6U W=0.36U AS=0.0936P AD=0.0936P
+ PS=0.88U PD=0.88U
* device instance $1020 m0 *1 639.4,825.9 nfet_05v0
M$1020 VSS \$I2139 \$I2169 VSS nfet_05v0 L=0.6U W=0.36U AS=0.0936P AD=0.1584P
+ PS=0.88U PD=1.6U
* device instance $1021 m0 *1 628.81,815.75 pfet_05v0
M$1021 \$I2938 \$I2357 VDD_DEC VDD_DEC pfet_05v0 L=0.5U W=1.22U AS=0.5368P
+ AD=0.3172P PS=3.32U PD=1.74U
* device instance $1022 m0 *1 629.83,815.75 pfet_05v0
M$1022 \$I2937 \$I2215 \$I2938 VDD_DEC pfet_05v0 L=0.5U W=1.22U AS=0.3172P
+ AD=0.3782P PS=1.74U PD=1.84U
* device instance $1023 m0 *1 630.95,815.75 pfet_05v0
M$1023 \$I2936 \$I2341 \$I2937 VDD_DEC pfet_05v0 L=0.5U W=1.22U AS=0.3782P
+ AD=0.3782P PS=1.84U PD=1.84U
* device instance $1024 m0 *1 632.07,815.75 pfet_05v0
M$1024 \$I2343 \$I2139 \$I2936 VDD_DEC pfet_05v0 L=0.5U W=1.22U AS=0.3782P
+ AD=0.5368P PS=1.84U PD=3.32U
* device instance $1025 m0 *1 628.76,818.06 nfet_05v0
M$1025 \$I2343 \$I2357 VSS VSS nfet_05v0 L=0.6U W=0.36U AS=0.1584P AD=0.0936P
+ PS=1.6U PD=0.88U
* device instance $1026 m0 *1 629.88,818.06 nfet_05v0
M$1026 VSS \$I2215 \$I2343 VSS nfet_05v0 L=0.6U W=0.36U AS=0.0936P AD=0.0936P
+ PS=0.88U PD=0.88U
* device instance $1027 m0 *1 631,818.06 nfet_05v0
M$1027 \$I2343 \$I2341 VSS VSS nfet_05v0 L=0.6U W=0.36U AS=0.0936P AD=0.0936P
+ PS=0.88U PD=0.88U
* device instance $1028 m0 *1 632.12,818.06 nfet_05v0
M$1028 VSS \$I2139 \$I2343 VSS nfet_05v0 L=0.6U W=0.36U AS=0.0936P AD=0.1584P
+ PS=0.88U PD=1.6U
* device instance $1029 m0 *1 497.77,800.07 pfet_05v0
M$1029 \$I2941 \$I2247 VDD_DEC VDD_DEC pfet_05v0 L=0.5U W=1.22U AS=0.5368P
+ AD=0.3172P PS=3.32U PD=1.74U
* device instance $1030 m0 *1 498.79,800.07 pfet_05v0
M$1030 \$I2940 \$I2197 \$I2941 VDD_DEC pfet_05v0 L=0.5U W=1.22U AS=0.3172P
+ AD=0.3782P PS=1.74U PD=1.84U
* device instance $1031 m0 *1 499.91,800.07 pfet_05v0
M$1031 \$I2939 \$I2249 \$I2940 VDD_DEC pfet_05v0 L=0.5U W=1.22U AS=0.3782P
+ AD=0.3782P PS=1.84U PD=1.84U
* device instance $1032 m0 *1 501.03,800.07 pfet_05v0
M$1032 \$I2272 \$I2201 \$I2939 VDD_DEC pfet_05v0 L=0.5U W=1.22U AS=0.3782P
+ AD=0.5368P PS=1.84U PD=3.32U
* device instance $1033 m0 *1 497.72,802.38 nfet_05v0
M$1033 \$I2272 \$I2247 VSS VSS nfet_05v0 L=0.6U W=0.36U AS=0.1584P AD=0.0936P
+ PS=1.6U PD=0.88U
* device instance $1034 m0 *1 498.84,802.38 nfet_05v0
M$1034 VSS \$I2197 \$I2272 VSS nfet_05v0 L=0.6U W=0.36U AS=0.0936P AD=0.0936P
+ PS=0.88U PD=0.88U
* device instance $1035 m0 *1 499.96,802.38 nfet_05v0
M$1035 \$I2272 \$I2249 VSS VSS nfet_05v0 L=0.6U W=0.36U AS=0.0936P AD=0.0936P
+ PS=0.88U PD=0.88U
* device instance $1036 m0 *1 501.08,802.38 nfet_05v0
M$1036 VSS \$I2201 \$I2272 VSS nfet_05v0 L=0.6U W=0.36U AS=0.0936P AD=0.1584P
+ PS=0.88U PD=1.6U
* device instance $1037 m0 *1 503.37,800.07 pfet_05v0
M$1037 \$I2944 \$I2232 VDD_DEC VDD_DEC pfet_05v0 L=0.5U W=1.22U AS=0.5368P
+ AD=0.3172P PS=3.32U PD=1.74U
* device instance $1038 m0 *1 504.39,800.07 pfet_05v0
M$1038 \$I2943 \$I2200 \$I2944 VDD_DEC pfet_05v0 L=0.5U W=1.22U AS=0.3172P
+ AD=0.3782P PS=1.74U PD=1.84U
* device instance $1039 m0 *1 505.51,800.07 pfet_05v0
M$1039 \$I2942 \$I2250 \$I2943 VDD_DEC pfet_05v0 L=0.5U W=1.22U AS=0.3782P
+ AD=0.3782P PS=1.84U PD=1.84U
* device instance $1040 m0 *1 506.63,800.07 pfet_05v0
M$1040 \$I2273 \$I2201 \$I2942 VDD_DEC pfet_05v0 L=0.5U W=1.22U AS=0.3782P
+ AD=0.5368P PS=1.84U PD=3.32U
* device instance $1041 m0 *1 503.32,802.38 nfet_05v0
M$1041 \$I2273 \$I2232 VSS VSS nfet_05v0 L=0.6U W=0.36U AS=0.1584P AD=0.0936P
+ PS=1.6U PD=0.88U
* device instance $1042 m0 *1 504.44,802.38 nfet_05v0
M$1042 VSS \$I2200 \$I2273 VSS nfet_05v0 L=0.6U W=0.36U AS=0.0936P AD=0.0936P
+ PS=0.88U PD=0.88U
* device instance $1043 m0 *1 505.56,802.38 nfet_05v0
M$1043 \$I2273 \$I2250 VSS VSS nfet_05v0 L=0.6U W=0.36U AS=0.0936P AD=0.0936P
+ PS=0.88U PD=0.88U
* device instance $1044 m0 *1 506.68,802.38 nfet_05v0
M$1044 VSS \$I2201 \$I2273 VSS nfet_05v0 L=0.6U W=0.36U AS=0.0936P AD=0.1584P
+ PS=0.88U PD=1.6U
* device instance $1045 m0 *1 590.73,792.23 pfet_05v0
M$1045 \$I2947 \$I2238 VDD_DEC VDD_DEC pfet_05v0 L=0.5U W=1.22U AS=0.5368P
+ AD=0.3172P PS=3.32U PD=1.74U
* device instance $1046 m0 *1 591.75,792.23 pfet_05v0
M$1046 \$I2946 \$I2212 \$I2947 VDD_DEC pfet_05v0 L=0.5U W=1.22U AS=0.3172P
+ AD=0.3782P PS=1.74U PD=1.84U
* device instance $1047 m0 *1 592.87,792.23 pfet_05v0
M$1047 \$I2945 \$I2211 \$I2946 VDD_DEC pfet_05v0 L=0.5U W=1.22U AS=0.3782P
+ AD=0.3782P PS=1.84U PD=1.84U
* device instance $1048 m0 *1 593.99,792.23 pfet_05v0
M$1048 \$I2072 \$I2172 \$I2945 VDD_DEC pfet_05v0 L=0.5U W=1.22U AS=0.3782P
+ AD=0.5368P PS=1.84U PD=3.32U
* device instance $1049 m0 *1 590.68,794.54 nfet_05v0
M$1049 \$I2072 \$I2238 VSS VSS nfet_05v0 L=0.6U W=0.36U AS=0.1584P AD=0.0936P
+ PS=1.6U PD=0.88U
* device instance $1050 m0 *1 591.8,794.54 nfet_05v0
M$1050 VSS \$I2212 \$I2072 VSS nfet_05v0 L=0.6U W=0.36U AS=0.0936P AD=0.0936P
+ PS=0.88U PD=0.88U
* device instance $1051 m0 *1 592.92,794.54 nfet_05v0
M$1051 \$I2072 \$I2211 VSS VSS nfet_05v0 L=0.6U W=0.36U AS=0.0936P AD=0.0936P
+ PS=0.88U PD=0.88U
* device instance $1052 m0 *1 594.04,794.54 nfet_05v0
M$1052 VSS \$I2172 \$I2072 VSS nfet_05v0 L=0.6U W=0.36U AS=0.0936P AD=0.1584P
+ PS=0.88U PD=1.6U
* device instance $1053 m0 *1 630.49,823.59 pfet_05v0
M$1053 \$I2950 \$I2209 VDD_DEC VDD_DEC pfet_05v0 L=0.5U W=1.22U AS=0.5368P
+ AD=0.3172P PS=3.32U PD=1.74U
* device instance $1054 m0 *1 631.51,823.59 pfet_05v0
M$1054 \$I2949 \$I2140 \$I2950 VDD_DEC pfet_05v0 L=0.5U W=1.22U AS=0.3172P
+ AD=0.3782P PS=1.74U PD=1.84U
* device instance $1055 m0 *1 632.63,823.59 pfet_05v0
M$1055 \$I2948 \$I2179 \$I2949 VDD_DEC pfet_05v0 L=0.5U W=1.22U AS=0.3782P
+ AD=0.3782P PS=1.84U PD=1.84U
* device instance $1056 m0 *1 633.75,823.59 pfet_05v0
M$1056 \$I2216 \$I2138 \$I2948 VDD_DEC pfet_05v0 L=0.5U W=1.22U AS=0.3782P
+ AD=0.5368P PS=1.84U PD=3.32U
* device instance $1057 m0 *1 630.44,825.9 nfet_05v0
M$1057 \$I2216 \$I2209 VSS VSS nfet_05v0 L=0.6U W=0.36U AS=0.1584P AD=0.0936P
+ PS=1.6U PD=0.88U
* device instance $1058 m0 *1 631.56,825.9 nfet_05v0
M$1058 VSS \$I2140 \$I2216 VSS nfet_05v0 L=0.6U W=0.36U AS=0.0936P AD=0.0936P
+ PS=0.88U PD=0.88U
* device instance $1059 m0 *1 632.68,825.9 nfet_05v0
M$1059 \$I2216 \$I2179 VSS VSS nfet_05v0 L=0.6U W=0.36U AS=0.0936P AD=0.0936P
+ PS=0.88U PD=0.88U
* device instance $1060 m0 *1 633.8,825.9 nfet_05v0
M$1060 VSS \$I2138 \$I2216 VSS nfet_05v0 L=0.6U W=0.36U AS=0.0936P AD=0.1584P
+ PS=0.88U PD=1.6U
* device instance $1061 m0 *1 608.65,800.07 pfet_05v0
M$1061 \$I2953 \$I2205 VDD_DEC VDD_DEC pfet_05v0 L=0.5U W=1.22U AS=0.5368P
+ AD=0.3172P PS=3.32U PD=1.74U
* device instance $1062 m0 *1 609.67,800.07 pfet_05v0
M$1062 \$I2952 \$I2285 \$I2953 VDD_DEC pfet_05v0 L=0.5U W=1.22U AS=0.3172P
+ AD=0.3782P PS=1.74U PD=1.84U
* device instance $1063 m0 *1 610.79,800.07 pfet_05v0
M$1063 \$I2951 \$I2243 \$I2952 VDD_DEC pfet_05v0 L=0.5U W=1.22U AS=0.3782P
+ AD=0.3782P PS=1.84U PD=1.84U
* device instance $1064 m0 *1 611.91,800.07 pfet_05v0
M$1064 \$I2244 \$I2214 \$I2951 VDD_DEC pfet_05v0 L=0.5U W=1.22U AS=0.3782P
+ AD=0.5368P PS=1.84U PD=3.32U
* device instance $1065 m0 *1 608.6,802.38 nfet_05v0
M$1065 \$I2244 \$I2205 VSS VSS nfet_05v0 L=0.6U W=0.36U AS=0.1584P AD=0.0936P
+ PS=1.6U PD=0.88U
* device instance $1066 m0 *1 609.72,802.38 nfet_05v0
M$1066 VSS \$I2285 \$I2244 VSS nfet_05v0 L=0.6U W=0.36U AS=0.0936P AD=0.0936P
+ PS=0.88U PD=0.88U
* device instance $1067 m0 *1 610.84,802.38 nfet_05v0
M$1067 \$I2244 \$I2243 VSS VSS nfet_05v0 L=0.6U W=0.36U AS=0.0936P AD=0.0936P
+ PS=0.88U PD=0.88U
* device instance $1068 m0 *1 611.96,802.38 nfet_05v0
M$1068 VSS \$I2214 \$I2244 VSS nfet_05v0 L=0.6U W=0.36U AS=0.0936P AD=0.1584P
+ PS=0.88U PD=1.6U
* device instance $1069 m0 *1 587.37,800.07 pfet_05v0
M$1069 \$I2956 \$I2274 VDD_DEC VDD_DEC pfet_05v0 L=0.5U W=1.22U AS=0.5368P
+ AD=0.3172P PS=3.32U PD=1.74U
* device instance $1070 m0 *1 588.39,800.07 pfet_05v0
M$1070 \$I2955 \$I2173 \$I2956 VDD_DEC pfet_05v0 L=0.5U W=1.22U AS=0.3172P
+ AD=0.3782P PS=1.74U PD=1.84U
* device instance $1071 m0 *1 589.51,800.07 pfet_05v0
M$1071 \$I2954 \$I2211 \$I2955 VDD_DEC pfet_05v0 L=0.5U W=1.22U AS=0.3782P
+ AD=0.3782P PS=1.84U PD=1.84U
* device instance $1072 m0 *1 590.63,800.07 pfet_05v0
M$1072 \$I2253 \$I2172 \$I2954 VDD_DEC pfet_05v0 L=0.5U W=1.22U AS=0.3782P
+ AD=0.5368P PS=1.84U PD=3.32U
* device instance $1073 m0 *1 587.32,802.38 nfet_05v0
M$1073 \$I2253 \$I2274 VSS VSS nfet_05v0 L=0.6U W=0.36U AS=0.1584P AD=0.0936P
+ PS=1.6U PD=0.88U
* device instance $1074 m0 *1 588.44,802.38 nfet_05v0
M$1074 VSS \$I2173 \$I2253 VSS nfet_05v0 L=0.6U W=0.36U AS=0.0936P AD=0.0936P
+ PS=0.88U PD=0.88U
* device instance $1075 m0 *1 589.56,802.38 nfet_05v0
M$1075 \$I2253 \$I2211 VSS VSS nfet_05v0 L=0.6U W=0.36U AS=0.0936P AD=0.0936P
+ PS=0.88U PD=0.88U
* device instance $1076 m0 *1 590.68,802.38 nfet_05v0
M$1076 VSS \$I2172 \$I2253 VSS nfet_05v0 L=0.6U W=0.36U AS=0.0936P AD=0.1584P
+ PS=0.88U PD=1.6U
* device instance $1077 m0 *1 664.65,784.39 pfet_05v0
M$1077 \$I2959 \$I2238 VDD_DEC VDD_DEC pfet_05v0 L=0.5U W=1.22U AS=0.5368P
+ AD=0.3172P PS=3.32U PD=1.74U
* device instance $1078 m0 *1 665.67,784.39 pfet_05v0
M$1078 \$I2958 \$I2140 \$I2959 VDD_DEC pfet_05v0 L=0.5U W=1.22U AS=0.3172P
+ AD=0.3782P PS=1.74U PD=1.84U
* device instance $1079 m0 *1 666.79,784.39 pfet_05v0
M$1079 \$I2957 \$I2287 \$I2958 VDD_DEC pfet_05v0 L=0.5U W=1.22U AS=0.3782P
+ AD=0.3782P PS=1.84U PD=1.84U
* device instance $1080 m0 *1 667.91,784.39 pfet_05v0
M$1080 \$I2082 \$I2138 \$I2957 VDD_DEC pfet_05v0 L=0.5U W=1.22U AS=0.3782P
+ AD=0.5368P PS=1.84U PD=3.32U
* device instance $1081 m0 *1 664.6,786.7 nfet_05v0
M$1081 \$I2082 \$I2238 VSS VSS nfet_05v0 L=0.6U W=0.36U AS=0.1584P AD=0.0936P
+ PS=1.6U PD=0.88U
* device instance $1082 m0 *1 665.72,786.7 nfet_05v0
M$1082 VSS \$I2140 \$I2082 VSS nfet_05v0 L=0.6U W=0.36U AS=0.0936P AD=0.0936P
+ PS=0.88U PD=0.88U
* device instance $1083 m0 *1 666.84,786.7 nfet_05v0
M$1083 \$I2082 \$I2287 VSS VSS nfet_05v0 L=0.6U W=0.36U AS=0.0936P AD=0.0936P
+ PS=0.88U PD=0.88U
* device instance $1084 m0 *1 667.96,786.7 nfet_05v0
M$1084 VSS \$I2138 \$I2082 VSS nfet_05v0 L=0.6U W=0.36U AS=0.0936P AD=0.1584P
+ PS=0.88U PD=1.6U
* device instance $1085 m0 *1 575.05,807.91 pfet_05v0
M$1085 \$I2962 \$I2238 VDD_DEC VDD_DEC pfet_05v0 L=0.5U W=1.22U AS=0.5368P
+ AD=0.3172P PS=3.32U PD=1.74U
* device instance $1086 m0 *1 576.07,807.91 pfet_05v0
M$1086 \$I2961 \$I2207 \$I2962 VDD_DEC pfet_05v0 L=0.5U W=1.22U AS=0.3172P
+ AD=0.3782P PS=1.74U PD=1.84U
* device instance $1087 m0 *1 577.19,807.91 pfet_05v0
M$1087 \$I2960 \$I2208 \$I2961 VDD_DEC pfet_05v0 L=0.5U W=1.22U AS=0.3782P
+ AD=0.3782P PS=1.84U PD=1.84U
* device instance $1088 m0 *1 578.31,807.91 pfet_05v0
M$1088 \$I2171 \$I2237 \$I2960 VDD_DEC pfet_05v0 L=0.5U W=1.22U AS=0.3782P
+ AD=0.5368P PS=1.84U PD=3.32U
* device instance $1089 m0 *1 575,810.22 nfet_05v0
M$1089 \$I2171 \$I2238 VSS VSS nfet_05v0 L=0.6U W=0.36U AS=0.1584P AD=0.0936P
+ PS=1.6U PD=0.88U
* device instance $1090 m0 *1 576.12,810.22 nfet_05v0
M$1090 VSS \$I2207 \$I2171 VSS nfet_05v0 L=0.6U W=0.36U AS=0.0936P AD=0.0936P
+ PS=0.88U PD=0.88U
* device instance $1091 m0 *1 577.24,810.22 nfet_05v0
M$1091 \$I2171 \$I2208 VSS VSS nfet_05v0 L=0.6U W=0.36U AS=0.0936P AD=0.0936P
+ PS=0.88U PD=0.88U
* device instance $1092 m0 *1 578.36,810.22 nfet_05v0
M$1092 VSS \$I2237 \$I2171 VSS nfet_05v0 L=0.6U W=0.36U AS=0.0936P AD=0.1584P
+ PS=0.88U PD=1.6U
* device instance $1093 m0 *1 623.21,823.59 pfet_05v0
M$1093 \$I2965 \$I2166 VDD_DEC VDD_DEC pfet_05v0 L=0.5U W=1.22U AS=0.5368P
+ AD=0.3172P PS=3.32U PD=1.74U
* device instance $1094 m0 *1 624.23,823.59 pfet_05v0
M$1094 \$I2964 \$I2140 \$I2965 VDD_DEC pfet_05v0 L=0.5U W=1.22U AS=0.3172P
+ AD=0.3782P PS=1.74U PD=1.84U
* device instance $1095 m0 *1 625.35,823.59 pfet_05v0
M$1095 \$I2963 \$I2287 \$I2964 VDD_DEC pfet_05v0 L=0.5U W=1.22U AS=0.3782P
+ AD=0.3782P PS=1.84U PD=1.84U
* device instance $1096 m0 *1 626.47,823.59 pfet_05v0
M$1096 \$I2030 \$I2138 \$I2963 VDD_DEC pfet_05v0 L=0.5U W=1.22U AS=0.3782P
+ AD=0.5368P PS=1.84U PD=3.32U
* device instance $1097 m0 *1 623.16,825.9 nfet_05v0
M$1097 \$I2030 \$I2166 VSS VSS nfet_05v0 L=0.6U W=0.36U AS=0.1584P AD=0.0936P
+ PS=1.6U PD=0.88U
* device instance $1098 m0 *1 624.28,825.9 nfet_05v0
M$1098 VSS \$I2140 \$I2030 VSS nfet_05v0 L=0.6U W=0.36U AS=0.0936P AD=0.0936P
+ PS=0.88U PD=0.88U
* device instance $1099 m0 *1 625.4,825.9 nfet_05v0
M$1099 \$I2030 \$I2287 VSS VSS nfet_05v0 L=0.6U W=0.36U AS=0.0936P AD=0.0936P
+ PS=0.88U PD=0.88U
* device instance $1100 m0 *1 626.52,825.9 nfet_05v0
M$1100 VSS \$I2138 \$I2030 VSS nfet_05v0 L=0.6U W=0.36U AS=0.0936P AD=0.1584P
+ PS=0.88U PD=1.6U
* device instance $1101 m0 *1 580.65,807.91 pfet_05v0
M$1101 \$I2968 \$I2360 VDD_DEC VDD_DEC pfet_05v0 L=0.5U W=1.22U AS=0.5368P
+ AD=0.3172P PS=3.32U PD=1.74U
* device instance $1102 m0 *1 581.67,807.91 pfet_05v0
M$1102 \$I2967 \$I2173 \$I2968 VDD_DEC pfet_05v0 L=0.5U W=1.22U AS=0.3172P
+ AD=0.3782P PS=1.74U PD=1.84U
* device instance $1103 m0 *1 582.79,807.91 pfet_05v0
M$1103 \$I2966 \$I2211 \$I2967 VDD_DEC pfet_05v0 L=0.5U W=1.22U AS=0.3782P
+ AD=0.3782P PS=1.84U PD=1.84U
* device instance $1104 m0 *1 583.91,807.91 pfet_05v0
M$1104 \$I2067 \$I2172 \$I2966 VDD_DEC pfet_05v0 L=0.5U W=1.22U AS=0.3782P
+ AD=0.5368P PS=1.84U PD=3.32U
* device instance $1105 m0 *1 580.6,810.22 nfet_05v0
M$1105 \$I2067 \$I2360 VSS VSS nfet_05v0 L=0.6U W=0.36U AS=0.1584P AD=0.0936P
+ PS=1.6U PD=0.88U
* device instance $1106 m0 *1 581.72,810.22 nfet_05v0
M$1106 VSS \$I2173 \$I2067 VSS nfet_05v0 L=0.6U W=0.36U AS=0.0936P AD=0.0936P
+ PS=0.88U PD=0.88U
* device instance $1107 m0 *1 582.84,810.22 nfet_05v0
M$1107 \$I2067 \$I2211 VSS VSS nfet_05v0 L=0.6U W=0.36U AS=0.0936P AD=0.0936P
+ PS=0.88U PD=0.88U
* device instance $1108 m0 *1 583.96,810.22 nfet_05v0
M$1108 VSS \$I2172 \$I2067 VSS nfet_05v0 L=0.6U W=0.36U AS=0.0936P AD=0.1584P
+ PS=0.88U PD=1.6U
* device instance $1109 m0 *1 614.25,800.07 pfet_05v0
M$1109 \$I2971 \$I2199 VDD_DEC VDD_DEC pfet_05v0 L=0.5U W=1.22U AS=0.5368P
+ AD=0.3172P PS=3.32U PD=1.74U
* device instance $1110 m0 *1 615.27,800.07 pfet_05v0
M$1110 \$I2970 \$I2286 \$I2971 VDD_DEC pfet_05v0 L=0.5U W=1.22U AS=0.3172P
+ AD=0.3782P PS=1.74U PD=1.84U
* device instance $1111 m0 *1 616.39,800.07 pfet_05v0
M$1111 \$I2969 \$I2287 \$I2970 VDD_DEC pfet_05v0 L=0.5U W=1.22U AS=0.3782P
+ AD=0.3782P PS=1.84U PD=1.84U
* device instance $1112 m0 *1 617.51,800.07 pfet_05v0
M$1112 \$I2075 \$I2214 \$I2969 VDD_DEC pfet_05v0 L=0.5U W=1.22U AS=0.3782P
+ AD=0.5368P PS=1.84U PD=3.32U
* device instance $1113 m0 *1 614.2,802.38 nfet_05v0
M$1113 \$I2075 \$I2199 VSS VSS nfet_05v0 L=0.6U W=0.36U AS=0.1584P AD=0.0936P
+ PS=1.6U PD=0.88U
* device instance $1114 m0 *1 615.32,802.38 nfet_05v0
M$1114 VSS \$I2286 \$I2075 VSS nfet_05v0 L=0.6U W=0.36U AS=0.0936P AD=0.0936P
+ PS=0.88U PD=0.88U
* device instance $1115 m0 *1 616.44,802.38 nfet_05v0
M$1115 \$I2075 \$I2287 VSS VSS nfet_05v0 L=0.6U W=0.36U AS=0.0936P AD=0.0936P
+ PS=0.88U PD=0.88U
* device instance $1116 m0 *1 617.56,802.38 nfet_05v0
M$1116 VSS \$I2214 \$I2075 VSS nfet_05v0 L=0.6U W=0.36U AS=0.0936P AD=0.1584P
+ PS=0.88U PD=1.6U
* device instance $1117 r180 *1 554.63,831.43 pfet_05v0
M$1117 \$I2974 \$I2274 VDD_DEC VDD_DEC pfet_05v0 L=0.5U W=1.22U AS=0.5368P
+ AD=0.3172P PS=3.32U PD=1.74U
* device instance $1118 r180 *1 553.61,831.43 pfet_05v0
M$1118 \$I2973 \$I2418 \$I2974 VDD_DEC pfet_05v0 L=0.5U W=1.22U AS=0.3172P
+ AD=0.3782P PS=1.74U PD=1.84U
* device instance $1119 r180 *1 552.49,831.43 pfet_05v0
M$1119 \$I2972 \$I2333 \$I2973 VDD_DEC pfet_05v0 L=0.5U W=1.22U AS=0.3782P
+ AD=0.3782P PS=1.84U PD=1.84U
* device instance $1120 r180 *1 551.37,831.43 pfet_05v0
M$1120 \$I2206 \$I2359 \$I2972 VDD_DEC pfet_05v0 L=0.5U W=1.22U AS=0.3782P
+ AD=0.5368P PS=1.84U PD=3.32U
* device instance $1121 r180 *1 554.68,833.74 nfet_05v0
M$1121 \$I2206 \$I2274 VSS VSS nfet_05v0 L=0.6U W=0.36U AS=0.1584P AD=0.0936P
+ PS=1.6U PD=0.88U
* device instance $1122 r180 *1 553.56,833.74 nfet_05v0
M$1122 VSS \$I2418 \$I2206 VSS nfet_05v0 L=0.6U W=0.36U AS=0.0936P AD=0.0936P
+ PS=0.88U PD=0.88U
* device instance $1123 r180 *1 552.44,833.74 nfet_05v0
M$1123 \$I2206 \$I2333 VSS VSS nfet_05v0 L=0.6U W=0.36U AS=0.0936P AD=0.0936P
+ PS=0.88U PD=0.88U
* device instance $1124 r180 *1 551.32,833.74 nfet_05v0
M$1124 VSS \$I2359 \$I2206 VSS nfet_05v0 L=0.6U W=0.36U AS=0.0936P AD=0.1584P
+ PS=0.88U PD=1.6U
* device instance $1125 r180 *1 542.87,823.59 pfet_05v0
M$1125 \$I2977 \$I2209 VDD_DEC VDD_DEC pfet_05v0 L=0.5U W=1.22U AS=0.5368P
+ AD=0.3172P PS=3.32U PD=1.74U
* device instance $1126 r180 *1 541.85,823.59 pfet_05v0
M$1126 \$I2976 \$I2418 \$I2977 VDD_DEC pfet_05v0 L=0.5U W=1.22U AS=0.3172P
+ AD=0.3782P PS=1.74U PD=1.84U
* device instance $1127 r180 *1 540.73,823.59 pfet_05v0
M$1127 \$I2975 \$I2333 \$I2976 VDD_DEC pfet_05v0 L=0.5U W=1.22U AS=0.3782P
+ AD=0.3782P PS=1.84U PD=1.84U
* device instance $1128 r180 *1 539.61,823.59 pfet_05v0
M$1128 \$I2022 \$I2359 \$I2975 VDD_DEC pfet_05v0 L=0.5U W=1.22U AS=0.3782P
+ AD=0.5368P PS=1.84U PD=3.32U
* device instance $1129 r180 *1 542.92,825.9 nfet_05v0
M$1129 \$I2022 \$I2209 VSS VSS nfet_05v0 L=0.6U W=0.36U AS=0.1584P AD=0.0936P
+ PS=1.6U PD=0.88U
* device instance $1130 r180 *1 541.8,825.9 nfet_05v0
M$1130 VSS \$I2418 \$I2022 VSS nfet_05v0 L=0.6U W=0.36U AS=0.0936P AD=0.0936P
+ PS=0.88U PD=0.88U
* device instance $1131 r180 *1 540.68,825.9 nfet_05v0
M$1131 \$I2022 \$I2333 VSS VSS nfet_05v0 L=0.6U W=0.36U AS=0.0936P AD=0.0936P
+ PS=0.88U PD=0.88U
* device instance $1132 r180 *1 539.56,825.9 nfet_05v0
M$1132 VSS \$I2359 \$I2022 VSS nfet_05v0 L=0.6U W=0.36U AS=0.0936P AD=0.1584P
+ PS=0.88U PD=1.6U
* device instance $1133 r180 *1 495.83,800.07 pfet_05v0
M$1133 \$I2980 \$I2330 VDD_DEC VDD_DEC pfet_05v0 L=0.5U W=1.22U AS=0.5368P
+ AD=0.3172P PS=3.32U PD=1.74U
* device instance $1134 r180 *1 494.81,800.07 pfet_05v0
M$1134 \$I2979 \$I2197 \$I2980 VDD_DEC pfet_05v0 L=0.5U W=1.22U AS=0.3172P
+ AD=0.3782P PS=1.74U PD=1.84U
* device instance $1135 r180 *1 493.69,800.07 pfet_05v0
M$1135 \$I2978 \$I2249 \$I2979 VDD_DEC pfet_05v0 L=0.5U W=1.22U AS=0.3782P
+ AD=0.3782P PS=1.84U PD=1.84U
* device instance $1136 r180 *1 492.57,800.07 pfet_05v0
M$1136 \$I2052 \$I2196 \$I2978 VDD_DEC pfet_05v0 L=0.5U W=1.22U AS=0.3782P
+ AD=0.5368P PS=1.84U PD=3.32U
* device instance $1137 r180 *1 495.88,802.38 nfet_05v0
M$1137 \$I2052 \$I2330 VSS VSS nfet_05v0 L=0.6U W=0.36U AS=0.1584P AD=0.0936P
+ PS=1.6U PD=0.88U
* device instance $1138 r180 *1 494.76,802.38 nfet_05v0
M$1138 VSS \$I2197 \$I2052 VSS nfet_05v0 L=0.6U W=0.36U AS=0.0936P AD=0.0936P
+ PS=0.88U PD=0.88U
* device instance $1139 r180 *1 493.64,802.38 nfet_05v0
M$1139 \$I2052 \$I2249 VSS VSS nfet_05v0 L=0.6U W=0.36U AS=0.0936P AD=0.0936P
+ PS=0.88U PD=0.88U
* device instance $1140 r180 *1 492.52,802.38 nfet_05v0
M$1140 VSS \$I2196 \$I2052 VSS nfet_05v0 L=0.6U W=0.36U AS=0.0936P AD=0.1584P
+ PS=0.88U PD=1.6U
* device instance $1141 r180 *1 496.39,792.23 pfet_05v0
M$1141 \$I2983 \$I2199 VDD_DEC VDD_DEC pfet_05v0 L=0.5U W=1.22U AS=0.5368P
+ AD=0.3172P PS=3.32U PD=1.74U
* device instance $1142 r180 *1 495.37,792.23 pfet_05v0
M$1142 \$I2982 \$I2197 \$I2983 VDD_DEC pfet_05v0 L=0.5U W=1.22U AS=0.3172P
+ AD=0.3782P PS=1.74U PD=1.84U
* device instance $1143 r180 *1 494.25,792.23 pfet_05v0
M$1143 \$I2981 \$I2249 \$I2982 VDD_DEC pfet_05v0 L=0.5U W=1.22U AS=0.3782P
+ AD=0.3782P PS=1.84U PD=1.84U
* device instance $1144 r180 *1 493.13,792.23 pfet_05v0
M$1144 \$I2159 \$I2196 \$I2981 VDD_DEC pfet_05v0 L=0.5U W=1.22U AS=0.3782P
+ AD=0.5368P PS=1.84U PD=3.32U
* device instance $1145 r180 *1 496.44,794.54 nfet_05v0
M$1145 \$I2159 \$I2199 VSS VSS nfet_05v0 L=0.6U W=0.36U AS=0.1584P AD=0.0936P
+ PS=1.6U PD=0.88U
* device instance $1146 r180 *1 495.32,794.54 nfet_05v0
M$1146 VSS \$I2197 \$I2159 VSS nfet_05v0 L=0.6U W=0.36U AS=0.0936P AD=0.0936P
+ PS=0.88U PD=0.88U
* device instance $1147 r180 *1 494.2,794.54 nfet_05v0
M$1147 \$I2159 \$I2249 VSS VSS nfet_05v0 L=0.6U W=0.36U AS=0.0936P AD=0.0936P
+ PS=0.88U PD=0.88U
* device instance $1148 r180 *1 493.08,794.54 nfet_05v0
M$1148 VSS \$I2196 \$I2159 VSS nfet_05v0 L=0.6U W=0.36U AS=0.0936P AD=0.1584P
+ PS=0.88U PD=1.6U
* device instance $1149 r180 *1 573.67,792.23 pfet_05v0
M$1149 \$I2986 \$I2205 VDD_DEC VDD_DEC pfet_05v0 L=0.5U W=1.22U AS=0.5368P
+ AD=0.3172P PS=3.32U PD=1.74U
* device instance $1150 r180 *1 572.65,792.23 pfet_05v0
M$1150 \$I2985 \$I2207 \$I2986 VDD_DEC pfet_05v0 L=0.5U W=1.22U AS=0.3172P
+ AD=0.3782P PS=1.74U PD=1.84U
* device instance $1151 r180 *1 571.53,792.23 pfet_05v0
M$1151 \$I2984 \$I2208 \$I2985 VDD_DEC pfet_05v0 L=0.5U W=1.22U AS=0.3782P
+ AD=0.3782P PS=1.84U PD=1.84U
* device instance $1152 r180 *1 570.41,792.23 pfet_05v0
M$1152 \$I2132 \$I2280 \$I2984 VDD_DEC pfet_05v0 L=0.5U W=1.22U AS=0.3782P
+ AD=0.5368P PS=1.84U PD=3.32U
* device instance $1153 r180 *1 573.72,794.54 nfet_05v0
M$1153 \$I2132 \$I2205 VSS VSS nfet_05v0 L=0.6U W=0.36U AS=0.1584P AD=0.0936P
+ PS=1.6U PD=0.88U
* device instance $1154 r180 *1 572.6,794.54 nfet_05v0
M$1154 VSS \$I2207 \$I2132 VSS nfet_05v0 L=0.6U W=0.36U AS=0.0936P AD=0.0936P
+ PS=0.88U PD=0.88U
* device instance $1155 r180 *1 571.48,794.54 nfet_05v0
M$1155 \$I2132 \$I2208 VSS VSS nfet_05v0 L=0.6U W=0.36U AS=0.0936P AD=0.0936P
+ PS=0.88U PD=0.88U
* device instance $1156 r180 *1 570.36,794.54 nfet_05v0
M$1156 VSS \$I2280 \$I2132 VSS nfet_05v0 L=0.6U W=0.36U AS=0.0936P AD=0.1584P
+ PS=0.88U PD=1.6U
* device instance $1157 r180 *1 546.23,792.23 pfet_05v0
M$1157 \$I2989 \$I2205 VDD_DEC VDD_DEC pfet_05v0 L=0.5U W=1.22U AS=0.5368P
+ AD=0.3172P PS=3.32U PD=1.74U
* device instance $1158 r180 *1 545.21,792.23 pfet_05v0
M$1158 \$I2988 \$I2203 \$I2989 VDD_DEC pfet_05v0 L=0.5U W=1.22U AS=0.3172P
+ AD=0.3782P PS=1.74U PD=1.84U
* device instance $1159 r180 *1 544.09,792.23 pfet_05v0
M$1159 \$I2987 \$I2333 \$I2988 VDD_DEC pfet_05v0 L=0.5U W=1.22U AS=0.3782P
+ AD=0.3782P PS=1.84U PD=1.84U
* device instance $1160 r180 *1 542.97,792.23 pfet_05v0
M$1160 \$I2060 \$I2204 \$I2987 VDD_DEC pfet_05v0 L=0.5U W=1.22U AS=0.3782P
+ AD=0.5368P PS=1.84U PD=3.32U
* device instance $1161 r180 *1 546.28,794.54 nfet_05v0
M$1161 \$I2060 \$I2205 VSS VSS nfet_05v0 L=0.6U W=0.36U AS=0.1584P AD=0.0936P
+ PS=1.6U PD=0.88U
* device instance $1162 r180 *1 545.16,794.54 nfet_05v0
M$1162 VSS \$I2203 \$I2060 VSS nfet_05v0 L=0.6U W=0.36U AS=0.0936P AD=0.0936P
+ PS=0.88U PD=0.88U
* device instance $1163 r180 *1 544.04,794.54 nfet_05v0
M$1163 \$I2060 \$I2333 VSS VSS nfet_05v0 L=0.6U W=0.36U AS=0.0936P AD=0.0936P
+ PS=0.88U PD=0.88U
* device instance $1164 r180 *1 542.92,794.54 nfet_05v0
M$1164 VSS \$I2204 \$I2060 VSS nfet_05v0 L=0.6U W=0.36U AS=0.0936P AD=0.1584P
+ PS=0.88U PD=1.6U
* device instance $1165 r180 *1 546.23,815.75 pfet_05v0
M$1165 \$I2992 \$I2199 VDD_DEC VDD_DEC pfet_05v0 L=0.5U W=1.22U AS=0.5368P
+ AD=0.3172P PS=3.32U PD=1.74U
* device instance $1166 r180 *1 545.21,815.75 pfet_05v0
M$1166 \$I2991 \$I2203 \$I2992 VDD_DEC pfet_05v0 L=0.5U W=1.22U AS=0.3172P
+ AD=0.3782P PS=1.74U PD=1.84U
* device instance $1167 r180 *1 544.09,815.75 pfet_05v0
M$1167 \$I2990 \$I2383 \$I2991 VDD_DEC pfet_05v0 L=0.5U W=1.22U AS=0.3782P
+ AD=0.3782P PS=1.84U PD=1.84U
* device instance $1168 r180 *1 542.97,815.75 pfet_05v0
M$1168 \$I2236 \$I2280 \$I2990 VDD_DEC pfet_05v0 L=0.5U W=1.22U AS=0.3782P
+ AD=0.5368P PS=1.84U PD=3.32U
* device instance $1169 r180 *1 546.28,818.06 nfet_05v0
M$1169 \$I2236 \$I2199 VSS VSS nfet_05v0 L=0.6U W=0.36U AS=0.1584P AD=0.0936P
+ PS=1.6U PD=0.88U
* device instance $1170 r180 *1 545.16,818.06 nfet_05v0
M$1170 VSS \$I2203 \$I2236 VSS nfet_05v0 L=0.6U W=0.36U AS=0.0936P AD=0.0936P
+ PS=0.88U PD=0.88U
* device instance $1171 r180 *1 544.04,818.06 nfet_05v0
M$1171 \$I2236 \$I2383 VSS VSS nfet_05v0 L=0.6U W=0.36U AS=0.0936P AD=0.0936P
+ PS=0.88U PD=0.88U
* device instance $1172 r180 *1 542.92,818.06 nfet_05v0
M$1172 VSS \$I2280 \$I2236 VSS nfet_05v0 L=0.6U W=0.36U AS=0.0936P AD=0.1584P
+ PS=0.88U PD=1.6U
* device instance $1173 r180 *1 588.23,792.23 pfet_05v0
M$1173 \$I2995 \$I2209 VDD_DEC VDD_DEC pfet_05v0 L=0.5U W=1.22U AS=0.5368P
+ AD=0.3172P PS=3.32U PD=1.74U
* device instance $1174 r180 *1 587.21,792.23 pfet_05v0
M$1174 \$I2994 \$I2173 \$I2995 VDD_DEC pfet_05v0 L=0.5U W=1.22U AS=0.3172P
+ AD=0.3782P PS=1.74U PD=1.84U
* device instance $1175 r180 *1 586.09,792.23 pfet_05v0
M$1175 \$I2993 \$I2211 \$I2994 VDD_DEC pfet_05v0 L=0.5U W=1.22U AS=0.3782P
+ AD=0.3782P PS=1.84U PD=1.84U
* device instance $1176 r180 *1 584.97,792.23 pfet_05v0
M$1176 \$I2028 \$I2172 \$I2993 VDD_DEC pfet_05v0 L=0.5U W=1.22U AS=0.3782P
+ AD=0.5368P PS=1.84U PD=3.32U
* device instance $1177 r180 *1 588.28,794.54 nfet_05v0
M$1177 \$I2028 \$I2209 VSS VSS nfet_05v0 L=0.6U W=0.36U AS=0.1584P AD=0.0936P
+ PS=1.6U PD=0.88U
* device instance $1178 r180 *1 587.16,794.54 nfet_05v0
M$1178 VSS \$I2173 \$I2028 VSS nfet_05v0 L=0.6U W=0.36U AS=0.0936P AD=0.0936P
+ PS=0.88U PD=0.88U
* device instance $1179 r180 *1 586.04,794.54 nfet_05v0
M$1179 \$I2028 \$I2211 VSS VSS nfet_05v0 L=0.6U W=0.36U AS=0.0936P AD=0.0936P
+ PS=0.88U PD=0.88U
* device instance $1180 r180 *1 584.92,794.54 nfet_05v0
M$1180 VSS \$I2172 \$I2028 VSS nfet_05v0 L=0.6U W=0.36U AS=0.0936P AD=0.1584P
+ PS=0.88U PD=1.6U
* device instance $1181 r180 *1 524.95,807.91 pfet_05v0
M$1181 \$I2998 \$I2305 VDD_DEC VDD_DEC pfet_05v0 L=0.5U W=1.22U AS=0.5368P
+ AD=0.3172P PS=3.32U PD=1.74U
* device instance $1182 r180 *1 523.93,807.91 pfet_05v0
M$1182 \$I2997 \$I2332 \$I2998 VDD_DEC pfet_05v0 L=0.5U W=1.22U AS=0.3172P
+ AD=0.3782P PS=1.74U PD=1.84U
* device instance $1183 r180 *1 522.81,807.91 pfet_05v0
M$1183 \$I2996 \$I2250 \$I2997 VDD_DEC pfet_05v0 L=0.5U W=1.22U AS=0.3782P
+ AD=0.3782P PS=1.84U PD=1.84U
* device instance $1184 r180 *1 521.69,807.91 pfet_05v0
M$1184 \$I2126 \$I2331 \$I2996 VDD_DEC pfet_05v0 L=0.5U W=1.22U AS=0.3782P
+ AD=0.5368P PS=1.84U PD=3.32U
* device instance $1185 r180 *1 525,810.22 nfet_05v0
M$1185 \$I2126 \$I2305 VSS VSS nfet_05v0 L=0.6U W=0.36U AS=0.1584P AD=0.0936P
+ PS=1.6U PD=0.88U
* device instance $1186 r180 *1 523.88,810.22 nfet_05v0
M$1186 VSS \$I2332 \$I2126 VSS nfet_05v0 L=0.6U W=0.36U AS=0.0936P AD=0.0936P
+ PS=0.88U PD=0.88U
* device instance $1187 r180 *1 522.76,810.22 nfet_05v0
M$1187 \$I2126 \$I2250 VSS VSS nfet_05v0 L=0.6U W=0.36U AS=0.0936P AD=0.0936P
+ PS=0.88U PD=0.88U
* device instance $1188 r180 *1 521.64,810.22 nfet_05v0
M$1188 VSS \$I2331 \$I2126 VSS nfet_05v0 L=0.6U W=0.36U AS=0.0936P AD=0.1584P
+ PS=0.88U PD=1.6U
* device instance $1189 r180 *1 519.35,807.91 pfet_05v0
M$1189 \$I3001 \$I2274 VDD_DEC VDD_DEC pfet_05v0 L=0.5U W=1.22U AS=0.5368P
+ AD=0.3172P PS=3.32U PD=1.74U
* device instance $1190 r180 *1 518.33,807.91 pfet_05v0
M$1190 \$I3000 \$I2332 \$I3001 VDD_DEC pfet_05v0 L=0.5U W=1.22U AS=0.3172P
+ AD=0.3782P PS=1.74U PD=1.84U
* device instance $1191 r180 *1 517.21,807.91 pfet_05v0
M$1191 \$I2999 \$I2250 \$I3000 VDD_DEC pfet_05v0 L=0.5U W=1.22U AS=0.3782P
+ AD=0.3782P PS=1.84U PD=1.84U
* device instance $1192 r180 *1 516.09,807.91 pfet_05v0
M$1192 \$I2162 \$I2331 \$I2999 VDD_DEC pfet_05v0 L=0.5U W=1.22U AS=0.3782P
+ AD=0.5368P PS=1.84U PD=3.32U
* device instance $1193 r180 *1 519.4,810.22 nfet_05v0
M$1193 \$I2162 \$I2274 VSS VSS nfet_05v0 L=0.6U W=0.36U AS=0.1584P AD=0.0936P
+ PS=1.6U PD=0.88U
* device instance $1194 r180 *1 518.28,810.22 nfet_05v0
M$1194 VSS \$I2332 \$I2162 VSS nfet_05v0 L=0.6U W=0.36U AS=0.0936P AD=0.0936P
+ PS=0.88U PD=0.88U
* device instance $1195 r180 *1 517.16,810.22 nfet_05v0
M$1195 \$I2162 \$I2250 VSS VSS nfet_05v0 L=0.6U W=0.36U AS=0.0936P AD=0.0936P
+ PS=0.88U PD=0.88U
* device instance $1196 r180 *1 516.04,810.22 nfet_05v0
M$1196 VSS \$I2331 \$I2162 VSS nfet_05v0 L=0.6U W=0.36U AS=0.0936P AD=0.1584P
+ PS=0.88U PD=1.6U
* device instance $1197 r180 *1 501.43,807.91 pfet_05v0
M$1197 \$I3004 \$I2362 VDD_DEC VDD_DEC pfet_05v0 L=0.5U W=1.22U AS=0.5368P
+ AD=0.3172P PS=3.32U PD=1.74U
* device instance $1198 r180 *1 500.41,807.91 pfet_05v0
M$1198 \$I3003 \$I2197 \$I3004 VDD_DEC pfet_05v0 L=0.5U W=1.22U AS=0.3172P
+ AD=0.3782P PS=1.74U PD=1.84U
* device instance $1199 r180 *1 499.29,807.91 pfet_05v0
M$1199 \$I3002 \$I2249 \$I3003 VDD_DEC pfet_05v0 L=0.5U W=1.22U AS=0.3782P
+ AD=0.3782P PS=1.84U PD=1.84U
* device instance $1200 r180 *1 498.17,807.91 pfet_05v0
M$1200 \$I2248 \$I2196 \$I3002 VDD_DEC pfet_05v0 L=0.5U W=1.22U AS=0.3782P
+ AD=0.5368P PS=1.84U PD=3.32U
* device instance $1201 r180 *1 501.48,810.22 nfet_05v0
M$1201 \$I2248 \$I2362 VSS VSS nfet_05v0 L=0.6U W=0.36U AS=0.1584P AD=0.0936P
+ PS=1.6U PD=0.88U
* device instance $1202 r180 *1 500.36,810.22 nfet_05v0
M$1202 VSS \$I2197 \$I2248 VSS nfet_05v0 L=0.6U W=0.36U AS=0.0936P AD=0.0936P
+ PS=0.88U PD=0.88U
* device instance $1203 r180 *1 499.24,810.22 nfet_05v0
M$1203 \$I2248 \$I2249 VSS VSS nfet_05v0 L=0.6U W=0.36U AS=0.0936P AD=0.0936P
+ PS=0.88U PD=0.88U
* device instance $1204 r180 *1 498.12,810.22 nfet_05v0
M$1204 VSS \$I2196 \$I2248 VSS nfet_05v0 L=0.6U W=0.36U AS=0.0936P AD=0.1584P
+ PS=0.88U PD=1.6U
* device instance $1205 r180 *1 524.95,815.75 pfet_05v0
M$1205 \$I3007 \$I2357 VDD_DEC VDD_DEC pfet_05v0 L=0.5U W=1.22U AS=0.5368P
+ AD=0.3172P PS=3.32U PD=1.74U
* device instance $1206 r180 *1 523.93,815.75 pfet_05v0
M$1206 \$I3006 \$I2332 \$I3007 VDD_DEC pfet_05v0 L=0.5U W=1.22U AS=0.3172P
+ AD=0.3782P PS=1.74U PD=1.84U
* device instance $1207 r180 *1 522.81,815.75 pfet_05v0
M$1207 \$I3005 \$I2249 \$I3006 VDD_DEC pfet_05v0 L=0.5U W=1.22U AS=0.3782P
+ AD=0.3782P PS=1.84U PD=1.84U
* device instance $1208 r180 *1 521.69,815.75 pfet_05v0
M$1208 \$I2233 \$I2331 \$I3005 VDD_DEC pfet_05v0 L=0.5U W=1.22U AS=0.3782P
+ AD=0.5368P PS=1.84U PD=3.32U
* device instance $1209 r180 *1 525,818.06 nfet_05v0
M$1209 \$I2233 \$I2357 VSS VSS nfet_05v0 L=0.6U W=0.36U AS=0.1584P AD=0.0936P
+ PS=1.6U PD=0.88U
* device instance $1210 r180 *1 523.88,818.06 nfet_05v0
M$1210 VSS \$I2332 \$I2233 VSS nfet_05v0 L=0.6U W=0.36U AS=0.0936P AD=0.0936P
+ PS=0.88U PD=0.88U
* device instance $1211 r180 *1 522.76,818.06 nfet_05v0
M$1211 \$I2233 \$I2249 VSS VSS nfet_05v0 L=0.6U W=0.36U AS=0.0936P AD=0.0936P
+ PS=0.88U PD=0.88U
* device instance $1212 r180 *1 521.64,818.06 nfet_05v0
M$1212 VSS \$I2331 \$I2233 VSS nfet_05v0 L=0.6U W=0.36U AS=0.0936P AD=0.1584P
+ PS=0.88U PD=1.6U
* device instance $1213 r180 *1 560.23,823.59 pfet_05v0
M$1213 \$I3010 \$I2238 VDD_DEC VDD_DEC pfet_05v0 L=0.5U W=1.22U AS=0.5368P
+ AD=0.3172P PS=3.32U PD=1.74U
* device instance $1214 r180 *1 559.21,823.59 pfet_05v0
M$1214 \$I3009 \$I2418 \$I3010 VDD_DEC pfet_05v0 L=0.5U W=1.22U AS=0.3172P
+ AD=0.3782P PS=1.74U PD=1.84U
* device instance $1215 r180 *1 558.09,823.59 pfet_05v0
M$1215 \$I3008 \$I2333 \$I3009 VDD_DEC pfet_05v0 L=0.5U W=1.22U AS=0.3782P
+ AD=0.3782P PS=1.84U PD=1.84U
* device instance $1216 r180 *1 556.97,823.59 pfet_05v0
M$1216 \$I2061 \$I2204 \$I3008 VDD_DEC pfet_05v0 L=0.5U W=1.22U AS=0.3782P
+ AD=0.5368P PS=1.84U PD=3.32U
* device instance $1217 r180 *1 560.28,825.9 nfet_05v0
M$1217 \$I2061 \$I2238 VSS VSS nfet_05v0 L=0.6U W=0.36U AS=0.1584P AD=0.0936P
+ PS=1.6U PD=0.88U
* device instance $1218 r180 *1 559.16,825.9 nfet_05v0
M$1218 VSS \$I2418 \$I2061 VSS nfet_05v0 L=0.6U W=0.36U AS=0.0936P AD=0.0936P
+ PS=0.88U PD=0.88U
* device instance $1219 r180 *1 558.04,825.9 nfet_05v0
M$1219 \$I2061 \$I2333 VSS VSS nfet_05v0 L=0.6U W=0.36U AS=0.0936P AD=0.0936P
+ PS=0.88U PD=0.88U
* device instance $1220 r180 *1 556.92,825.9 nfet_05v0
M$1220 VSS \$I2204 \$I2061 VSS nfet_05v0 L=0.6U W=0.36U AS=0.0936P AD=0.1584P
+ PS=0.88U PD=1.6U
* device instance $1221 r180 *1 537.27,823.59 pfet_05v0
M$1221 \$I3013 \$I2323 VDD_DEC VDD_DEC pfet_05v0 L=0.5U W=1.22U AS=0.5368P
+ AD=0.3172P PS=3.32U PD=1.74U
* device instance $1222 r180 *1 536.25,823.59 pfet_05v0
M$1222 \$I3012 \$I2332 \$I3013 VDD_DEC pfet_05v0 L=0.5U W=1.22U AS=0.3172P
+ AD=0.3782P PS=1.74U PD=1.84U
* device instance $1223 r180 *1 535.13,823.59 pfet_05v0
M$1223 \$I3011 \$I2170 \$I3012 VDD_DEC pfet_05v0 L=0.5U W=1.22U AS=0.3782P
+ AD=0.3782P PS=1.84U PD=1.84U
* device instance $1224 r180 *1 534.01,823.59 pfet_05v0
M$1224 \$I2058 \$I2359 \$I3011 VDD_DEC pfet_05v0 L=0.5U W=1.22U AS=0.3782P
+ AD=0.5368P PS=1.84U PD=3.32U
* device instance $1225 r180 *1 537.32,825.9 nfet_05v0
M$1225 \$I2058 \$I2323 VSS VSS nfet_05v0 L=0.6U W=0.36U AS=0.1584P AD=0.0936P
+ PS=1.6U PD=0.88U
* device instance $1226 r180 *1 536.2,825.9 nfet_05v0
M$1226 VSS \$I2332 \$I2058 VSS nfet_05v0 L=0.6U W=0.36U AS=0.0936P AD=0.0936P
+ PS=0.88U PD=0.88U
* device instance $1227 r180 *1 535.08,825.9 nfet_05v0
M$1227 \$I2058 \$I2170 VSS VSS nfet_05v0 L=0.6U W=0.36U AS=0.0936P AD=0.0936P
+ PS=0.88U PD=0.88U
* device instance $1228 r180 *1 533.96,825.9 nfet_05v0
M$1228 VSS \$I2359 \$I2058 VSS nfet_05v0 L=0.6U W=0.36U AS=0.0936P AD=0.1584P
+ PS=0.88U PD=1.6U
* device instance $1229 r180 *1 583.75,800.07 pfet_05v0
M$1229 \$I3016 \$I2199 VDD_DEC VDD_DEC pfet_05v0 L=0.5U W=1.22U AS=0.5368P
+ AD=0.3172P PS=3.32U PD=1.74U
* device instance $1230 r180 *1 582.73,800.07 pfet_05v0
M$1230 \$I3015 \$I2212 \$I3016 VDD_DEC pfet_05v0 L=0.5U W=1.22U AS=0.3172P
+ AD=0.3782P PS=1.74U PD=1.84U
* device instance $1231 r180 *1 581.61,800.07 pfet_05v0
M$1231 \$I3014 \$I2284 \$I3015 VDD_DEC pfet_05v0 L=0.5U W=1.22U AS=0.3782P
+ AD=0.3782P PS=1.84U PD=1.84U
* device instance $1232 r180 *1 580.49,800.07 pfet_05v0
M$1232 \$I2134 \$I2172 \$I3014 VDD_DEC pfet_05v0 L=0.5U W=1.22U AS=0.3782P
+ AD=0.5368P PS=1.84U PD=3.32U
* device instance $1233 r180 *1 583.8,802.38 nfet_05v0
M$1233 \$I2134 \$I2199 VSS VSS nfet_05v0 L=0.6U W=0.36U AS=0.1584P AD=0.0936P
+ PS=1.6U PD=0.88U
* device instance $1234 r180 *1 582.68,802.38 nfet_05v0
M$1234 VSS \$I2212 \$I2134 VSS nfet_05v0 L=0.6U W=0.36U AS=0.0936P AD=0.0936P
+ PS=0.88U PD=0.88U
* device instance $1235 r180 *1 581.56,802.38 nfet_05v0
M$1235 \$I2134 \$I2284 VSS VSS nfet_05v0 L=0.6U W=0.36U AS=0.0936P AD=0.0936P
+ PS=0.88U PD=0.88U
* device instance $1236 r180 *1 580.44,802.38 nfet_05v0
M$1236 VSS \$I2172 \$I2134 VSS nfet_05v0 L=0.6U W=0.36U AS=0.0936P AD=0.1584P
+ PS=0.88U PD=1.6U
* device instance $1237 r0 *1 665.21,790.33 pfet_05v0
M$1237 \$I3019 \$I2205 VDD_DEC VDD_DEC pfet_05v0 L=0.5U W=1.22U AS=0.5368P
+ AD=0.3172P PS=3.32U PD=1.74U
* device instance $1238 r0 *1 666.23,790.33 pfet_05v0
M$1238 \$I3018 \$I2177 \$I3019 VDD_DEC pfet_05v0 L=0.5U W=1.22U AS=0.3172P
+ AD=0.3782P PS=1.74U PD=1.84U
* device instance $1239 r0 *1 667.35,790.33 pfet_05v0
M$1239 \$I3017 \$I2179 \$I3018 VDD_DEC pfet_05v0 L=0.5U W=1.22U AS=0.3782P
+ AD=0.3782P PS=1.84U PD=1.84U
* device instance $1240 r0 *1 668.47,790.33 pfet_05v0
M$1240 \$I2288 \$I2178 \$I3017 VDD_DEC pfet_05v0 L=0.5U W=1.22U AS=0.3782P
+ AD=0.5368P PS=1.84U PD=3.32U
* device instance $1241 r0 *1 665.16,788.02 nfet_05v0
M$1241 \$I2288 \$I2205 VSS VSS nfet_05v0 L=0.6U W=0.36U AS=0.1584P AD=0.0936P
+ PS=1.6U PD=0.88U
* device instance $1242 r0 *1 666.28,788.02 nfet_05v0
M$1242 VSS \$I2177 \$I2288 VSS nfet_05v0 L=0.6U W=0.36U AS=0.0936P AD=0.0936P
+ PS=0.88U PD=0.88U
* device instance $1243 r0 *1 667.4,788.02 nfet_05v0
M$1243 \$I2288 \$I2179 VSS VSS nfet_05v0 L=0.6U W=0.36U AS=0.0936P AD=0.0936P
+ PS=0.88U PD=0.88U
* device instance $1244 r0 *1 668.52,788.02 nfet_05v0
M$1244 VSS \$I2178 \$I2288 VSS nfet_05v0 L=0.6U W=0.36U AS=0.0936P AD=0.1584P
+ PS=0.88U PD=1.6U
* device instance $1245 r0 *1 613.69,806.01 pfet_05v0
M$1245 \$I3022 \$I2251 VDD_DEC VDD_DEC pfet_05v0 L=0.5U W=1.22U AS=0.5368P
+ AD=0.3172P PS=3.32U PD=1.74U
* device instance $1246 r0 *1 614.71,806.01 pfet_05v0
M$1246 \$I3021 \$I2285 \$I3022 VDD_DEC pfet_05v0 L=0.5U W=1.22U AS=0.3172P
+ AD=0.3782P PS=1.74U PD=1.84U
* device instance $1247 r0 *1 615.83,806.01 pfet_05v0
M$1247 \$I3020 \$I2179 \$I3021 VDD_DEC pfet_05v0 L=0.5U W=1.22U AS=0.3782P
+ AD=0.3782P PS=1.84U PD=1.84U
* device instance $1248 r0 *1 616.95,806.01 pfet_05v0
M$1248 \$I2168 \$I2214 \$I3020 VDD_DEC pfet_05v0 L=0.5U W=1.22U AS=0.3782P
+ AD=0.5368P PS=1.84U PD=3.32U
* device instance $1249 r0 *1 613.64,803.7 nfet_05v0
M$1249 \$I2168 \$I2251 VSS VSS nfet_05v0 L=0.6U W=0.36U AS=0.1584P AD=0.0936P
+ PS=1.6U PD=0.88U
* device instance $1250 r0 *1 614.76,803.7 nfet_05v0
M$1250 VSS \$I2285 \$I2168 VSS nfet_05v0 L=0.6U W=0.36U AS=0.0936P AD=0.0936P
+ PS=0.88U PD=0.88U
* device instance $1251 r0 *1 615.88,803.7 nfet_05v0
M$1251 \$I2168 \$I2179 VSS VSS nfet_05v0 L=0.6U W=0.36U AS=0.0936P AD=0.0936P
+ PS=0.88U PD=0.88U
* device instance $1252 r0 *1 617,803.7 nfet_05v0
M$1252 VSS \$I2214 \$I2168 VSS nfet_05v0 L=0.6U W=0.36U AS=0.0936P AD=0.1584P
+ PS=0.88U PD=1.6U
* device instance $1253 r0 *1 540.89,829.53 pfet_05v0
M$1253 \$I3025 \$I2360 VDD_DEC VDD_DEC pfet_05v0 L=0.5U W=1.22U AS=0.5368P
+ AD=0.3172P PS=3.32U PD=1.74U
* device instance $1254 r0 *1 541.91,829.53 pfet_05v0
M$1254 \$I3024 \$I2418 \$I3025 VDD_DEC pfet_05v0 L=0.5U W=1.22U AS=0.3172P
+ AD=0.3782P PS=1.74U PD=1.84U
* device instance $1255 r0 *1 543.03,829.53 pfet_05v0
M$1255 \$I3023 \$I2333 \$I3024 VDD_DEC pfet_05v0 L=0.5U W=1.22U AS=0.3782P
+ AD=0.3782P PS=1.84U PD=1.84U
* device instance $1256 r0 *1 544.15,829.53 pfet_05v0
M$1256 \$I2309 \$I2359 \$I3023 VDD_DEC pfet_05v0 L=0.5U W=1.22U AS=0.3782P
+ AD=0.5368P PS=1.84U PD=3.32U
* device instance $1257 r0 *1 540.84,827.22 nfet_05v0
M$1257 \$I2309 \$I2360 VSS VSS nfet_05v0 L=0.6U W=0.36U AS=0.1584P AD=0.0936P
+ PS=1.6U PD=0.88U
* device instance $1258 r0 *1 541.96,827.22 nfet_05v0
M$1258 VSS \$I2418 \$I2309 VSS nfet_05v0 L=0.6U W=0.36U AS=0.0936P AD=0.0936P
+ PS=0.88U PD=0.88U
* device instance $1259 r0 *1 543.08,827.22 nfet_05v0
M$1259 \$I2309 \$I2333 VSS VSS nfet_05v0 L=0.6U W=0.36U AS=0.0936P AD=0.0936P
+ PS=0.88U PD=0.88U
* device instance $1260 r0 *1 544.2,827.22 nfet_05v0
M$1260 VSS \$I2359 \$I2309 VSS nfet_05v0 L=0.6U W=0.36U AS=0.0936P AD=0.1584P
+ PS=0.88U PD=1.6U
* device instance $1261 r0 *1 619.29,806.01 pfet_05v0
M$1261 \$I3028 \$I2209 VDD_DEC VDD_DEC pfet_05v0 L=0.5U W=1.22U AS=0.5368P
+ AD=0.3172P PS=3.32U PD=1.74U
* device instance $1262 r0 *1 620.31,806.01 pfet_05v0
M$1262 \$I3027 \$I2286 \$I3028 VDD_DEC pfet_05v0 L=0.5U W=1.22U AS=0.3172P
+ AD=0.3782P PS=1.74U PD=1.84U
* device instance $1263 r0 *1 621.43,806.01 pfet_05v0
M$1263 \$I3026 \$I2287 \$I3027 VDD_DEC pfet_05v0 L=0.5U W=1.22U AS=0.3782P
+ AD=0.3782P PS=1.84U PD=1.84U
* device instance $1264 r0 *1 622.55,806.01 pfet_05v0
M$1264 \$I2256 \$I2214 \$I3026 VDD_DEC pfet_05v0 L=0.5U W=1.22U AS=0.3782P
+ AD=0.5368P PS=1.84U PD=3.32U
* device instance $1265 r0 *1 619.24,803.7 nfet_05v0
M$1265 \$I2256 \$I2209 VSS VSS nfet_05v0 L=0.6U W=0.36U AS=0.1584P AD=0.0936P
+ PS=1.6U PD=0.88U
* device instance $1266 r0 *1 620.36,803.7 nfet_05v0
M$1266 VSS \$I2286 \$I2256 VSS nfet_05v0 L=0.6U W=0.36U AS=0.0936P AD=0.0936P
+ PS=0.88U PD=0.88U
* device instance $1267 r0 *1 621.48,803.7 nfet_05v0
M$1267 \$I2256 \$I2287 VSS VSS nfet_05v0 L=0.6U W=0.36U AS=0.0936P AD=0.0936P
+ PS=0.88U PD=0.88U
* device instance $1268 r0 *1 622.6,803.7 nfet_05v0
M$1268 VSS \$I2214 \$I2256 VSS nfet_05v0 L=0.6U W=0.36U AS=0.0936P AD=0.1584P
+ PS=0.88U PD=1.6U
* device instance $1269 r0 *1 656.81,806.01 pfet_05v0
M$1269 \$I3031 \$I2308 VDD_DEC VDD_DEC pfet_05v0 L=0.5U W=1.22U AS=0.5368P
+ AD=0.3172P PS=3.32U PD=1.74U
* device instance $1270 r0 *1 657.83,806.01 pfet_05v0
M$1270 \$I3030 \$I2215 \$I3031 VDD_DEC pfet_05v0 L=0.5U W=1.22U AS=0.3172P
+ AD=0.3782P PS=1.74U PD=1.84U
* device instance $1271 r0 *1 658.95,806.01 pfet_05v0
M$1271 \$I3029 \$I2179 \$I3030 VDD_DEC pfet_05v0 L=0.5U W=1.22U AS=0.3782P
+ AD=0.3782P PS=1.84U PD=1.84U
* device instance $1272 r0 *1 660.07,806.01 pfet_05v0
M$1272 \$I2328 \$I2178 \$I3029 VDD_DEC pfet_05v0 L=0.5U W=1.22U AS=0.3782P
+ AD=0.5368P PS=1.84U PD=3.32U
* device instance $1273 r0 *1 656.76,803.7 nfet_05v0
M$1273 \$I2328 \$I2308 VSS VSS nfet_05v0 L=0.6U W=0.36U AS=0.1584P AD=0.0936P
+ PS=1.6U PD=0.88U
* device instance $1274 r0 *1 657.88,803.7 nfet_05v0
M$1274 VSS \$I2215 \$I2328 VSS nfet_05v0 L=0.6U W=0.36U AS=0.0936P AD=0.0936P
+ PS=0.88U PD=0.88U
* device instance $1275 r0 *1 659,803.7 nfet_05v0
M$1275 \$I2328 \$I2179 VSS VSS nfet_05v0 L=0.6U W=0.36U AS=0.0936P AD=0.0936P
+ PS=0.88U PD=0.88U
* device instance $1276 r0 *1 660.12,803.7 nfet_05v0
M$1276 VSS \$I2178 \$I2328 VSS nfet_05v0 L=0.6U W=0.36U AS=0.0936P AD=0.1584P
+ PS=0.88U PD=1.6U
* device instance $1277 r0 *1 665.21,806.01 pfet_05v0
M$1277 \$I3034 \$I2274 VDD_DEC VDD_DEC pfet_05v0 L=0.5U W=1.22U AS=0.5368P
+ AD=0.3172P PS=3.32U PD=1.74U
* device instance $1278 r0 *1 666.23,806.01 pfet_05v0
M$1278 \$I3033 \$I2140 \$I3034 VDD_DEC pfet_05v0 L=0.5U W=1.22U AS=0.3172P
+ AD=0.3782P PS=1.74U PD=1.84U
* device instance $1279 r0 *1 667.35,806.01 pfet_05v0
M$1279 \$I3032 \$I2287 \$I3033 VDD_DEC pfet_05v0 L=0.5U W=1.22U AS=0.3782P
+ AD=0.3782P PS=1.84U PD=1.84U
* device instance $1280 r0 *1 668.47,806.01 pfet_05v0
M$1280 \$I2080 \$I2138 \$I3032 VDD_DEC pfet_05v0 L=0.5U W=1.22U AS=0.3782P
+ AD=0.5368P PS=1.84U PD=3.32U
* device instance $1281 r0 *1 665.16,803.7 nfet_05v0
M$1281 \$I2080 \$I2274 VSS VSS nfet_05v0 L=0.6U W=0.36U AS=0.1584P AD=0.0936P
+ PS=1.6U PD=0.88U
* device instance $1282 r0 *1 666.28,803.7 nfet_05v0
M$1282 VSS \$I2140 \$I2080 VSS nfet_05v0 L=0.6U W=0.36U AS=0.0936P AD=0.0936P
+ PS=0.88U PD=0.88U
* device instance $1283 r0 *1 667.4,803.7 nfet_05v0
M$1283 \$I2080 \$I2287 VSS VSS nfet_05v0 L=0.6U W=0.36U AS=0.0936P AD=0.0936P
+ PS=0.88U PD=0.88U
* device instance $1284 r0 *1 668.52,803.7 nfet_05v0
M$1284 VSS \$I2138 \$I2080 VSS nfet_05v0 L=0.6U W=0.36U AS=0.0936P AD=0.1584P
+ PS=0.88U PD=1.6U
* device instance $1285 r0 *1 586.81,813.85 pfet_05v0
M$1285 \$I3037 \$I2402 VDD_DEC VDD_DEC pfet_05v0 L=0.5U W=1.22U AS=0.5368P
+ AD=0.3172P PS=3.32U PD=1.74U
* device instance $1286 r0 *1 587.83,813.85 pfet_05v0
M$1286 \$I3036 \$I2212 \$I3037 VDD_DEC pfet_05v0 L=0.5U W=1.22U AS=0.3172P
+ AD=0.3782P PS=1.74U PD=1.84U
* device instance $1287 r0 *1 588.95,813.85 pfet_05v0
M$1287 \$I3035 \$I2284 \$I3036 VDD_DEC pfet_05v0 L=0.5U W=1.22U AS=0.3782P
+ AD=0.3782P PS=1.84U PD=1.84U
* device instance $1288 r0 *1 590.07,813.85 pfet_05v0
M$1288 \$I2239 \$I2252 \$I3035 VDD_DEC pfet_05v0 L=0.5U W=1.22U AS=0.3782P
+ AD=0.5368P PS=1.84U PD=3.32U
* device instance $1289 r0 *1 586.76,811.54 nfet_05v0
M$1289 \$I2239 \$I2402 VSS VSS nfet_05v0 L=0.6U W=0.36U AS=0.1584P AD=0.0936P
+ PS=1.6U PD=0.88U
* device instance $1290 r0 *1 587.88,811.54 nfet_05v0
M$1290 VSS \$I2212 \$I2239 VSS nfet_05v0 L=0.6U W=0.36U AS=0.0936P AD=0.0936P
+ PS=0.88U PD=0.88U
* device instance $1291 r0 *1 589,811.54 nfet_05v0
M$1291 \$I2239 \$I2284 VSS VSS nfet_05v0 L=0.6U W=0.36U AS=0.0936P AD=0.0936P
+ PS=0.88U PD=0.88U
* device instance $1292 r0 *1 590.12,811.54 nfet_05v0
M$1292 VSS \$I2252 \$I2239 VSS nfet_05v0 L=0.6U W=0.36U AS=0.0936P AD=0.1584P
+ PS=0.88U PD=1.6U
* device instance $1293 r0 *1 540.89,790.33 pfet_05v0
M$1293 \$I3040 \$I2166 VDD_DEC VDD_DEC pfet_05v0 L=0.5U W=1.22U AS=0.5368P
+ AD=0.3172P PS=3.32U PD=1.74U
* device instance $1294 r0 *1 541.91,790.33 pfet_05v0
M$1294 \$I3039 \$I2203 \$I3040 VDD_DEC pfet_05v0 L=0.5U W=1.22U AS=0.3172P
+ AD=0.3782P PS=1.74U PD=1.84U
* device instance $1295 r0 *1 543.03,790.33 pfet_05v0
M$1295 \$I3038 \$I2170 \$I3039 VDD_DEC pfet_05v0 L=0.5U W=1.22U AS=0.3782P
+ AD=0.3782P PS=1.84U PD=1.84U
* device instance $1296 r0 *1 544.15,790.33 pfet_05v0
M$1296 \$I2025 \$I2204 \$I3038 VDD_DEC pfet_05v0 L=0.5U W=1.22U AS=0.3782P
+ AD=0.5368P PS=1.84U PD=3.32U
* device instance $1297 r0 *1 540.84,788.02 nfet_05v0
M$1297 \$I2025 \$I2166 VSS VSS nfet_05v0 L=0.6U W=0.36U AS=0.1584P AD=0.0936P
+ PS=1.6U PD=0.88U
* device instance $1298 r0 *1 541.96,788.02 nfet_05v0
M$1298 VSS \$I2203 \$I2025 VSS nfet_05v0 L=0.6U W=0.36U AS=0.0936P AD=0.0936P
+ PS=0.88U PD=0.88U
* device instance $1299 r0 *1 543.08,788.02 nfet_05v0
M$1299 \$I2025 \$I2170 VSS VSS nfet_05v0 L=0.6U W=0.36U AS=0.0936P AD=0.0936P
+ PS=0.88U PD=0.88U
* device instance $1300 r0 *1 544.2,788.02 nfet_05v0
M$1300 VSS \$I2204 \$I2025 VSS nfet_05v0 L=0.6U W=0.36U AS=0.0936P AD=0.1584P
+ PS=0.88U PD=1.6U
* device instance $1301 r0 *1 594.09,813.85 pfet_05v0
M$1301 \$I3043 \$I2357 VDD_DEC VDD_DEC pfet_05v0 L=0.5U W=1.22U AS=0.5368P
+ AD=0.3172P PS=3.32U PD=1.74U
* device instance $1302 r0 *1 595.11,813.85 pfet_05v0
M$1302 \$I3042 \$I2311 \$I3043 VDD_DEC pfet_05v0 L=0.5U W=1.22U AS=0.3172P
+ AD=0.3782P PS=1.74U PD=1.84U
* device instance $1303 r0 *1 596.23,813.85 pfet_05v0
M$1303 \$I3041 \$I2284 \$I3042 VDD_DEC pfet_05v0 L=0.5U W=1.22U AS=0.3782P
+ AD=0.3782P PS=1.84U PD=1.84U
* device instance $1304 r0 *1 597.35,813.85 pfet_05v0
M$1304 \$I2103 \$I2252 \$I3041 VDD_DEC pfet_05v0 L=0.5U W=1.22U AS=0.3782P
+ AD=0.5368P PS=1.84U PD=3.32U
* device instance $1305 r0 *1 594.04,811.54 nfet_05v0
M$1305 \$I2103 \$I2357 VSS VSS nfet_05v0 L=0.6U W=0.36U AS=0.1584P AD=0.0936P
+ PS=1.6U PD=0.88U
* device instance $1306 r0 *1 595.16,811.54 nfet_05v0
M$1306 VSS \$I2311 \$I2103 VSS nfet_05v0 L=0.6U W=0.36U AS=0.0936P AD=0.0936P
+ PS=0.88U PD=0.88U
* device instance $1307 r0 *1 596.28,811.54 nfet_05v0
M$1307 \$I2103 \$I2284 VSS VSS nfet_05v0 L=0.6U W=0.36U AS=0.0936P AD=0.0936P
+ PS=0.88U PD=0.88U
* device instance $1308 r0 *1 597.4,811.54 nfet_05v0
M$1308 VSS \$I2252 \$I2103 VSS nfet_05v0 L=0.6U W=0.36U AS=0.0936P AD=0.1584P
+ PS=0.88U PD=1.6U
* device instance $1309 r0 *1 604.17,806.01 pfet_05v0
M$1309 \$I3046 \$I2308 VDD_DEC VDD_DEC pfet_05v0 L=0.5U W=1.22U AS=0.5368P
+ AD=0.3172P PS=3.32U PD=1.74U
* device instance $1310 r0 *1 605.19,806.01 pfet_05v0
M$1310 \$I3045 \$I2241 \$I3046 VDD_DEC pfet_05v0 L=0.5U W=1.22U AS=0.3172P
+ AD=0.3782P PS=1.74U PD=1.84U
* device instance $1311 r0 *1 606.31,806.01 pfet_05v0
M$1311 \$I3044 \$I2243 \$I3045 VDD_DEC pfet_05v0 L=0.5U W=1.22U AS=0.3782P
+ AD=0.3782P PS=1.84U PD=1.84U
* device instance $1312 r0 *1 607.43,806.01 pfet_05v0
M$1312 \$I2136 \$I2240 \$I3044 VDD_DEC pfet_05v0 L=0.5U W=1.22U AS=0.3782P
+ AD=0.5368P PS=1.84U PD=3.32U
* device instance $1313 r0 *1 604.12,803.7 nfet_05v0
M$1313 \$I2136 \$I2308 VSS VSS nfet_05v0 L=0.6U W=0.36U AS=0.1584P AD=0.0936P
+ PS=1.6U PD=0.88U
* device instance $1314 r0 *1 605.24,803.7 nfet_05v0
M$1314 VSS \$I2241 \$I2136 VSS nfet_05v0 L=0.6U W=0.36U AS=0.0936P AD=0.0936P
+ PS=0.88U PD=0.88U
* device instance $1315 r0 *1 606.36,803.7 nfet_05v0
M$1315 \$I2136 \$I2243 VSS VSS nfet_05v0 L=0.6U W=0.36U AS=0.0936P AD=0.0936P
+ PS=0.88U PD=0.88U
* device instance $1316 r0 *1 607.48,803.7 nfet_05v0
M$1316 VSS \$I2240 \$I2136 VSS nfet_05v0 L=0.6U W=0.36U AS=0.0936P AD=0.1584P
+ PS=0.88U PD=1.6U
* device instance $1317 r0 *1 619.29,821.69 pfet_05v0
M$1317 \$I3049 \$I2360 VDD_DEC VDD_DEC pfet_05v0 L=0.5U W=1.22U AS=0.5368P
+ AD=0.3172P PS=3.32U PD=1.74U
* device instance $1318 r0 *1 620.31,821.69 pfet_05v0
M$1318 \$I3048 \$I2286 \$I3049 VDD_DEC pfet_05v0 L=0.5U W=1.22U AS=0.3172P
+ AD=0.3782P PS=1.74U PD=1.84U
* device instance $1319 r0 *1 621.43,821.69 pfet_05v0
M$1319 \$I3047 \$I2287 \$I3048 VDD_DEC pfet_05v0 L=0.5U W=1.22U AS=0.3782P
+ AD=0.3782P PS=1.84U PD=1.84U
* device instance $1320 r0 *1 622.55,821.69 pfet_05v0
M$1320 \$I2325 \$I2214 \$I3047 VDD_DEC pfet_05v0 L=0.5U W=1.22U AS=0.3782P
+ AD=0.5368P PS=1.84U PD=3.32U
* device instance $1321 r0 *1 619.24,819.38 nfet_05v0
M$1321 \$I2325 \$I2360 VSS VSS nfet_05v0 L=0.6U W=0.36U AS=0.1584P AD=0.0936P
+ PS=1.6U PD=0.88U
* device instance $1322 r0 *1 620.36,819.38 nfet_05v0
M$1322 VSS \$I2286 \$I2325 VSS nfet_05v0 L=0.6U W=0.36U AS=0.0936P AD=0.0936P
+ PS=0.88U PD=0.88U
* device instance $1323 r0 *1 621.48,819.38 nfet_05v0
M$1323 \$I2325 \$I2287 VSS VSS nfet_05v0 L=0.6U W=0.36U AS=0.0936P AD=0.0936P
+ PS=0.88U PD=0.88U
* device instance $1324 r0 *1 622.6,819.38 nfet_05v0
M$1324 VSS \$I2214 \$I2325 VSS nfet_05v0 L=0.6U W=0.36U AS=0.0936P AD=0.1584P
+ PS=0.88U PD=1.6U
* device instance $1325 r0 *1 535.29,813.85 pfet_05v0
M$1325 \$I3052 \$I2251 VDD_DEC VDD_DEC pfet_05v0 L=0.5U W=1.22U AS=0.5368P
+ AD=0.3172P PS=3.32U PD=1.74U
* device instance $1326 r0 *1 536.31,813.85 pfet_05v0
M$1326 \$I3051 \$I2332 \$I3052 VDD_DEC pfet_05v0 L=0.5U W=1.22U AS=0.3172P
+ AD=0.3782P PS=1.74U PD=1.84U
* device instance $1327 r0 *1 537.43,813.85 pfet_05v0
M$1327 \$I3050 \$I2170 \$I3051 VDD_DEC pfet_05v0 L=0.5U W=1.22U AS=0.3782P
+ AD=0.3782P PS=1.84U PD=1.84U
* device instance $1328 r0 *1 538.55,813.85 pfet_05v0
M$1328 \$I2276 \$I2280 \$I3050 VDD_DEC pfet_05v0 L=0.5U W=1.22U AS=0.3782P
+ AD=0.5368P PS=1.84U PD=3.32U
* device instance $1329 r0 *1 535.24,811.54 nfet_05v0
M$1329 \$I2276 \$I2251 VSS VSS nfet_05v0 L=0.6U W=0.36U AS=0.1584P AD=0.0936P
+ PS=1.6U PD=0.88U
* device instance $1330 r0 *1 536.36,811.54 nfet_05v0
M$1330 VSS \$I2332 \$I2276 VSS nfet_05v0 L=0.6U W=0.36U AS=0.0936P AD=0.0936P
+ PS=0.88U PD=0.88U
* device instance $1331 r0 *1 537.48,811.54 nfet_05v0
M$1331 \$I2276 \$I2170 VSS VSS nfet_05v0 L=0.6U W=0.36U AS=0.0936P AD=0.0936P
+ PS=0.88U PD=0.88U
* device instance $1332 r0 *1 538.6,811.54 nfet_05v0
M$1332 VSS \$I2280 \$I2276 VSS nfet_05v0 L=0.6U W=0.36U AS=0.0936P AD=0.1584P
+ PS=0.88U PD=1.6U
* device instance $1333 r0 *1 626.01,821.69 pfet_05v0
M$1333 \$I3055 \$I2308 VDD_DEC VDD_DEC pfet_05v0 L=0.5U W=1.22U AS=0.5368P
+ AD=0.3172P PS=3.32U PD=1.74U
* device instance $1334 r0 *1 627.03,821.69 pfet_05v0
M$1334 \$I3054 \$I2140 \$I3055 VDD_DEC pfet_05v0 L=0.5U W=1.22U AS=0.3172P
+ AD=0.3782P PS=1.74U PD=1.84U
* device instance $1335 r0 *1 628.15,821.69 pfet_05v0
M$1335 \$I3053 \$I2287 \$I3054 VDD_DEC pfet_05v0 L=0.5U W=1.22U AS=0.3782P
+ AD=0.3782P PS=1.84U PD=1.84U
* device instance $1336 r0 *1 629.27,821.69 pfet_05v0
M$1336 \$I2312 \$I2138 \$I3053 VDD_DEC pfet_05v0 L=0.5U W=1.22U AS=0.3782P
+ AD=0.5368P PS=1.84U PD=3.32U
* device instance $1337 r0 *1 625.96,819.38 nfet_05v0
M$1337 \$I2312 \$I2308 VSS VSS nfet_05v0 L=0.6U W=0.36U AS=0.1584P AD=0.0936P
+ PS=1.6U PD=0.88U
* device instance $1338 r0 *1 627.08,819.38 nfet_05v0
M$1338 VSS \$I2140 \$I2312 VSS nfet_05v0 L=0.6U W=0.36U AS=0.0936P AD=0.0936P
+ PS=0.88U PD=0.88U
* device instance $1339 r0 *1 628.2,819.38 nfet_05v0
M$1339 \$I2312 \$I2287 VSS VSS nfet_05v0 L=0.6U W=0.36U AS=0.0936P AD=0.0936P
+ PS=0.88U PD=0.88U
* device instance $1340 r0 *1 629.32,819.38 nfet_05v0
M$1340 VSS \$I2138 \$I2312 VSS nfet_05v0 L=0.6U W=0.36U AS=0.0936P AD=0.1584P
+ PS=0.88U PD=1.6U
* device instance $1341 r0 *1 610.89,821.69 pfet_05v0
M$1341 \$I3058 \$I2274 VDD_DEC VDD_DEC pfet_05v0 L=0.5U W=1.22U AS=0.5368P
+ AD=0.3172P PS=3.32U PD=1.74U
* device instance $1342 r0 *1 611.91,821.69 pfet_05v0
M$1342 \$I3057 \$I2241 \$I3058 VDD_DEC pfet_05v0 L=0.5U W=1.22U AS=0.3172P
+ AD=0.3782P PS=1.74U PD=1.84U
* device instance $1343 r0 *1 613.03,821.69 pfet_05v0
M$1343 \$I3056 \$I2243 \$I3057 VDD_DEC pfet_05v0 L=0.5U W=1.22U AS=0.3782P
+ AD=0.3782P PS=1.84U PD=1.84U
* device instance $1344 r0 *1 614.15,821.69 pfet_05v0
M$1344 \$I2031 \$I2240 \$I3056 VDD_DEC pfet_05v0 L=0.5U W=1.22U AS=0.3782P
+ AD=0.5368P PS=1.84U PD=3.32U
* device instance $1345 r0 *1 610.84,819.38 nfet_05v0
M$1345 \$I2031 \$I2274 VSS VSS nfet_05v0 L=0.6U W=0.36U AS=0.1584P AD=0.0936P
+ PS=1.6U PD=0.88U
* device instance $1346 r0 *1 611.96,819.38 nfet_05v0
M$1346 VSS \$I2241 \$I2031 VSS nfet_05v0 L=0.6U W=0.36U AS=0.0936P AD=0.0936P
+ PS=0.88U PD=0.88U
* device instance $1347 r0 *1 613.08,819.38 nfet_05v0
M$1347 \$I2031 \$I2243 VSS VSS nfet_05v0 L=0.6U W=0.36U AS=0.0936P AD=0.0936P
+ PS=0.88U PD=0.88U
* device instance $1348 r0 *1 614.2,819.38 nfet_05v0
M$1348 VSS \$I2240 \$I2031 VSS nfet_05v0 L=0.6U W=0.36U AS=0.0936P AD=0.1584P
+ PS=0.88U PD=1.6U
* device instance $1349 r0 *1 619.29,798.17 pfet_05v0
M$1349 \$I3061 \$I2238 VDD_DEC VDD_DEC pfet_05v0 L=0.5U W=1.22U AS=0.5368P
+ AD=0.3172P PS=3.32U PD=1.74U
* device instance $1350 r0 *1 620.31,798.17 pfet_05v0
M$1350 \$I3060 \$I2241 \$I3061 VDD_DEC pfet_05v0 L=0.5U W=1.22U AS=0.3172P
+ AD=0.3782P PS=1.74U PD=1.84U
* device instance $1351 r0 *1 621.43,798.17 pfet_05v0
M$1351 \$I3059 \$I2179 \$I3060 VDD_DEC pfet_05v0 L=0.5U W=1.22U AS=0.3782P
+ AD=0.3782P PS=1.84U PD=1.84U
* device instance $1352 r0 *1 622.55,798.17 pfet_05v0
M$1352 \$I2076 \$I2240 \$I3059 VDD_DEC pfet_05v0 L=0.5U W=1.22U AS=0.3782P
+ AD=0.5368P PS=1.84U PD=3.32U
* device instance $1353 r0 *1 619.24,795.86 nfet_05v0
M$1353 \$I2076 \$I2238 VSS VSS nfet_05v0 L=0.6U W=0.36U AS=0.1584P AD=0.0936P
+ PS=1.6U PD=0.88U
* device instance $1354 r0 *1 620.36,795.86 nfet_05v0
M$1354 VSS \$I2241 \$I2076 VSS nfet_05v0 L=0.6U W=0.36U AS=0.0936P AD=0.0936P
+ PS=0.88U PD=0.88U
* device instance $1355 r0 *1 621.48,795.86 nfet_05v0
M$1355 \$I2076 \$I2179 VSS VSS nfet_05v0 L=0.6U W=0.36U AS=0.0936P AD=0.0936P
+ PS=0.88U PD=0.88U
* device instance $1356 r0 *1 622.6,795.86 nfet_05v0
M$1356 VSS \$I2240 \$I2076 VSS nfet_05v0 L=0.6U W=0.36U AS=0.0936P AD=0.1584P
+ PS=0.88U PD=1.6U
* device instance $1357 r0 *1 599.13,798.17 pfet_05v0
M$1357 \$I3064 \$I2209 VDD_DEC VDD_DEC pfet_05v0 L=0.5U W=1.22U AS=0.5368P
+ AD=0.3172P PS=3.32U PD=1.74U
* device instance $1358 r0 *1 600.15,798.17 pfet_05v0
M$1358 \$I3063 \$I2212 \$I3064 VDD_DEC pfet_05v0 L=0.5U W=1.22U AS=0.3172P
+ AD=0.3782P PS=1.74U PD=1.84U
* device instance $1359 r0 *1 601.27,798.17 pfet_05v0
M$1359 \$I3062 \$I2243 \$I3063 VDD_DEC pfet_05v0 L=0.5U W=1.22U AS=0.3782P
+ AD=0.3782P PS=1.84U PD=1.84U
* device instance $1360 r0 *1 602.39,798.17 pfet_05v0
M$1360 \$I2213 \$I2240 \$I3062 VDD_DEC pfet_05v0 L=0.5U W=1.22U AS=0.3782P
+ AD=0.5368P PS=1.84U PD=3.32U
* device instance $1361 r0 *1 599.08,795.86 nfet_05v0
M$1361 \$I2213 \$I2209 VSS VSS nfet_05v0 L=0.6U W=0.36U AS=0.1584P AD=0.0936P
+ PS=1.6U PD=0.88U
* device instance $1362 r0 *1 600.2,795.86 nfet_05v0
M$1362 VSS \$I2212 \$I2213 VSS nfet_05v0 L=0.6U W=0.36U AS=0.0936P AD=0.0936P
+ PS=0.88U PD=0.88U
* device instance $1363 r0 *1 601.32,795.86 nfet_05v0
M$1363 \$I2213 \$I2243 VSS VSS nfet_05v0 L=0.6U W=0.36U AS=0.0936P AD=0.0936P
+ PS=0.88U PD=0.88U
* device instance $1364 r0 *1 602.44,795.86 nfet_05v0
M$1364 VSS \$I2240 \$I2213 VSS nfet_05v0 L=0.6U W=0.36U AS=0.0936P AD=0.1584P
+ PS=0.88U PD=1.6U
* device instance $1365 r0 *1 604.73,798.17 pfet_05v0
M$1365 \$I3067 \$I2166 VDD_DEC VDD_DEC pfet_05v0 L=0.5U W=1.22U AS=0.5368P
+ AD=0.3172P PS=3.32U PD=1.74U
* device instance $1366 r0 *1 605.75,798.17 pfet_05v0
M$1366 \$I3066 \$I2241 \$I3067 VDD_DEC pfet_05v0 L=0.5U W=1.22U AS=0.3172P
+ AD=0.3782P PS=1.74U PD=1.84U
* device instance $1367 r0 *1 606.87,798.17 pfet_05v0
M$1367 \$I3065 \$I2243 \$I3066 VDD_DEC pfet_05v0 L=0.5U W=1.22U AS=0.3782P
+ AD=0.3782P PS=1.84U PD=1.84U
* device instance $1368 r0 *1 607.99,798.17 pfet_05v0
M$1368 \$I2242 \$I2240 \$I3065 VDD_DEC pfet_05v0 L=0.5U W=1.22U AS=0.3782P
+ AD=0.5368P PS=1.84U PD=3.32U
* device instance $1369 r0 *1 604.68,795.86 nfet_05v0
M$1369 \$I2242 \$I2166 VSS VSS nfet_05v0 L=0.6U W=0.36U AS=0.1584P AD=0.0936P
+ PS=1.6U PD=0.88U
* device instance $1370 r0 *1 605.8,795.86 nfet_05v0
M$1370 VSS \$I2241 \$I2242 VSS nfet_05v0 L=0.6U W=0.36U AS=0.0936P AD=0.0936P
+ PS=0.88U PD=0.88U
* device instance $1371 r0 *1 606.92,795.86 nfet_05v0
M$1371 \$I2242 \$I2243 VSS VSS nfet_05v0 L=0.6U W=0.36U AS=0.0936P AD=0.0936P
+ PS=0.88U PD=0.88U
* device instance $1372 r0 *1 608.04,795.86 nfet_05v0
M$1372 VSS \$I2240 \$I2242 VSS nfet_05v0 L=0.6U W=0.36U AS=0.0936P AD=0.1584P
+ PS=0.88U PD=1.6U
* device instance $1373 r0 *1 592.41,798.17 pfet_05v0
M$1373 \$I3070 \$I2205 VDD_DEC VDD_DEC pfet_05v0 L=0.5U W=1.22U AS=0.5368P
+ AD=0.3172P PS=3.32U PD=1.74U
* device instance $1374 r0 *1 593.43,798.17 pfet_05v0
M$1374 \$I3069 \$I2173 \$I3070 VDD_DEC pfet_05v0 L=0.5U W=1.22U AS=0.3172P
+ AD=0.3782P PS=1.74U PD=1.84U
* device instance $1375 r0 *1 594.55,798.17 pfet_05v0
M$1375 \$I3068 \$I2211 \$I3069 VDD_DEC pfet_05v0 L=0.5U W=1.22U AS=0.3782P
+ AD=0.3782P PS=1.84U PD=1.84U
* device instance $1376 r0 *1 595.67,798.17 pfet_05v0
M$1376 \$I2167 \$I2252 \$I3068 VDD_DEC pfet_05v0 L=0.5U W=1.22U AS=0.3782P
+ AD=0.5368P PS=1.84U PD=3.32U
* device instance $1377 r0 *1 592.36,795.86 nfet_05v0
M$1377 \$I2167 \$I2205 VSS VSS nfet_05v0 L=0.6U W=0.36U AS=0.1584P AD=0.0936P
+ PS=1.6U PD=0.88U
* device instance $1378 r0 *1 593.48,795.86 nfet_05v0
M$1378 VSS \$I2173 \$I2167 VSS nfet_05v0 L=0.6U W=0.36U AS=0.0936P AD=0.0936P
+ PS=0.88U PD=0.88U
* device instance $1379 r0 *1 594.6,795.86 nfet_05v0
M$1379 \$I2167 \$I2211 VSS VSS nfet_05v0 L=0.6U W=0.36U AS=0.0936P AD=0.0936P
+ PS=0.88U PD=0.88U
* device instance $1380 r0 *1 595.72,795.86 nfet_05v0
M$1380 VSS \$I2252 \$I2167 VSS nfet_05v0 L=0.6U W=0.36U AS=0.0936P AD=0.1584P
+ PS=0.88U PD=1.6U
* device instance $1381 r0 *1 586.81,798.17 pfet_05v0
M$1381 \$I3073 \$I2308 VDD_DEC VDD_DEC pfet_05v0 L=0.5U W=1.22U AS=0.5368P
+ AD=0.3172P PS=3.32U PD=1.74U
* device instance $1382 r0 *1 587.83,798.17 pfet_05v0
M$1382 \$I3072 \$I2173 \$I3073 VDD_DEC pfet_05v0 L=0.5U W=1.22U AS=0.3172P
+ AD=0.3782P PS=1.74U PD=1.84U
* device instance $1383 r0 *1 588.95,798.17 pfet_05v0
M$1383 \$I3071 \$I2211 \$I3072 VDD_DEC pfet_05v0 L=0.5U W=1.22U AS=0.3782P
+ AD=0.3782P PS=1.84U PD=1.84U
* device instance $1384 r0 *1 590.07,798.17 pfet_05v0
M$1384 \$I2029 \$I2252 \$I3071 VDD_DEC pfet_05v0 L=0.5U W=1.22U AS=0.3782P
+ AD=0.5368P PS=1.84U PD=3.32U
* device instance $1385 r0 *1 586.76,795.86 nfet_05v0
M$1385 \$I2029 \$I2308 VSS VSS nfet_05v0 L=0.6U W=0.36U AS=0.1584P AD=0.0936P
+ PS=1.6U PD=0.88U
* device instance $1386 r0 *1 587.88,795.86 nfet_05v0
M$1386 VSS \$I2173 \$I2029 VSS nfet_05v0 L=0.6U W=0.36U AS=0.0936P AD=0.0936P
+ PS=0.88U PD=0.88U
* device instance $1387 r0 *1 589,795.86 nfet_05v0
M$1387 \$I2029 \$I2211 VSS VSS nfet_05v0 L=0.6U W=0.36U AS=0.0936P AD=0.0936P
+ PS=0.88U PD=0.88U
* device instance $1388 r0 *1 590.12,795.86 nfet_05v0
M$1388 VSS \$I2252 \$I2029 VSS nfet_05v0 L=0.6U W=0.36U AS=0.0936P AD=0.1584P
+ PS=0.88U PD=1.6U
* device instance $1389 r0 *1 510.09,813.85 pfet_05v0
M$1389 \$I3076 \$I2362 VDD_DEC VDD_DEC pfet_05v0 L=0.5U W=1.22U AS=0.5368P
+ AD=0.3172P PS=3.32U PD=1.74U
* device instance $1390 r0 *1 511.11,813.85 pfet_05v0
M$1390 \$I3075 \$I2197 \$I3076 VDD_DEC pfet_05v0 L=0.5U W=1.22U AS=0.3172P
+ AD=0.3782P PS=1.74U PD=1.84U
* device instance $1391 r0 *1 512.23,813.85 pfet_05v0
M$1391 \$I3074 \$I2250 \$I3075 VDD_DEC pfet_05v0 L=0.5U W=1.22U AS=0.3782P
+ AD=0.3782P PS=1.84U PD=1.84U
* device instance $1392 r0 *1 513.35,813.85 pfet_05v0
M$1392 \$I2125 \$I2196 \$I3074 VDD_DEC pfet_05v0 L=0.5U W=1.22U AS=0.3782P
+ AD=0.5368P PS=1.84U PD=3.32U
* device instance $1393 r0 *1 510.04,811.54 nfet_05v0
M$1393 \$I2125 \$I2362 VSS VSS nfet_05v0 L=0.6U W=0.36U AS=0.1584P AD=0.0936P
+ PS=1.6U PD=0.88U
* device instance $1394 r0 *1 511.16,811.54 nfet_05v0
M$1394 VSS \$I2197 \$I2125 VSS nfet_05v0 L=0.6U W=0.36U AS=0.0936P AD=0.0936P
+ PS=0.88U PD=0.88U
* device instance $1395 r0 *1 512.28,811.54 nfet_05v0
M$1395 \$I2125 \$I2250 VSS VSS nfet_05v0 L=0.6U W=0.36U AS=0.0936P AD=0.0936P
+ PS=0.88U PD=0.88U
* device instance $1396 r0 *1 513.4,811.54 nfet_05v0
M$1396 VSS \$I2196 \$I2125 VSS nfet_05v0 L=0.6U W=0.36U AS=0.0936P AD=0.1584P
+ PS=0.88U PD=1.6U
* device instance $1397 r0 *1 631.61,821.69 pfet_05v0
M$1397 \$I3079 \$I2205 VDD_DEC VDD_DEC pfet_05v0 L=0.5U W=1.22U AS=0.5368P
+ AD=0.3172P PS=3.32U PD=1.74U
* device instance $1398 r0 *1 632.63,821.69 pfet_05v0
M$1398 \$I3078 \$I2215 \$I3079 VDD_DEC pfet_05v0 L=0.5U W=1.22U AS=0.3172P
+ AD=0.3782P PS=1.74U PD=1.84U
* device instance $1399 r0 *1 633.75,821.69 pfet_05v0
M$1399 \$I3077 \$I2287 \$I3078 VDD_DEC pfet_05v0 L=0.5U W=1.22U AS=0.3782P
+ AD=0.3782P PS=1.84U PD=1.84U
* device instance $1400 r0 *1 634.87,821.69 pfet_05v0
M$1400 \$I2078 \$I2138 \$I3077 VDD_DEC pfet_05v0 L=0.5U W=1.22U AS=0.3782P
+ AD=0.5368P PS=1.84U PD=3.32U
* device instance $1401 r0 *1 631.56,819.38 nfet_05v0
M$1401 \$I2078 \$I2205 VSS VSS nfet_05v0 L=0.6U W=0.36U AS=0.1584P AD=0.0936P
+ PS=1.6U PD=0.88U
* device instance $1402 r0 *1 632.68,819.38 nfet_05v0
M$1402 VSS \$I2215 \$I2078 VSS nfet_05v0 L=0.6U W=0.36U AS=0.0936P AD=0.0936P
+ PS=0.88U PD=0.88U
* device instance $1403 r0 *1 633.8,819.38 nfet_05v0
M$1403 \$I2078 \$I2287 VSS VSS nfet_05v0 L=0.6U W=0.36U AS=0.0936P AD=0.0936P
+ PS=0.88U PD=0.88U
* device instance $1404 r0 *1 634.92,819.38 nfet_05v0
M$1404 VSS \$I2138 \$I2078 VSS nfet_05v0 L=0.6U W=0.36U AS=0.0936P AD=0.1584P
+ PS=0.88U PD=1.6U
* device instance $1405 r0 *1 496.09,806.01 pfet_05v0
M$1405 \$I3082 \$I2323 VDD_DEC VDD_DEC pfet_05v0 L=0.5U W=1.22U AS=0.5368P
+ AD=0.3172P PS=3.32U PD=1.74U
* device instance $1406 r0 *1 497.11,806.01 pfet_05v0
M$1406 \$I3081 \$I2197 \$I3082 VDD_DEC pfet_05v0 L=0.5U W=1.22U AS=0.3172P
+ AD=0.3782P PS=1.74U PD=1.84U
* device instance $1407 r0 *1 498.23,806.01 pfet_05v0
M$1407 \$I3080 \$I2249 \$I3081 VDD_DEC pfet_05v0 L=0.5U W=1.22U AS=0.3782P
+ AD=0.3782P PS=1.84U PD=1.84U
* device instance $1408 r0 *1 499.35,806.01 pfet_05v0
M$1408 \$I2271 \$I2196 \$I3080 VDD_DEC pfet_05v0 L=0.5U W=1.22U AS=0.3782P
+ AD=0.5368P PS=1.84U PD=3.32U
* device instance $1409 r0 *1 496.04,803.7 nfet_05v0
M$1409 \$I2271 \$I2323 VSS VSS nfet_05v0 L=0.6U W=0.36U AS=0.1584P AD=0.0936P
+ PS=1.6U PD=0.88U
* device instance $1410 r0 *1 497.16,803.7 nfet_05v0
M$1410 VSS \$I2197 \$I2271 VSS nfet_05v0 L=0.6U W=0.36U AS=0.0936P AD=0.0936P
+ PS=0.88U PD=0.88U
* device instance $1411 r0 *1 498.28,803.7 nfet_05v0
M$1411 \$I2271 \$I2249 VSS VSS nfet_05v0 L=0.6U W=0.36U AS=0.0936P AD=0.0936P
+ PS=0.88U PD=0.88U
* device instance $1412 r0 *1 499.4,803.7 nfet_05v0
M$1412 VSS \$I2196 \$I2271 VSS nfet_05v0 L=0.6U W=0.36U AS=0.0936P AD=0.1584P
+ PS=0.88U PD=1.6U
* device instance $1413 r0 *1 547.61,821.69 pfet_05v0
M$1413 \$I3085 \$I2384 VDD_DEC VDD_DEC pfet_05v0 L=0.5U W=1.22U AS=0.5368P
+ AD=0.3172P PS=3.32U PD=1.74U
* device instance $1414 r0 *1 548.63,821.69 pfet_05v0
M$1414 \$I3084 \$I2354 \$I3085 VDD_DEC pfet_05v0 L=0.5U W=1.22U AS=0.3172P
+ AD=0.3782P PS=1.74U PD=1.84U
* device instance $1415 r0 *1 549.75,821.69 pfet_05v0
M$1415 \$I3083 \$I2322 \$I3084 VDD_DEC pfet_05v0 L=0.5U W=1.22U AS=0.3782P
+ AD=0.3782P PS=1.84U PD=1.84U
* device instance $1416 r0 *1 550.87,821.69 pfet_05v0
M$1416 \$I2335 \$I2353 \$I3083 VDD_DEC pfet_05v0 L=0.5U W=1.22U AS=0.3782P
+ AD=0.5368P PS=1.84U PD=3.32U
* device instance $1417 r0 *1 547.56,819.38 nfet_05v0
M$1417 \$I2335 \$I2384 VSS VSS nfet_05v0 L=0.6U W=0.36U AS=0.1584P AD=0.0936P
+ PS=1.6U PD=0.88U
* device instance $1418 r0 *1 548.68,819.38 nfet_05v0
M$1418 VSS \$I2354 \$I2335 VSS nfet_05v0 L=0.6U W=0.36U AS=0.0936P AD=0.0936P
+ PS=0.88U PD=0.88U
* device instance $1419 r0 *1 549.8,819.38 nfet_05v0
M$1419 \$I2335 \$I2322 VSS VSS nfet_05v0 L=0.6U W=0.36U AS=0.0936P AD=0.0936P
+ PS=0.88U PD=0.88U
* device instance $1420 r0 *1 550.92,819.38 nfet_05v0
M$1420 VSS \$I2353 \$I2335 VSS nfet_05v0 L=0.6U W=0.36U AS=0.0936P AD=0.1584P
+ PS=0.88U PD=1.6U
* device instance $1421 r0 *1 522.41,821.69 pfet_05v0
M$1421 \$I3088 \$I2330 VDD_DEC VDD_DEC pfet_05v0 L=0.5U W=1.22U AS=0.5368P
+ AD=0.3172P PS=3.32U PD=1.74U
* device instance $1422 r0 *1 523.43,821.69 pfet_05v0
M$1422 \$I3087 \$I2200 \$I3088 VDD_DEC pfet_05v0 L=0.5U W=1.22U AS=0.3172P
+ AD=0.3782P PS=1.74U PD=1.84U
* device instance $1423 r0 *1 524.55,821.69 pfet_05v0
M$1423 \$I3086 \$I2250 \$I3087 VDD_DEC pfet_05v0 L=0.5U W=1.22U AS=0.3782P
+ AD=0.3782P PS=1.84U PD=1.84U
* device instance $1424 r0 *1 525.67,821.69 pfet_05v0
M$1424 \$I2056 \$I2201 \$I3086 VDD_DEC pfet_05v0 L=0.5U W=1.22U AS=0.3782P
+ AD=0.5368P PS=1.84U PD=3.32U
* device instance $1425 r0 *1 522.36,819.38 nfet_05v0
M$1425 \$I2056 \$I2330 VSS VSS nfet_05v0 L=0.6U W=0.36U AS=0.1584P AD=0.0936P
+ PS=1.6U PD=0.88U
* device instance $1426 r0 *1 523.48,819.38 nfet_05v0
M$1426 VSS \$I2200 \$I2056 VSS nfet_05v0 L=0.6U W=0.36U AS=0.0936P AD=0.0936P
+ PS=0.88U PD=0.88U
* device instance $1427 r0 *1 524.6,819.38 nfet_05v0
M$1427 \$I2056 \$I2250 VSS VSS nfet_05v0 L=0.6U W=0.36U AS=0.0936P AD=0.0936P
+ PS=0.88U PD=0.88U
* device instance $1428 r0 *1 525.72,819.38 nfet_05v0
M$1428 VSS \$I2201 \$I2056 VSS nfet_05v0 L=0.6U W=0.36U AS=0.0936P AD=0.1584P
+ PS=0.88U PD=1.6U
* device instance $1429 r0 *1 528.01,821.69 pfet_05v0
M$1429 \$I3091 \$I2247 VDD_DEC VDD_DEC pfet_05v0 L=0.5U W=1.22U AS=0.5368P
+ AD=0.3172P PS=3.32U PD=1.74U
* device instance $1430 r0 *1 529.03,821.69 pfet_05v0
M$1430 \$I3090 \$I2200 \$I3091 VDD_DEC pfet_05v0 L=0.5U W=1.22U AS=0.3172P
+ AD=0.3782P PS=1.74U PD=1.84U
* device instance $1431 r0 *1 530.15,821.69 pfet_05v0
M$1431 \$I3089 \$I2250 \$I3090 VDD_DEC pfet_05v0 L=0.5U W=1.22U AS=0.3782P
+ AD=0.3782P PS=1.84U PD=1.84U
* device instance $1432 r0 *1 531.27,821.69 pfet_05v0
M$1432 \$I2275 \$I2201 \$I3089 VDD_DEC pfet_05v0 L=0.5U W=1.22U AS=0.3782P
+ AD=0.5368P PS=1.84U PD=3.32U
* device instance $1433 r0 *1 527.96,819.38 nfet_05v0
M$1433 \$I2275 \$I2247 VSS VSS nfet_05v0 L=0.6U W=0.36U AS=0.1584P AD=0.0936P
+ PS=1.6U PD=0.88U
* device instance $1434 r0 *1 529.08,819.38 nfet_05v0
M$1434 VSS \$I2200 \$I2275 VSS nfet_05v0 L=0.6U W=0.36U AS=0.0936P AD=0.0936P
+ PS=0.88U PD=0.88U
* device instance $1435 r0 *1 530.2,819.38 nfet_05v0
M$1435 \$I2275 \$I2250 VSS VSS nfet_05v0 L=0.6U W=0.36U AS=0.0936P AD=0.0936P
+ PS=0.88U PD=0.88U
* device instance $1436 r0 *1 531.32,819.38 nfet_05v0
M$1436 VSS \$I2201 \$I2275 VSS nfet_05v0 L=0.6U W=0.36U AS=0.0936P AD=0.1584P
+ PS=0.88U PD=1.6U
* device instance $1437 r0 *1 639.45,829.53 pfet_05v0
M$1437 \$I3094 \$I2166 VDD_DEC VDD_DEC pfet_05v0 L=0.5U W=1.22U AS=0.5368P
+ AD=0.3172P PS=3.32U PD=1.74U
* device instance $1438 r0 *1 640.47,829.53 pfet_05v0
M$1438 \$I3093 \$I2177 \$I3094 VDD_DEC pfet_05v0 L=0.5U W=1.22U AS=0.3172P
+ AD=0.3782P PS=1.74U PD=1.84U
* device instance $1439 r0 *1 641.59,829.53 pfet_05v0
M$1439 \$I3092 \$I2179 \$I3093 VDD_DEC pfet_05v0 L=0.5U W=1.22U AS=0.3782P
+ AD=0.3782P PS=1.84U PD=1.84U
* device instance $1440 r0 *1 642.71,829.53 pfet_05v0
M$1440 \$I2425 \$I2178 \$I3092 VDD_DEC pfet_05v0 L=0.5U W=1.22U AS=0.3782P
+ AD=0.5368P PS=1.84U PD=3.32U
* device instance $1441 r0 *1 639.4,827.22 nfet_05v0
M$1441 \$I2425 \$I2166 VSS VSS nfet_05v0 L=0.6U W=0.36U AS=0.1584P AD=0.0936P
+ PS=1.6U PD=0.88U
* device instance $1442 r0 *1 640.52,827.22 nfet_05v0
M$1442 VSS \$I2177 \$I2425 VSS nfet_05v0 L=0.6U W=0.36U AS=0.0936P AD=0.0936P
+ PS=0.88U PD=0.88U
* device instance $1443 r0 *1 641.64,827.22 nfet_05v0
M$1443 \$I2425 \$I2179 VSS VSS nfet_05v0 L=0.6U W=0.36U AS=0.0936P AD=0.0936P
+ PS=0.88U PD=0.88U
* device instance $1444 r0 *1 642.76,827.22 nfet_05v0
M$1444 VSS \$I2178 \$I2425 VSS nfet_05v0 L=0.6U W=0.36U AS=0.0936P AD=0.1584P
+ PS=0.88U PD=1.6U
* device instance $1445 r0 *1 594.65,806.01 pfet_05v0
M$1445 \$I3097 \$I2251 VDD_DEC VDD_DEC pfet_05v0 L=0.5U W=1.22U AS=0.5368P
+ AD=0.3172P PS=3.32U PD=1.74U
* device instance $1446 r0 *1 595.67,806.01 pfet_05v0
M$1446 \$I3096 \$I2311 \$I3097 VDD_DEC pfet_05v0 L=0.5U W=1.22U AS=0.3172P
+ AD=0.3782P PS=1.74U PD=1.84U
* device instance $1447 r0 *1 596.79,806.01 pfet_05v0
M$1447 \$I3095 \$I2284 \$I3096 VDD_DEC pfet_05v0 L=0.5U W=1.22U AS=0.3782P
+ AD=0.3782P PS=1.84U PD=1.84U
* device instance $1448 r0 *1 597.91,806.01 pfet_05v0
M$1448 \$I2071 \$I2252 \$I3095 VDD_DEC pfet_05v0 L=0.5U W=1.22U AS=0.3782P
+ AD=0.5368P PS=1.84U PD=3.32U
* device instance $1449 r0 *1 594.6,803.7 nfet_05v0
M$1449 \$I2071 \$I2251 VSS VSS nfet_05v0 L=0.6U W=0.36U AS=0.1584P AD=0.0936P
+ PS=1.6U PD=0.88U
* device instance $1450 r0 *1 595.72,803.7 nfet_05v0
M$1450 VSS \$I2311 \$I2071 VSS nfet_05v0 L=0.6U W=0.36U AS=0.0936P AD=0.0936P
+ PS=0.88U PD=0.88U
* device instance $1451 r0 *1 596.84,803.7 nfet_05v0
M$1451 \$I2071 \$I2284 VSS VSS nfet_05v0 L=0.6U W=0.36U AS=0.0936P AD=0.0936P
+ PS=0.88U PD=0.88U
* device instance $1452 r0 *1 597.96,803.7 nfet_05v0
M$1452 VSS \$I2252 \$I2071 VSS nfet_05v0 L=0.6U W=0.36U AS=0.0936P AD=0.1584P
+ PS=0.88U PD=1.6U
* device instance $1453 r0 *1 657.37,821.69 pfet_05v0
M$1453 \$I3100 \$I2274 VDD_DEC VDD_DEC pfet_05v0 L=0.5U W=1.22U AS=0.5368P
+ AD=0.3172P PS=3.32U PD=1.74U
* device instance $1454 r0 *1 658.39,821.69 pfet_05v0
M$1454 \$I3099 \$I2177 \$I3100 VDD_DEC pfet_05v0 L=0.5U W=1.22U AS=0.3172P
+ AD=0.3782P PS=1.74U PD=1.84U
* device instance $1455 r0 *1 659.51,821.69 pfet_05v0
M$1455 \$I3098 \$I2179 \$I3099 VDD_DEC pfet_05v0 L=0.5U W=1.22U AS=0.3782P
+ AD=0.3782P PS=1.84U PD=1.84U
* device instance $1456 r0 *1 660.63,821.69 pfet_05v0
M$1456 \$I2386 \$I2178 \$I3098 VDD_DEC pfet_05v0 L=0.5U W=1.22U AS=0.3782P
+ AD=0.5368P PS=1.84U PD=3.32U
* device instance $1457 r0 *1 657.32,819.38 nfet_05v0
M$1457 \$I2386 \$I2274 VSS VSS nfet_05v0 L=0.6U W=0.36U AS=0.1584P AD=0.0936P
+ PS=1.6U PD=0.88U
* device instance $1458 r0 *1 658.44,819.38 nfet_05v0
M$1458 VSS \$I2177 \$I2386 VSS nfet_05v0 L=0.6U W=0.36U AS=0.0936P AD=0.0936P
+ PS=0.88U PD=0.88U
* device instance $1459 r0 *1 659.56,819.38 nfet_05v0
M$1459 \$I2386 \$I2179 VSS VSS nfet_05v0 L=0.6U W=0.36U AS=0.0936P AD=0.0936P
+ PS=0.88U PD=0.88U
* device instance $1460 r0 *1 660.68,819.38 nfet_05v0
M$1460 VSS \$I2178 \$I2386 VSS nfet_05v0 L=0.6U W=0.36U AS=0.0936P AD=0.1584P
+ PS=0.88U PD=1.6U
* device instance $1461 r0 *1 665.21,782.49 pfet_05v0
M$1461 \$I3103 \$I2360 VDD_DEC VDD_DEC pfet_05v0 L=0.5U W=1.22U AS=0.5368P
+ AD=0.3172P PS=3.32U PD=1.74U
* device instance $1462 r0 *1 666.23,782.49 pfet_05v0
M$1462 \$I3102 \$I2140 \$I3103 VDD_DEC pfet_05v0 L=0.5U W=1.22U AS=0.3172P
+ AD=0.3782P PS=1.74U PD=1.84U
* device instance $1463 r0 *1 667.35,782.49 pfet_05v0
M$1463 \$I3101 \$I2179 \$I3102 VDD_DEC pfet_05v0 L=0.5U W=1.22U AS=0.3782P
+ AD=0.3782P PS=1.84U PD=1.84U
* device instance $1464 r0 *1 668.47,782.49 pfet_05v0
M$1464 \$I2081 \$I2138 \$I3101 VDD_DEC pfet_05v0 L=0.5U W=1.22U AS=0.3782P
+ AD=0.5368P PS=1.84U PD=3.32U
* device instance $1465 r0 *1 665.16,780.18 nfet_05v0
M$1465 \$I2081 \$I2360 VSS VSS nfet_05v0 L=0.6U W=0.36U AS=0.1584P AD=0.0936P
+ PS=1.6U PD=0.88U
* device instance $1466 r0 *1 666.28,780.18 nfet_05v0
M$1466 VSS \$I2140 \$I2081 VSS nfet_05v0 L=0.6U W=0.36U AS=0.0936P AD=0.0936P
+ PS=0.88U PD=0.88U
* device instance $1467 r0 *1 667.4,780.18 nfet_05v0
M$1467 \$I2081 \$I2179 VSS VSS nfet_05v0 L=0.6U W=0.36U AS=0.0936P AD=0.0936P
+ PS=0.88U PD=0.88U
* device instance $1468 r0 *1 668.52,780.18 nfet_05v0
M$1468 VSS \$I2138 \$I2081 VSS nfet_05v0 L=0.6U W=0.36U AS=0.0936P AD=0.1584P
+ PS=0.88U PD=1.6U
* device instance $1469 m0 *1 488.96,784.39 pfet_05v0
M$1469 VDD_DEC \$I3105 \$I3104 VDD_DEC pfet_05v0 L=1U W=1.22U AS=0.5368P
+ AD=0.5368P PS=3.32U PD=3.32U
* device instance $1470 m0 *1 488.96,786.61 nfet_05v0
M$1470 \$I3105 \$I3104 VSS VSS nfet_05v0 L=1U W=0.82U AS=0.3608P AD=0.3608P
+ PS=2.52U PD=2.52U
* device instance $1471 m0 *1 488.96,776.55 pfet_05v0
M$1471 VDD_DEC \$I3107 \$I3106 VDD_DEC pfet_05v0 L=1U W=1.22U AS=0.5368P
+ AD=0.5368P PS=3.32U PD=3.32U
* device instance $1472 m0 *1 488.96,778.77 nfet_05v0
M$1472 \$I3107 \$I3106 VSS VSS nfet_05v0 L=1U W=0.82U AS=0.3608P AD=0.3608P
+ PS=2.52U PD=2.52U
* device instance $1473 m0 *1 642.4,784.39 pfet_05v0
M$1473 VDD_DEC \$I3109 \$I3108 VDD_DEC pfet_05v0 L=1U W=1.22U AS=0.5368P
+ AD=0.5368P PS=3.32U PD=3.32U
* device instance $1474 m0 *1 642.4,786.61 nfet_05v0
M$1474 \$I3109 \$I3108 VSS VSS nfet_05v0 L=1U W=0.82U AS=0.3608P AD=0.3608P
+ PS=2.52U PD=2.52U
* device instance $1475 m0 *1 626.16,815.75 pfet_05v0
M$1475 VDD_DEC \$I3111 \$I3110 VDD_DEC pfet_05v0 L=1U W=1.22U AS=0.5368P
+ AD=0.5368P PS=3.32U PD=3.32U
* device instance $1476 m0 *1 626.16,817.97 nfet_05v0
M$1476 \$I3111 \$I3110 VSS VSS nfet_05v0 L=1U W=0.82U AS=0.3608P AD=0.3608P
+ PS=2.52U PD=2.52U
* device instance $1477 m0 *1 580.24,823.59 pfet_05v0
M$1477 VDD_DEC \$I3113 \$I3112 VDD_DEC pfet_05v0 L=1U W=1.22U AS=0.5368P
+ AD=0.5368P PS=3.32U PD=3.32U
* device instance $1478 m0 *1 580.24,825.81 nfet_05v0
M$1478 \$I3113 \$I3112 VSS VSS nfet_05v0 L=1U W=0.82U AS=0.3608P AD=0.3608P
+ PS=2.52U PD=2.52U
* device instance $1479 m0 *1 642.4,831.43 pfet_05v0
M$1479 VDD_DEC \$I3115 \$I3114 VDD_DEC pfet_05v0 L=1U W=1.22U AS=0.5368P
+ AD=0.5368P PS=3.32U PD=3.32U
* device instance $1480 m0 *1 642.4,833.65 nfet_05v0
M$1480 \$I3115 \$I3114 VSS VSS nfet_05v0 L=1U W=0.82U AS=0.3608P AD=0.3608P
+ PS=2.52U PD=2.52U
* device instance $1481 m0 *1 615.52,792.23 pfet_05v0
M$1481 VDD_DEC \$I3117 \$I3116 VDD_DEC pfet_05v0 L=1U W=1.22U AS=0.5368P
+ AD=0.5368P PS=3.32U PD=3.32U
* device instance $1482 m0 *1 615.52,794.45 nfet_05v0
M$1482 \$I3117 \$I3116 VSS VSS nfet_05v0 L=1U W=0.82U AS=0.3608P AD=0.3608P
+ PS=2.52U PD=2.52U
* device instance $1483 m0 *1 540.48,815.75 pfet_05v0
M$1483 VDD_DEC \$I3119 \$I3118 VDD_DEC pfet_05v0 L=1U W=1.22U AS=0.5368P
+ AD=0.5368P PS=3.32U PD=3.32U
* device instance $1484 m0 *1 540.48,817.97 nfet_05v0
M$1484 \$I3119 \$I3118 VSS VSS nfet_05v0 L=1U W=0.82U AS=0.3608P AD=0.3608P
+ PS=2.52U PD=2.52U
* device instance $1485 m0 *1 590.88,807.91 pfet_05v0
M$1485 VDD_DEC \$I3121 \$I3120 VDD_DEC pfet_05v0 L=1U W=1.22U AS=0.5368P
+ AD=0.5368P PS=3.32U PD=3.32U
* device instance $1486 m0 *1 590.88,810.13 nfet_05v0
M$1486 \$I3121 \$I3120 VSS VSS nfet_05v0 L=1U W=0.82U AS=0.3608P AD=0.3608P
+ PS=2.52U PD=2.52U
* device instance $1487 m0 *1 615.52,807.91 pfet_05v0
M$1487 VDD_DEC \$I3123 \$I3122 VDD_DEC pfet_05v0 L=1U W=1.22U AS=0.5368P
+ AD=0.5368P PS=3.32U PD=3.32U
* device instance $1488 m0 *1 615.52,810.13 nfet_05v0
M$1488 \$I3123 \$I3122 VSS VSS nfet_05v0 L=1U W=0.82U AS=0.3608P AD=0.3608P
+ PS=2.52U PD=2.52U
* device instance $1489 m0 *1 509.12,815.75 pfet_05v0
M$1489 VDD_DEC \$I3125 \$I3124 VDD_DEC pfet_05v0 L=1U W=1.22U AS=0.5368P
+ AD=0.5368P PS=3.32U PD=3.32U
* device instance $1490 m0 *1 509.12,817.97 nfet_05v0
M$1490 \$I3125 \$I3124 VSS VSS nfet_05v0 L=1U W=0.82U AS=0.3608P AD=0.3608P
+ PS=2.52U PD=2.52U
* device instance $1491 m0 *1 670.4,784.39 pfet_05v0
M$1491 VDD_DEC \$I3127 \$I3126 VDD_DEC pfet_05v0 L=1U W=1.22U AS=0.5368P
+ AD=0.5368P PS=3.32U PD=3.32U
* device instance $1492 m0 *1 670.4,786.61 nfet_05v0
M$1492 \$I3127 \$I3126 VSS VSS nfet_05v0 L=1U W=0.82U AS=0.3608P AD=0.3608P
+ PS=2.52U PD=2.52U
* device instance $1493 m0 *1 620.56,823.59 pfet_05v0
M$1493 VDD_DEC \$I3129 \$I3128 VDD_DEC pfet_05v0 L=1U W=1.22U AS=0.5368P
+ AD=0.5368P PS=3.32U PD=3.32U
* device instance $1494 m0 *1 620.56,825.81 nfet_05v0
M$1494 \$I3129 \$I3128 VSS VSS nfet_05v0 L=1U W=0.82U AS=0.3608P AD=0.3608P
+ PS=2.52U PD=2.52U
* device instance $1495 m0 *1 567.36,792.23 pfet_05v0
M$1495 VDD_DEC \$I3131 \$I3130 VDD_DEC pfet_05v0 L=1U W=1.22U AS=0.5368P
+ AD=0.5368P PS=3.32U PD=3.32U
* device instance $1496 m0 *1 567.36,794.45 nfet_05v0
M$1496 \$I3131 \$I3130 VSS VSS nfet_05v0 L=1U W=0.82U AS=0.3608P AD=0.3608P
+ PS=2.52U PD=2.52U
* device instance $1497 m0 *1 603.2,831.43 pfet_05v0
M$1497 VDD_DEC \$I3133 \$I3132 VDD_DEC pfet_05v0 L=1U W=1.22U AS=0.5368P
+ AD=0.5368P PS=3.32U PD=3.32U
* device instance $1498 m0 *1 603.2,833.65 nfet_05v0
M$1498 \$I3133 \$I3132 VSS VSS nfet_05v0 L=1U W=0.82U AS=0.3608P AD=0.3608P
+ PS=2.52U PD=2.52U
* device instance $1499 m0 *1 606.56,800.07 pfet_05v0
M$1499 VDD_DEC \$I3135 \$I3134 VDD_DEC pfet_05v0 L=1U W=1.22U AS=0.5368P
+ AD=0.5368P PS=3.32U PD=3.32U
* device instance $1500 m0 *1 606.56,802.29 nfet_05v0
M$1500 \$I3135 \$I3134 VSS VSS nfet_05v0 L=1U W=0.82U AS=0.3608P AD=0.3608P
+ PS=2.52U PD=2.52U
* device instance $1501 m0 *1 602.08,800.07 pfet_05v0
M$1501 VDD_DEC \$I3137 \$I3136 VDD_DEC pfet_05v0 L=1U W=1.22U AS=0.5368P
+ AD=0.5368P PS=3.32U PD=3.32U
* device instance $1502 m0 *1 602.08,802.29 nfet_05v0
M$1502 \$I3137 \$I3136 VSS VSS nfet_05v0 L=1U W=0.82U AS=0.3608P AD=0.3608P
+ PS=2.52U PD=2.52U
* device instance $1503 m0 *1 488.96,792.23 pfet_05v0
M$1503 VDD_DEC \$I3139 \$I3138 VDD_DEC pfet_05v0 L=1U W=1.22U AS=0.5368P
+ AD=0.5368P PS=3.32U PD=3.32U
* device instance $1504 m0 *1 488.96,794.45 nfet_05v0
M$1504 \$I3139 \$I3138 VSS VSS nfet_05v0 L=1U W=0.82U AS=0.3608P AD=0.3608P
+ PS=2.52U PD=2.52U
* device instance $1505 m0 *1 488.96,800.07 pfet_05v0
M$1505 VDD_DEC \$I3141 \$I3140 VDD_DEC pfet_05v0 L=1U W=1.22U AS=0.5368P
+ AD=0.5368P PS=3.32U PD=3.32U
* device instance $1506 m0 *1 488.96,802.29 nfet_05v0
M$1506 \$I3141 \$I3140 VSS VSS nfet_05v0 L=1U W=0.82U AS=0.3608P AD=0.3608P
+ PS=2.52U PD=2.52U
* device instance $1507 m0 *1 543.28,831.43 pfet_05v0
M$1507 VDD_DEC \$I3143 \$I3142 VDD_DEC pfet_05v0 L=1U W=1.22U AS=0.5368P
+ AD=0.5368P PS=3.32U PD=3.32U
* device instance $1508 m0 *1 543.28,833.65 nfet_05v0
M$1508 \$I3143 \$I3142 VSS VSS nfet_05v0 L=1U W=0.82U AS=0.3608P AD=0.3608P
+ PS=2.52U PD=2.52U
* device instance $1509 m0 *1 528.16,800.07 pfet_05v0
M$1509 VDD_DEC \$I3145 \$I3144 VDD_DEC pfet_05v0 L=1U W=1.22U AS=0.5368P
+ AD=0.5368P PS=3.32U PD=3.32U
* device instance $1510 m0 *1 528.16,802.29 nfet_05v0
M$1510 \$I3145 \$I3144 VSS VSS nfet_05v0 L=1U W=0.82U AS=0.3608P AD=0.3608P
+ PS=2.52U PD=2.52U
* device instance $1511 m0 *1 642.4,776.55 pfet_05v0
M$1511 VDD_DEC \$I3147 \$I3146 VDD_DEC pfet_05v0 L=1U W=1.22U AS=0.5368P
+ AD=0.5368P PS=3.32U PD=3.32U
* device instance $1512 m0 *1 642.4,778.77 nfet_05v0
M$1512 \$I3147 \$I3146 VSS VSS nfet_05v0 L=1U W=0.82U AS=0.3608P AD=0.3608P
+ PS=2.52U PD=2.52U
* device instance $1513 m0 *1 528.16,776.55 pfet_05v0
M$1513 VDD_DEC \$I3149 \$I3148 VDD_DEC pfet_05v0 L=1U W=1.22U AS=0.5368P
+ AD=0.5368P PS=3.32U PD=3.32U
* device instance $1514 m0 *1 528.16,778.77 nfet_05v0
M$1514 \$I3149 \$I3148 VSS VSS nfet_05v0 L=1U W=0.82U AS=0.3608P AD=0.3608P
+ PS=2.52U PD=2.52U
* device instance $1515 m0 *1 506.88,831.43 pfet_05v0
M$1515 VDD_DEC \$I3151 \$I3150 VDD_DEC pfet_05v0 L=1U W=1.22U AS=0.5368P
+ AD=0.5368P PS=3.32U PD=3.32U
* device instance $1516 m0 *1 506.88,833.65 nfet_05v0
M$1516 \$I3151 \$I3150 VSS VSS nfet_05v0 L=1U W=0.82U AS=0.3608P AD=0.3608P
+ PS=2.52U PD=2.52U
* device instance $1517 m0 *1 528.16,784.39 pfet_05v0
M$1517 VDD_DEC \$I3153 \$I3152 VDD_DEC pfet_05v0 L=1U W=1.22U AS=0.5368P
+ AD=0.5368P PS=3.32U PD=3.32U
* device instance $1518 m0 *1 528.16,786.61 nfet_05v0
M$1518 \$I3153 \$I3152 VSS VSS nfet_05v0 L=1U W=0.82U AS=0.3608P AD=0.3608P
+ PS=2.52U PD=2.52U
* device instance $1519 m0 *1 524.8,823.59 pfet_05v0
M$1519 VDD_DEC \$I3155 \$I3154 VDD_DEC pfet_05v0 L=1U W=1.22U AS=0.5368P
+ AD=0.5368P PS=3.32U PD=3.32U
* device instance $1520 m0 *1 524.8,825.81 nfet_05v0
M$1520 \$I3155 \$I3154 VSS VSS nfet_05v0 L=1U W=0.82U AS=0.3608P AD=0.3608P
+ PS=2.52U PD=2.52U
* device instance $1521 r0 *1 670.96,806.01 pfet_05v0
M$1521 VDD_DEC \$I3157 \$I3156 VDD_DEC pfet_05v0 L=1U W=1.22U AS=0.5368P
+ AD=0.5368P PS=3.32U PD=3.32U
* device instance $1522 r0 *1 670.96,803.79 nfet_05v0
M$1522 \$I3157 \$I3156 VSS VSS nfet_05v0 L=1U W=0.82U AS=0.3608P AD=0.3608P
+ PS=2.52U PD=2.52U
* device instance $1523 r0 *1 592.56,806.01 pfet_05v0
M$1523 VDD_DEC \$I3159 \$I3158 VDD_DEC pfet_05v0 L=1U W=1.22U AS=0.5368P
+ AD=0.5368P PS=3.32U PD=3.32U
* device instance $1524 r0 *1 592.56,803.79 nfet_05v0
M$1524 \$I3159 \$I3158 VSS VSS nfet_05v0 L=1U W=0.82U AS=0.3608P AD=0.3608P
+ PS=2.52U PD=2.52U
* device instance $1525 r0 *1 669.84,813.85 pfet_05v0
M$1525 VDD_DEC \$I3161 \$I3160 VDD_DEC pfet_05v0 L=1U W=1.22U AS=0.5368P
+ AD=0.5368P PS=3.32U PD=3.32U
* device instance $1526 r0 *1 669.84,811.63 nfet_05v0
M$1526 \$I3161 \$I3160 VSS VSS nfet_05v0 L=1U W=0.82U AS=0.3608P AD=0.3608P
+ PS=2.52U PD=2.52U
* device instance $1527 r0 *1 600.4,806.01 pfet_05v0
M$1527 VDD_DEC \$I3163 \$I3162 VDD_DEC pfet_05v0 L=1U W=1.22U AS=0.5368P
+ AD=0.5368P PS=3.32U PD=3.32U
* device instance $1528 r0 *1 600.4,803.79 nfet_05v0
M$1528 \$I3163 \$I3162 VSS VSS nfet_05v0 L=1U W=0.82U AS=0.3608P AD=0.3608P
+ PS=2.52U PD=2.52U
* device instance $1529 r0 *1 493.44,821.69 pfet_05v0
M$1529 VDD_DEC \$I3165 \$I3164 VDD_DEC pfet_05v0 L=1U W=1.22U AS=0.5368P
+ AD=0.5368P PS=3.32U PD=3.32U
* device instance $1530 r0 *1 493.44,819.47 nfet_05v0
M$1530 \$I3165 \$I3164 VSS VSS nfet_05v0 L=1U W=0.82U AS=0.3608P AD=0.3608P
+ PS=2.52U PD=2.52U
* device instance $1531 r0 *1 564.56,806.01 pfet_05v0
M$1531 VDD_DEC \$I3167 \$I3166 VDD_DEC pfet_05v0 L=1U W=1.22U AS=0.5368P
+ AD=0.5368P PS=3.32U PD=3.32U
* device instance $1532 r0 *1 564.56,803.79 nfet_05v0
M$1532 \$I3167 \$I3166 VSS VSS nfet_05v0 L=1U W=0.82U AS=0.3608P AD=0.3608P
+ PS=2.52U PD=2.52U
* device instance $1533 r0 *1 622.24,813.85 pfet_05v0
M$1533 VDD_DEC \$I3169 \$I3168 VDD_DEC pfet_05v0 L=1U W=1.22U AS=0.5368P
+ AD=0.5368P PS=3.32U PD=3.32U
* device instance $1534 r0 *1 622.24,811.63 nfet_05v0
M$1534 \$I3169 \$I3168 VSS VSS nfet_05v0 L=1U W=0.82U AS=0.3608P AD=0.3608P
+ PS=2.52U PD=2.52U
* device instance $1535 r0 *1 660.32,837.37 pfet_05v0
M$1535 VDD_DEC \$I3171 \$I3170 VDD_DEC pfet_05v0 L=1U W=1.22U AS=0.5368P
+ AD=0.5368P PS=3.32U PD=3.32U
* device instance $1536 r0 *1 660.32,835.15 nfet_05v0
M$1536 \$I3171 \$I3170 VSS VSS nfet_05v0 L=1U W=0.82U AS=0.3608P AD=0.3608P
+ PS=2.52U PD=2.52U
* device instance $1537 r0 *1 669.84,829.53 pfet_05v0
M$1537 VDD_DEC \$I3173 \$I3172 VDD_DEC pfet_05v0 L=1U W=1.22U AS=0.5368P
+ AD=0.5368P PS=3.32U PD=3.32U
* device instance $1538 r0 *1 669.84,827.31 nfet_05v0
M$1538 \$I3173 \$I3172 VSS VSS nfet_05v0 L=1U W=0.82U AS=0.3608P AD=0.3608P
+ PS=2.52U PD=2.52U
* device instance $1539 r0 *1 616.64,821.69 pfet_05v0
M$1539 VDD_DEC \$I3175 \$I3174 VDD_DEC pfet_05v0 L=1U W=1.22U AS=0.5368P
+ AD=0.5368P PS=3.32U PD=3.32U
* device instance $1540 r0 *1 616.64,819.47 nfet_05v0
M$1540 \$I3175 \$I3174 VSS VSS nfet_05v0 L=1U W=0.82U AS=0.3608P AD=0.3608P
+ PS=2.52U PD=2.52U
* device instance $1541 r0 *1 618.32,837.37 pfet_05v0
M$1541 VDD_DEC \$I3177 \$I3176 VDD_DEC pfet_05v0 L=1U W=1.22U AS=0.5368P
+ AD=0.5368P PS=3.32U PD=3.32U
* device instance $1542 r0 *1 618.32,835.15 nfet_05v0
M$1542 \$I3177 \$I3176 VSS VSS nfet_05v0 L=1U W=0.82U AS=0.3608P AD=0.3608P
+ PS=2.52U PD=2.52U
* device instance $1543 r0 *1 590.32,821.69 pfet_05v0
M$1543 VDD_DEC \$I3179 \$I3178 VDD_DEC pfet_05v0 L=1U W=1.22U AS=0.5368P
+ AD=0.5368P PS=3.32U PD=3.32U
* device instance $1544 r0 *1 590.32,819.47 nfet_05v0
M$1544 \$I3179 \$I3178 VSS VSS nfet_05v0 L=1U W=0.82U AS=0.3608P AD=0.3608P
+ PS=2.52U PD=2.52U
* device instance $1545 r0 *1 621.68,829.53 pfet_05v0
M$1545 VDD_DEC \$I3181 \$I3180 VDD_DEC pfet_05v0 L=1U W=1.22U AS=0.5368P
+ AD=0.5368P PS=3.32U PD=3.32U
* device instance $1546 r0 *1 621.68,827.31 nfet_05v0
M$1546 \$I3181 \$I3180 VSS VSS nfet_05v0 L=1U W=0.82U AS=0.3608P AD=0.3608P
+ PS=2.52U PD=2.52U
* device instance $1547 r0 *1 614.96,829.53 pfet_05v0
M$1547 VDD_DEC \$I3183 \$I3182 VDD_DEC pfet_05v0 L=1U W=1.22U AS=0.5368P
+ AD=0.5368P PS=3.32U PD=3.32U
* device instance $1548 r0 *1 614.96,827.31 nfet_05v0
M$1548 \$I3183 \$I3182 VSS VSS nfet_05v0 L=1U W=0.82U AS=0.3608P AD=0.3608P
+ PS=2.52U PD=2.52U
* device instance $1549 r0 *1 669.84,821.69 pfet_05v0
M$1549 VDD_DEC \$I3185 \$I3184 VDD_DEC pfet_05v0 L=1U W=1.22U AS=0.5368P
+ AD=0.5368P PS=3.32U PD=3.32U
* device instance $1550 r0 *1 669.84,819.47 nfet_05v0
M$1550 \$I3185 \$I3184 VSS VSS nfet_05v0 L=1U W=0.82U AS=0.3608P AD=0.3608P
+ PS=2.52U PD=2.52U
* device instance $1551 r0 *1 556.72,806.01 pfet_05v0
M$1551 VDD_DEC \$I3187 \$I3186 VDD_DEC pfet_05v0 L=1U W=1.22U AS=0.5368P
+ AD=0.5368P PS=3.32U PD=3.32U
* device instance $1552 r0 *1 556.72,803.79 nfet_05v0
M$1552 \$I3187 \$I3186 VSS VSS nfet_05v0 L=1U W=0.82U AS=0.3608P AD=0.3608P
+ PS=2.52U PD=2.52U
* device instance $1553 r0 *1 547.76,790.33 pfet_05v0
M$1553 VDD_DEC \$I3189 \$I3188 VDD_DEC pfet_05v0 L=1U W=1.22U AS=0.5368P
+ AD=0.5368P PS=3.32U PD=3.32U
* device instance $1554 r0 *1 547.76,788.11 nfet_05v0
M$1554 \$I3189 \$I3188 VSS VSS nfet_05v0 L=1U W=0.82U AS=0.3608P AD=0.3608P
+ PS=2.52U PD=2.52U
* device instance $1555 r0 *1 586.96,782.49 pfet_05v0
M$1555 VDD_DEC \$I3191 \$I3190 VDD_DEC pfet_05v0 L=1U W=1.22U AS=0.5368P
+ AD=0.5368P PS=3.32U PD=3.32U
* device instance $1556 r0 *1 586.96,780.27 nfet_05v0
M$1556 \$I3191 \$I3190 VSS VSS nfet_05v0 L=1U W=0.82U AS=0.3608P AD=0.3608P
+ PS=2.52U PD=2.52U
* device instance $1557 r0 *1 582.48,798.17 pfet_05v0
M$1557 VDD_DEC \$I3193 \$I3192 VDD_DEC pfet_05v0 L=1U W=1.22U AS=0.5368P
+ AD=0.5368P PS=3.32U PD=3.32U
* device instance $1558 r0 *1 582.48,795.95 nfet_05v0
M$1558 \$I3193 \$I3192 VSS VSS nfet_05v0 L=1U W=0.82U AS=0.3608P AD=0.3608P
+ PS=2.52U PD=2.52U
* device instance $1559 r0 *1 670.96,798.17 pfet_05v0
M$1559 VDD_DEC \$I3195 \$I3194 VDD_DEC pfet_05v0 L=1U W=1.22U AS=0.5368P
+ AD=0.5368P PS=3.32U PD=3.32U
* device instance $1560 r0 *1 670.96,795.95 nfet_05v0
M$1560 \$I3195 \$I3194 VSS VSS nfet_05v0 L=1U W=0.82U AS=0.3608P AD=0.3608P
+ PS=2.52U PD=2.52U
* device instance $1561 r0 *1 669.28,774.65 pfet_05v0
M$1561 VDD_DEC \$I3197 \$I3196 VDD_DEC pfet_05v0 L=1U W=1.22U AS=0.5368P
+ AD=0.5368P PS=3.32U PD=3.32U
* device instance $1562 r0 *1 669.28,772.43 nfet_05v0
M$1562 \$I3197 \$I3196 VSS VSS nfet_05v0 L=1U W=0.82U AS=0.3608P AD=0.3608P
+ PS=2.52U PD=2.52U
* device instance $1563 r0 *1 662,782.49 pfet_05v0
M$1563 VDD_DEC \$I3199 \$I3198 VDD_DEC pfet_05v0 L=1U W=1.22U AS=0.5368P
+ AD=0.5368P PS=3.32U PD=3.32U
* device instance $1564 r0 *1 662,780.27 nfet_05v0
M$1564 \$I3199 \$I3198 VSS VSS nfet_05v0 L=1U W=0.82U AS=0.3608P AD=0.3608P
+ PS=2.52U PD=2.52U
* device instance $1565 r0 *1 508.56,829.53 pfet_05v0
M$1565 VDD_DEC \$I3201 \$I3200 VDD_DEC pfet_05v0 L=1U W=1.22U AS=0.5368P
+ AD=0.5368P PS=3.32U PD=3.32U
* device instance $1566 r0 *1 508.56,827.31 nfet_05v0
M$1566 \$I3201 \$I3200 VSS VSS nfet_05v0 L=1U W=0.82U AS=0.3608P AD=0.3608P
+ PS=2.52U PD=2.52U
* device instance $1567 r0 *1 493.44,837.37 pfet_05v0
M$1567 VDD_DEC \$I3203 \$I3202 VDD_DEC pfet_05v0 L=1U W=1.22U AS=0.5368P
+ AD=0.5368P PS=3.32U PD=3.32U
* device instance $1568 r0 *1 493.44,835.15 nfet_05v0
M$1568 \$I3203 \$I3202 VSS VSS nfet_05v0 L=1U W=0.82U AS=0.3608P AD=0.3608P
+ PS=2.52U PD=2.52U
* device instance $1569 r0 *1 592.56,790.33 pfet_05v0
M$1569 VDD_DEC \$I3205 \$I3204 VDD_DEC pfet_05v0 L=1U W=1.22U AS=0.5368P
+ AD=0.5368P PS=3.32U PD=3.32U
* device instance $1570 r0 *1 592.56,788.11 nfet_05v0
M$1570 \$I3205 \$I3204 VSS VSS nfet_05v0 L=1U W=0.82U AS=0.3608P AD=0.3608P
+ PS=2.52U PD=2.52U
* device instance $1571 r0 *1 508.56,790.33 pfet_05v0
M$1571 VDD_DEC \$I3207 \$I3206 VDD_DEC pfet_05v0 L=1U W=1.22U AS=0.5368P
+ AD=0.5368P PS=3.32U PD=3.32U
* device instance $1572 r0 *1 508.56,788.11 nfet_05v0
M$1572 \$I3207 \$I3206 VSS VSS nfet_05v0 L=1U W=0.82U AS=0.3608P AD=0.3608P
+ PS=2.52U PD=2.52U
* device instance $1573 r0 *1 644.08,790.33 pfet_05v0
M$1573 VDD_DEC \$I3209 \$I3208 VDD_DEC pfet_05v0 L=1U W=1.22U AS=0.5368P
+ AD=0.5368P PS=3.32U PD=3.32U
* device instance $1574 r0 *1 644.08,788.11 nfet_05v0
M$1574 \$I3209 \$I3208 VSS VSS nfet_05v0 L=1U W=0.82U AS=0.3608P AD=0.3608P
+ PS=2.52U PD=2.52U
* device instance $1575 r0 *1 508.56,782.49 pfet_05v0
M$1575 VDD_DEC \$I3211 \$I3210 VDD_DEC pfet_05v0 L=1U W=1.22U AS=0.5368P
+ AD=0.5368P PS=3.32U PD=3.32U
* device instance $1576 r0 *1 508.56,780.27 nfet_05v0
M$1576 \$I3211 \$I3210 VSS VSS nfet_05v0 L=1U W=0.82U AS=0.3608P AD=0.3608P
+ PS=2.52U PD=2.52U
* device instance $1577 r0 *1 550.56,837.37 pfet_05v0
M$1577 VDD_DEC \$I3213 \$I3212 VDD_DEC pfet_05v0 L=1U W=1.22U AS=0.5368P
+ AD=0.5368P PS=3.32U PD=3.32U
* device instance $1578 r0 *1 550.56,835.15 nfet_05v0
M$1578 \$I3213 \$I3212 VSS VSS nfet_05v0 L=1U W=0.82U AS=0.3608P AD=0.3608P
+ PS=2.52U PD=2.52U
* device instance $1579 r0 *1 488.96,798.17 pfet_05v0
M$1579 VDD_DEC \$I3215 \$I3214 VDD_DEC pfet_05v0 L=1U W=1.22U AS=0.5368P
+ AD=0.5368P PS=3.32U PD=3.32U
* device instance $1580 r0 *1 488.96,795.95 nfet_05v0
M$1580 \$I3215 \$I3214 VSS VSS nfet_05v0 L=1U W=0.82U AS=0.3608P AD=0.3608P
+ PS=2.52U PD=2.52U
* device instance $1581 r0 *1 670.96,782.49 pfet_05v0
M$1581 VDD_DEC \$I3217 \$I3216 VDD_DEC pfet_05v0 L=1U W=1.22U AS=0.5368P
+ AD=0.5368P PS=3.32U PD=3.32U
* device instance $1582 r0 *1 670.96,780.27 nfet_05v0
M$1582 \$I3217 \$I3216 VSS VSS nfet_05v0 L=1U W=0.82U AS=0.3608P AD=0.3608P
+ PS=2.52U PD=2.52U
* device instance $1583 r0 *1 571.28,829.53 pfet_05v0
M$1583 VDD_DEC \$I3219 \$I3218 VDD_DEC pfet_05v0 L=1U W=1.22U AS=0.5368P
+ AD=0.5368P PS=3.32U PD=3.32U
* device instance $1584 r0 *1 571.28,827.31 nfet_05v0
M$1584 \$I3219 \$I3218 VSS VSS nfet_05v0 L=1U W=0.82U AS=0.3608P AD=0.3608P
+ PS=2.52U PD=2.52U
* device instance $1585 r0 *1 547.76,782.49 pfet_05v0
M$1585 VDD_DEC \$I3221 \$I3220 VDD_DEC pfet_05v0 L=1U W=1.22U AS=0.5368P
+ AD=0.5368P PS=3.32U PD=3.32U
* device instance $1586 r0 *1 547.76,780.27 nfet_05v0
M$1586 \$I3221 \$I3220 VSS VSS nfet_05v0 L=1U W=0.82U AS=0.3608P AD=0.3608P
+ PS=2.52U PD=2.52U
* device instance $1587 r0 *1 571.28,821.69 pfet_05v0
M$1587 VDD_DEC \$I3223 \$I3222 VDD_DEC pfet_05v0 L=1U W=1.22U AS=0.5368P
+ AD=0.5368P PS=3.32U PD=3.32U
* device instance $1588 r0 *1 571.28,819.47 nfet_05v0
M$1588 \$I3223 \$I3222 VSS VSS nfet_05v0 L=1U W=0.82U AS=0.3608P AD=0.3608P
+ PS=2.52U PD=2.52U
* device instance $1589 r0 *1 670.96,790.33 pfet_05v0
M$1589 VDD_DEC \$I3225 \$I3224 VDD_DEC pfet_05v0 L=1U W=1.22U AS=0.5368P
+ AD=0.5368P PS=3.32U PD=3.32U
* device instance $1590 r0 *1 670.96,788.11 nfet_05v0
M$1590 \$I3225 \$I3224 VSS VSS nfet_05v0 L=1U W=0.82U AS=0.3608P AD=0.3608P
+ PS=2.52U PD=2.52U
* device instance $1591 r0 *1 544.4,821.69 pfet_05v0
M$1591 VDD_DEC \$I3227 \$I3226 VDD_DEC pfet_05v0 L=1U W=1.22U AS=0.5368P
+ AD=0.5368P PS=3.32U PD=3.32U
* device instance $1592 r0 *1 544.4,819.47 nfet_05v0
M$1592 \$I3227 \$I3226 VSS VSS nfet_05v0 L=1U W=0.82U AS=0.3608P AD=0.3608P
+ PS=2.52U PD=2.52U
* device instance $1593 r0 *1 584.16,774.65 pfet_05v0
M$1593 VDD_DEC \$I3229 \$I3228 VDD_DEC pfet_05v0 L=1U W=1.22U AS=0.5368P
+ AD=0.5368P PS=3.32U PD=3.32U
* device instance $1594 r0 *1 584.16,772.43 nfet_05v0
M$1594 \$I3229 \$I3228 VSS VSS nfet_05v0 L=1U W=0.82U AS=0.3608P AD=0.3608P
+ PS=2.52U PD=2.52U
* device instance $1595 r0 *1 502.745,798.49 pfet_05v0
M$1595 \$I3236 \$I3231 \$I3232 VDD_DEC pfet_05v0 L=0.5U W=0.36U AS=0.3456P
+ AD=0.0612P PS=2.64U PD=0.7U
* device instance $1596 r0 *1 503.585,798.49 pfet_05v0
M$1596 \$I3236 \$I3231 VDD_DEC VDD_DEC pfet_05v0 L=0.5U W=0.36U AS=0.379P
+ AD=0.0612P PS=2.37U PD=0.7U
* device instance $1597 r0 *1 505.235,798.17 pfet_05v0
M$1597 \$266 \$I3232 VDD_DEC VDD_DEC pfet_05v0 L=0.5U W=1.22U AS=0.379P
+ AD=0.5368P PS=2.37U PD=3.32U
* device instance $1598 r0 *1 498.505,798.6 pfet_05v0
M$1598 VDD_DEC \$I2248 \$I3230 VDD_DEC pfet_05v0 L=0.5U W=0.36U AS=0.3852P
+ AD=0.1116P PS=2.86U PD=0.98U
* device instance $1599 r0 *1 499.625,798.6 pfet_05v0
M$1599 \$I3235 \$I3230 VDD_DEC VDD_DEC pfet_05v0 L=0.5U W=0.36U AS=0.1116P
+ AD=0.0612P PS=0.98U PD=0.7U
* device instance $1600 r0 *1 500.465,798.6 pfet_05v0
M$1600 \$I3235 \$I3230 \$I3231 VDD_DEC pfet_05v0 L=0.5U W=0.36U AS=0.3852P
+ AD=0.0612P PS=2.86U PD=0.7U
* device instance $1601 r0 *1 502.795,795.722 nfet_05v0
M$1601 \$I3234 \$I3231 \$I3232 VSS nfet_05v0 L=0.6U W=0.365U AS=0.3705P
+ AD=0.0438P PS=2.77U PD=0.605U
* device instance $1602 r0 *1 503.635,795.722 nfet_05v0
M$1602 VSS \$I3231 \$I3234 VSS nfet_05v0 L=0.6U W=0.365U AS=0.0438P
+ AD=0.282625P PS=0.605U PD=1.87U
* device instance $1603 r0 *1 505.285,795.95 nfet_05v0
M$1603 \$266 \$I3232 VSS VSS nfet_05v0 L=0.6U W=0.82U AS=0.282625P AD=0.3608P
+ PS=1.87U PD=2.52U
* device instance $1604 r0 *1 498.555,795.72 nfet_05v0
M$1604 VSS \$I2248 \$I3230 VSS nfet_05v0 L=0.6U W=0.36U AS=0.333P AD=0.0936P
+ PS=2.57U PD=0.88U
* device instance $1605 r0 *1 499.675,795.72 nfet_05v0
M$1605 \$I3233 \$I3230 VSS VSS nfet_05v0 L=0.6U W=0.36U AS=0.0936P AD=0.0432P
+ PS=0.88U PD=0.6U
* device instance $1606 r0 *1 500.515,795.72 nfet_05v0
M$1606 \$I3231 \$I3230 \$I3233 VSS nfet_05v0 L=0.6U W=0.36U AS=0.0432P
+ AD=0.369P PS=0.6U PD=2.77U
* device instance $1607 r0 *1 515.065,806.33 pfet_05v0
M$1607 \$I3243 \$I3238 \$I3239 VDD_DEC pfet_05v0 L=0.5U W=0.36U AS=0.3456P
+ AD=0.0612P PS=2.64U PD=0.7U
* device instance $1608 r0 *1 515.905,806.33 pfet_05v0
M$1608 \$I3243 \$I3238 VDD_DEC VDD_DEC pfet_05v0 L=0.5U W=0.36U AS=0.379P
+ AD=0.0612P PS=2.37U PD=0.7U
* device instance $1609 r0 *1 517.555,806.01 pfet_05v0
M$1609 \$269 \$I3239 VDD_DEC VDD_DEC pfet_05v0 L=0.5U W=1.22U AS=0.379P
+ AD=0.5368P PS=2.37U PD=3.32U
* device instance $1610 r0 *1 510.825,806.44 pfet_05v0
M$1610 VDD_DEC \$I2306 \$I3237 VDD_DEC pfet_05v0 L=0.5U W=0.36U AS=0.3852P
+ AD=0.1116P PS=2.86U PD=0.98U
* device instance $1611 r0 *1 511.945,806.44 pfet_05v0
M$1611 \$I3242 \$I3237 VDD_DEC VDD_DEC pfet_05v0 L=0.5U W=0.36U AS=0.1116P
+ AD=0.0612P PS=0.98U PD=0.7U
* device instance $1612 r0 *1 512.785,806.44 pfet_05v0
M$1612 \$I3242 \$I3237 \$I3238 VDD_DEC pfet_05v0 L=0.5U W=0.36U AS=0.3852P
+ AD=0.0612P PS=2.86U PD=0.7U
* device instance $1613 r0 *1 515.115,803.562 nfet_05v0
M$1613 \$I3241 \$I3238 \$I3239 VSS nfet_05v0 L=0.6U W=0.365U AS=0.3705P
+ AD=0.0438P PS=2.77U PD=0.605U
* device instance $1614 r0 *1 515.955,803.562 nfet_05v0
M$1614 VSS \$I3238 \$I3241 VSS nfet_05v0 L=0.6U W=0.365U AS=0.0438P
+ AD=0.282625P PS=0.605U PD=1.87U
* device instance $1615 r0 *1 517.605,803.79 nfet_05v0
M$1615 \$269 \$I3239 VSS VSS nfet_05v0 L=0.6U W=0.82U AS=0.282625P AD=0.3608P
+ PS=1.87U PD=2.52U
* device instance $1616 r0 *1 510.875,803.56 nfet_05v0
M$1616 VSS \$I2306 \$I3237 VSS nfet_05v0 L=0.6U W=0.36U AS=0.333P AD=0.0936P
+ PS=2.57U PD=0.88U
* device instance $1617 r0 *1 511.995,803.56 nfet_05v0
M$1617 \$I3240 \$I3237 VSS VSS nfet_05v0 L=0.6U W=0.36U AS=0.0936P AD=0.0432P
+ PS=0.88U PD=0.6U
* device instance $1618 r0 *1 512.835,803.56 nfet_05v0
M$1618 \$I3238 \$I3237 \$I3240 VSS nfet_05v0 L=0.6U W=0.36U AS=0.0432P
+ AD=0.369P PS=0.6U PD=2.77U
* device instance $1619 m0 *1 513.385,799.75 pfet_05v0
M$1619 \$I3250 \$I3245 \$I3246 VDD_DEC pfet_05v0 L=0.5U W=0.36U AS=0.3456P
+ AD=0.0612P PS=2.64U PD=0.7U
* device instance $1620 m0 *1 514.225,799.75 pfet_05v0
M$1620 \$I3250 \$I3245 VDD_DEC VDD_DEC pfet_05v0 L=0.5U W=0.36U AS=0.379P
+ AD=0.0612P PS=2.37U PD=0.7U
* device instance $1621 m0 *1 515.875,800.07 pfet_05v0
M$1621 \$271 \$I3246 VDD_DEC VDD_DEC pfet_05v0 L=0.5U W=1.22U AS=0.379P
+ AD=0.5368P PS=2.37U PD=3.32U
* device instance $1622 m0 *1 509.145,799.64 pfet_05v0
M$1622 VDD_DEC \$I2272 \$I3244 VDD_DEC pfet_05v0 L=0.5U W=0.36U AS=0.3852P
+ AD=0.1116P PS=2.86U PD=0.98U
* device instance $1623 m0 *1 510.265,799.64 pfet_05v0
M$1623 \$I3249 \$I3244 VDD_DEC VDD_DEC pfet_05v0 L=0.5U W=0.36U AS=0.1116P
+ AD=0.0612P PS=0.98U PD=0.7U
* device instance $1624 m0 *1 511.105,799.64 pfet_05v0
M$1624 \$I3249 \$I3244 \$I3245 VDD_DEC pfet_05v0 L=0.5U W=0.36U AS=0.3852P
+ AD=0.0612P PS=2.86U PD=0.7U
* device instance $1625 m0 *1 513.435,802.518 nfet_05v0
M$1625 \$I3248 \$I3245 \$I3246 VSS nfet_05v0 L=0.6U W=0.365U AS=0.3705P
+ AD=0.0438P PS=2.77U PD=0.605U
* device instance $1626 m0 *1 514.275,802.518 nfet_05v0
M$1626 VSS \$I3245 \$I3248 VSS nfet_05v0 L=0.6U W=0.365U AS=0.0438P
+ AD=0.282625P PS=0.605U PD=1.87U
* device instance $1627 m0 *1 515.925,802.29 nfet_05v0
M$1627 \$271 \$I3246 VSS VSS nfet_05v0 L=0.6U W=0.82U AS=0.282625P AD=0.3608P
+ PS=1.87U PD=2.52U
* device instance $1628 m0 *1 509.195,802.52 nfet_05v0
M$1628 VSS \$I2272 \$I3244 VSS nfet_05v0 L=0.6U W=0.36U AS=0.333P AD=0.0936P
+ PS=2.57U PD=0.88U
* device instance $1629 m0 *1 510.315,802.52 nfet_05v0
M$1629 \$I3247 \$I3244 VSS VSS nfet_05v0 L=0.6U W=0.36U AS=0.0936P AD=0.0432P
+ PS=0.88U PD=0.6U
* device instance $1630 m0 *1 511.155,802.52 nfet_05v0
M$1630 \$I3245 \$I3244 \$I3247 VSS nfet_05v0 L=0.6U W=0.36U AS=0.0432P
+ AD=0.369P PS=0.6U PD=2.77U
* device instance $1631 m90 *1 522.215,806.33 pfet_05v0
M$1631 \$I3257 \$I3252 \$I3253 VDD_DEC pfet_05v0 L=0.5U W=0.36U AS=0.3456P
+ AD=0.0612P PS=2.64U PD=0.7U
* device instance $1632 m90 *1 521.375,806.33 pfet_05v0
M$1632 \$I3257 \$I3252 VDD_DEC VDD_DEC pfet_05v0 L=0.5U W=0.36U AS=0.379P
+ AD=0.0612P PS=2.37U PD=0.7U
* device instance $1633 m90 *1 519.725,806.01 pfet_05v0
M$1633 \$275 \$I3253 VDD_DEC VDD_DEC pfet_05v0 L=0.5U W=1.22U AS=0.379P
+ AD=0.5368P PS=2.37U PD=3.32U
* device instance $1634 m90 *1 526.455,806.44 pfet_05v0
M$1634 VDD_DEC \$I2304 \$I3251 VDD_DEC pfet_05v0 L=0.5U W=0.36U AS=0.3852P
+ AD=0.1116P PS=2.86U PD=0.98U
* device instance $1635 m90 *1 525.335,806.44 pfet_05v0
M$1635 \$I3256 \$I3251 VDD_DEC VDD_DEC pfet_05v0 L=0.5U W=0.36U AS=0.1116P
+ AD=0.0612P PS=0.98U PD=0.7U
* device instance $1636 m90 *1 524.495,806.44 pfet_05v0
M$1636 \$I3256 \$I3251 \$I3252 VDD_DEC pfet_05v0 L=0.5U W=0.36U AS=0.3852P
+ AD=0.0612P PS=2.86U PD=0.7U
* device instance $1637 m90 *1 522.165,803.562 nfet_05v0
M$1637 \$I3255 \$I3252 \$I3253 VSS nfet_05v0 L=0.6U W=0.365U AS=0.3705P
+ AD=0.0438P PS=2.77U PD=0.605U
* device instance $1638 m90 *1 521.325,803.562 nfet_05v0
M$1638 VSS \$I3252 \$I3255 VSS nfet_05v0 L=0.6U W=0.365U AS=0.0438P
+ AD=0.282625P PS=0.605U PD=1.87U
* device instance $1639 m90 *1 519.675,803.79 nfet_05v0
M$1639 \$275 \$I3253 VSS VSS nfet_05v0 L=0.6U W=0.82U AS=0.282625P AD=0.3608P
+ PS=1.87U PD=2.52U
* device instance $1640 m90 *1 526.405,803.56 nfet_05v0
M$1640 VSS \$I2304 \$I3251 VSS nfet_05v0 L=0.6U W=0.36U AS=0.333P AD=0.0936P
+ PS=2.57U PD=0.88U
* device instance $1641 m90 *1 525.285,803.56 nfet_05v0
M$1641 \$I3254 \$I3251 VSS VSS nfet_05v0 L=0.6U W=0.36U AS=0.0936P AD=0.0432P
+ PS=0.88U PD=0.6U
* device instance $1642 m90 *1 524.445,803.56 nfet_05v0
M$1642 \$I3252 \$I3251 \$I3254 VSS nfet_05v0 L=0.6U W=0.36U AS=0.0432P
+ AD=0.369P PS=0.6U PD=2.77U
* device instance $1643 m0 *1 522.345,799.75 pfet_05v0
M$1643 \$I3264 \$I3259 \$I3260 VDD_DEC pfet_05v0 L=0.5U W=0.36U AS=0.3456P
+ AD=0.0612P PS=2.64U PD=0.7U
* device instance $1644 m0 *1 523.185,799.75 pfet_05v0
M$1644 \$I3264 \$I3259 VDD_DEC VDD_DEC pfet_05v0 L=0.5U W=0.36U AS=0.379P
+ AD=0.0612P PS=2.37U PD=0.7U
* device instance $1645 m0 *1 524.835,800.07 pfet_05v0
M$1645 \$278 \$I3260 VDD_DEC VDD_DEC pfet_05v0 L=0.5U W=1.22U AS=0.379P
+ AD=0.5368P PS=2.37U PD=3.32U
* device instance $1646 m0 *1 518.105,799.64 pfet_05v0
M$1646 VDD_DEC \$I2271 \$I3258 VDD_DEC pfet_05v0 L=0.5U W=0.36U AS=0.3852P
+ AD=0.1116P PS=2.86U PD=0.98U
* device instance $1647 m0 *1 519.225,799.64 pfet_05v0
M$1647 \$I3263 \$I3258 VDD_DEC VDD_DEC pfet_05v0 L=0.5U W=0.36U AS=0.1116P
+ AD=0.0612P PS=0.98U PD=0.7U
* device instance $1648 m0 *1 520.065,799.64 pfet_05v0
M$1648 \$I3263 \$I3258 \$I3259 VDD_DEC pfet_05v0 L=0.5U W=0.36U AS=0.3852P
+ AD=0.0612P PS=2.86U PD=0.7U
* device instance $1649 m0 *1 522.395,802.518 nfet_05v0
M$1649 \$I3262 \$I3259 \$I3260 VSS nfet_05v0 L=0.6U W=0.365U AS=0.3705P
+ AD=0.0438P PS=2.77U PD=0.605U
* device instance $1650 m0 *1 523.235,802.518 nfet_05v0
M$1650 VSS \$I3259 \$I3262 VSS nfet_05v0 L=0.6U W=0.365U AS=0.0438P
+ AD=0.282625P PS=0.605U PD=1.87U
* device instance $1651 m0 *1 524.885,802.29 nfet_05v0
M$1651 \$278 \$I3260 VSS VSS nfet_05v0 L=0.6U W=0.82U AS=0.282625P AD=0.3608P
+ PS=1.87U PD=2.52U
* device instance $1652 m0 *1 518.155,802.52 nfet_05v0
M$1652 VSS \$I2271 \$I3258 VSS nfet_05v0 L=0.6U W=0.36U AS=0.333P AD=0.0936P
+ PS=2.57U PD=0.88U
* device instance $1653 m0 *1 519.275,802.52 nfet_05v0
M$1653 \$I3261 \$I3258 VSS VSS nfet_05v0 L=0.6U W=0.36U AS=0.0936P AD=0.0432P
+ PS=0.88U PD=0.6U
* device instance $1654 m0 *1 520.115,802.52 nfet_05v0
M$1654 \$I3259 \$I3258 \$I3261 VSS nfet_05v0 L=0.6U W=0.36U AS=0.0432P
+ AD=0.369P PS=0.6U PD=2.77U
* device instance $1655 r0 *1 524.025,798.49 pfet_05v0
M$1655 \$I3271 \$I3266 \$I3267 VDD_DEC pfet_05v0 L=0.5U W=0.36U AS=0.3456P
+ AD=0.0612P PS=2.64U PD=0.7U
* device instance $1656 r0 *1 524.865,798.49 pfet_05v0
M$1656 \$I3271 \$I3266 VDD_DEC VDD_DEC pfet_05v0 L=0.5U W=0.36U AS=0.379P
+ AD=0.0612P PS=2.37U PD=0.7U
* device instance $1657 r0 *1 526.515,798.17 pfet_05v0
M$1657 \$280 \$I3267 VDD_DEC VDD_DEC pfet_05v0 L=0.5U W=1.22U AS=0.379P
+ AD=0.5368P PS=2.37U PD=3.32U
* device instance $1658 r0 *1 519.785,798.6 pfet_05v0
M$1658 VDD_DEC \$I2233 \$I3265 VDD_DEC pfet_05v0 L=0.5U W=0.36U AS=0.3852P
+ AD=0.1116P PS=2.86U PD=0.98U
* device instance $1659 r0 *1 520.905,798.6 pfet_05v0
M$1659 \$I3270 \$I3265 VDD_DEC VDD_DEC pfet_05v0 L=0.5U W=0.36U AS=0.1116P
+ AD=0.0612P PS=0.98U PD=0.7U
* device instance $1660 r0 *1 521.745,798.6 pfet_05v0
M$1660 \$I3270 \$I3265 \$I3266 VDD_DEC pfet_05v0 L=0.5U W=0.36U AS=0.3852P
+ AD=0.0612P PS=2.86U PD=0.7U
* device instance $1661 r0 *1 524.075,795.722 nfet_05v0
M$1661 \$I3269 \$I3266 \$I3267 VSS nfet_05v0 L=0.6U W=0.365U AS=0.3705P
+ AD=0.0438P PS=2.77U PD=0.605U
* device instance $1662 r0 *1 524.915,795.722 nfet_05v0
M$1662 VSS \$I3266 \$I3269 VSS nfet_05v0 L=0.6U W=0.365U AS=0.0438P
+ AD=0.282625P PS=0.605U PD=1.87U
* device instance $1663 r0 *1 526.565,795.95 nfet_05v0
M$1663 \$280 \$I3267 VSS VSS nfet_05v0 L=0.6U W=0.82U AS=0.282625P AD=0.3608P
+ PS=1.87U PD=2.52U
* device instance $1664 r0 *1 519.835,795.72 nfet_05v0
M$1664 VSS \$I2233 \$I3265 VSS nfet_05v0 L=0.6U W=0.36U AS=0.333P AD=0.0936P
+ PS=2.57U PD=0.88U
* device instance $1665 r0 *1 520.955,795.72 nfet_05v0
M$1665 \$I3268 \$I3265 VSS VSS nfet_05v0 L=0.6U W=0.36U AS=0.0936P AD=0.0432P
+ PS=0.88U PD=0.6U
* device instance $1666 r0 *1 521.795,795.72 nfet_05v0
M$1666 \$I3266 \$I3265 \$I3268 VSS nfet_05v0 L=0.6U W=0.36U AS=0.0432P
+ AD=0.369P PS=0.6U PD=2.77U
* device instance $1667 m90 *1 531.175,806.33 pfet_05v0
M$1667 \$I3278 \$I3273 \$I3274 VDD_DEC pfet_05v0 L=0.5U W=0.36U AS=0.3456P
+ AD=0.0612P PS=2.64U PD=0.7U
* device instance $1668 m90 *1 530.335,806.33 pfet_05v0
M$1668 \$I3278 \$I3273 VDD_DEC VDD_DEC pfet_05v0 L=0.5U W=0.36U AS=0.379P
+ AD=0.0612P PS=2.37U PD=0.7U
* device instance $1669 m90 *1 528.685,806.01 pfet_05v0
M$1669 \$151 \$I3274 VDD_DEC VDD_DEC pfet_05v0 L=0.5U W=1.22U AS=0.379P
+ AD=0.5368P PS=2.37U PD=3.32U
* device instance $1670 m90 *1 535.415,806.44 pfet_05v0
M$1670 VDD_DEC \$I2273 \$I3272 VDD_DEC pfet_05v0 L=0.5U W=0.36U AS=0.3852P
+ AD=0.1116P PS=2.86U PD=0.98U
* device instance $1671 m90 *1 534.295,806.44 pfet_05v0
M$1671 \$I3277 \$I3272 VDD_DEC VDD_DEC pfet_05v0 L=0.5U W=0.36U AS=0.1116P
+ AD=0.0612P PS=0.98U PD=0.7U
* device instance $1672 m90 *1 533.455,806.44 pfet_05v0
M$1672 \$I3277 \$I3272 \$I3273 VDD_DEC pfet_05v0 L=0.5U W=0.36U AS=0.3852P
+ AD=0.0612P PS=2.86U PD=0.7U
* device instance $1673 m90 *1 531.125,803.562 nfet_05v0
M$1673 \$I3276 \$I3273 \$I3274 VSS nfet_05v0 L=0.6U W=0.365U AS=0.3705P
+ AD=0.0438P PS=2.77U PD=0.605U
* device instance $1674 m90 *1 530.285,803.562 nfet_05v0
M$1674 VSS \$I3273 \$I3276 VSS nfet_05v0 L=0.6U W=0.365U AS=0.0438P
+ AD=0.282625P PS=0.605U PD=1.87U
* device instance $1675 m90 *1 528.635,803.79 nfet_05v0
M$1675 \$151 \$I3274 VSS VSS nfet_05v0 L=0.6U W=0.82U AS=0.282625P AD=0.3608P
+ PS=1.87U PD=2.52U
* device instance $1676 m90 *1 535.365,803.56 nfet_05v0
M$1676 VSS \$I2273 \$I3272 VSS nfet_05v0 L=0.6U W=0.36U AS=0.333P AD=0.0936P
+ PS=2.57U PD=0.88U
* device instance $1677 m90 *1 534.245,803.56 nfet_05v0
M$1677 \$I3275 \$I3272 VSS VSS nfet_05v0 L=0.6U W=0.36U AS=0.0936P AD=0.0432P
+ PS=0.88U PD=0.6U
* device instance $1678 m90 *1 533.405,803.56 nfet_05v0
M$1678 \$I3273 \$I3272 \$I3275 VSS nfet_05v0 L=0.6U W=0.36U AS=0.0432P
+ AD=0.369P PS=0.6U PD=2.77U
* device instance $1679 m0 *1 534.665,799.75 pfet_05v0
M$1679 \$I3285 \$I3280 \$I3281 VDD_DEC pfet_05v0 L=0.5U W=0.36U AS=0.3456P
+ AD=0.0612P PS=2.64U PD=0.7U
* device instance $1680 m0 *1 535.505,799.75 pfet_05v0
M$1680 \$I3285 \$I3280 VDD_DEC VDD_DEC pfet_05v0 L=0.5U W=0.36U AS=0.379P
+ AD=0.0612P PS=2.37U PD=0.7U
* device instance $1681 m0 *1 537.155,800.07 pfet_05v0
M$1681 \$163 \$I3281 VDD_DEC VDD_DEC pfet_05v0 L=0.5U W=1.22U AS=0.379P
+ AD=0.5368P PS=2.37U PD=3.32U
* device instance $1682 m0 *1 530.425,799.64 pfet_05v0
M$1682 VDD_DEC \$I2275 \$I3279 VDD_DEC pfet_05v0 L=0.5U W=0.36U AS=0.3852P
+ AD=0.1116P PS=2.86U PD=0.98U
* device instance $1683 m0 *1 531.545,799.64 pfet_05v0
M$1683 \$I3284 \$I3279 VDD_DEC VDD_DEC pfet_05v0 L=0.5U W=0.36U AS=0.1116P
+ AD=0.0612P PS=0.98U PD=0.7U
* device instance $1684 m0 *1 532.385,799.64 pfet_05v0
M$1684 \$I3284 \$I3279 \$I3280 VDD_DEC pfet_05v0 L=0.5U W=0.36U AS=0.3852P
+ AD=0.0612P PS=2.86U PD=0.7U
* device instance $1685 m0 *1 534.715,802.518 nfet_05v0
M$1685 \$I3283 \$I3280 \$I3281 VSS nfet_05v0 L=0.6U W=0.365U AS=0.3705P
+ AD=0.0438P PS=2.77U PD=0.605U
* device instance $1686 m0 *1 535.555,802.518 nfet_05v0
M$1686 VSS \$I3280 \$I3283 VSS nfet_05v0 L=0.6U W=0.365U AS=0.0438P
+ AD=0.282625P PS=0.605U PD=1.87U
* device instance $1687 m0 *1 537.205,802.29 nfet_05v0
M$1687 \$163 \$I3281 VSS VSS nfet_05v0 L=0.6U W=0.82U AS=0.282625P AD=0.3608P
+ PS=1.87U PD=2.52U
* device instance $1688 m0 *1 530.475,802.52 nfet_05v0
M$1688 VSS \$I2275 \$I3279 VSS nfet_05v0 L=0.6U W=0.36U AS=0.333P AD=0.0936P
+ PS=2.57U PD=0.88U
* device instance $1689 m0 *1 531.595,802.52 nfet_05v0
M$1689 \$I3282 \$I3279 VSS VSS nfet_05v0 L=0.6U W=0.36U AS=0.0936P AD=0.0432P
+ PS=0.88U PD=0.6U
* device instance $1690 m0 *1 532.435,802.52 nfet_05v0
M$1690 \$I3280 \$I3279 \$I3282 VSS nfet_05v0 L=0.6U W=0.36U AS=0.0432P
+ AD=0.369P PS=0.6U PD=2.77U
* device instance $1691 r0 *1 532.985,798.49 pfet_05v0
M$1691 \$I3292 \$I3287 \$I3288 VDD_DEC pfet_05v0 L=0.5U W=0.36U AS=0.3456P
+ AD=0.0612P PS=2.64U PD=0.7U
* device instance $1692 r0 *1 533.825,798.49 pfet_05v0
M$1692 \$I3292 \$I3287 VDD_DEC VDD_DEC pfet_05v0 L=0.5U W=0.36U AS=0.379P
+ AD=0.0612P PS=2.37U PD=0.7U
* device instance $1693 r0 *1 535.475,798.17 pfet_05v0
M$1693 \$169 \$I3288 VDD_DEC VDD_DEC pfet_05v0 L=0.5U W=1.22U AS=0.379P
+ AD=0.5368P PS=2.37U PD=3.32U
* device instance $1694 r0 *1 528.745,798.6 pfet_05v0
M$1694 VDD_DEC \$I2235 \$I3286 VDD_DEC pfet_05v0 L=0.5U W=0.36U AS=0.3852P
+ AD=0.1116P PS=2.86U PD=0.98U
* device instance $1695 r0 *1 529.865,798.6 pfet_05v0
M$1695 \$I3291 \$I3286 VDD_DEC VDD_DEC pfet_05v0 L=0.5U W=0.36U AS=0.1116P
+ AD=0.0612P PS=0.98U PD=0.7U
* device instance $1696 r0 *1 530.705,798.6 pfet_05v0
M$1696 \$I3291 \$I3286 \$I3287 VDD_DEC pfet_05v0 L=0.5U W=0.36U AS=0.3852P
+ AD=0.0612P PS=2.86U PD=0.7U
* device instance $1697 r0 *1 533.035,795.722 nfet_05v0
M$1697 \$I3290 \$I3287 \$I3288 VSS nfet_05v0 L=0.6U W=0.365U AS=0.3705P
+ AD=0.0438P PS=2.77U PD=0.605U
* device instance $1698 r0 *1 533.875,795.722 nfet_05v0
M$1698 VSS \$I3287 \$I3290 VSS nfet_05v0 L=0.6U W=0.365U AS=0.0438P
+ AD=0.282625P PS=0.605U PD=1.87U
* device instance $1699 r0 *1 535.525,795.95 nfet_05v0
M$1699 \$169 \$I3288 VSS VSS nfet_05v0 L=0.6U W=0.82U AS=0.282625P AD=0.3608P
+ PS=1.87U PD=2.52U
* device instance $1700 r0 *1 528.795,795.72 nfet_05v0
M$1700 VSS \$I2235 \$I3286 VSS nfet_05v0 L=0.6U W=0.36U AS=0.333P AD=0.0936P
+ PS=2.57U PD=0.88U
* device instance $1701 r0 *1 529.915,795.72 nfet_05v0
M$1701 \$I3289 \$I3286 VSS VSS nfet_05v0 L=0.6U W=0.36U AS=0.0936P AD=0.0432P
+ PS=0.88U PD=0.6U
* device instance $1702 r0 *1 530.755,795.72 nfet_05v0
M$1702 \$I3287 \$I3286 \$I3289 VSS nfet_05v0 L=0.6U W=0.36U AS=0.0432P
+ AD=0.369P PS=0.6U PD=2.77U
* device instance $1703 m90 *1 540.135,806.33 pfet_05v0
M$1703 \$I3299 \$I3294 \$I3295 VDD_DEC pfet_05v0 L=0.5U W=0.36U AS=0.3456P
+ AD=0.0612P PS=2.64U PD=0.7U
* device instance $1704 m90 *1 539.295,806.33 pfet_05v0
M$1704 \$I3299 \$I3294 VDD_DEC VDD_DEC pfet_05v0 L=0.5U W=0.36U AS=0.379P
+ AD=0.0612P PS=2.37U PD=0.7U
* device instance $1705 m90 *1 537.645,806.01 pfet_05v0
M$1705 \$178 \$I3295 VDD_DEC VDD_DEC pfet_05v0 L=0.5U W=1.22U AS=0.379P
+ AD=0.5368P PS=2.37U PD=3.32U
* device instance $1706 m90 *1 544.375,806.44 pfet_05v0
M$1706 VDD_DEC \$I2307 \$I3293 VDD_DEC pfet_05v0 L=0.5U W=0.36U AS=0.3852P
+ AD=0.1116P PS=2.86U PD=0.98U
* device instance $1707 m90 *1 543.255,806.44 pfet_05v0
M$1707 \$I3298 \$I3293 VDD_DEC VDD_DEC pfet_05v0 L=0.5U W=0.36U AS=0.1116P
+ AD=0.0612P PS=0.98U PD=0.7U
* device instance $1708 m90 *1 542.415,806.44 pfet_05v0
M$1708 \$I3298 \$I3293 \$I3294 VDD_DEC pfet_05v0 L=0.5U W=0.36U AS=0.3852P
+ AD=0.0612P PS=2.86U PD=0.7U
* device instance $1709 m90 *1 540.085,803.562 nfet_05v0
M$1709 \$I3297 \$I3294 \$I3295 VSS nfet_05v0 L=0.6U W=0.365U AS=0.3705P
+ AD=0.0438P PS=2.77U PD=0.605U
* device instance $1710 m90 *1 539.245,803.562 nfet_05v0
M$1710 VSS \$I3294 \$I3297 VSS nfet_05v0 L=0.6U W=0.365U AS=0.0438P
+ AD=0.282625P PS=0.605U PD=1.87U
* device instance $1711 m90 *1 537.595,803.79 nfet_05v0
M$1711 \$178 \$I3295 VSS VSS nfet_05v0 L=0.6U W=0.82U AS=0.282625P AD=0.3608P
+ PS=1.87U PD=2.52U
* device instance $1712 m90 *1 544.325,803.56 nfet_05v0
M$1712 VSS \$I2307 \$I3293 VSS nfet_05v0 L=0.6U W=0.36U AS=0.333P AD=0.0936P
+ PS=2.57U PD=0.88U
* device instance $1713 m90 *1 543.205,803.56 nfet_05v0
M$1713 \$I3296 \$I3293 VSS VSS nfet_05v0 L=0.6U W=0.36U AS=0.0936P AD=0.0432P
+ PS=0.88U PD=0.6U
* device instance $1714 m90 *1 542.365,803.56 nfet_05v0
M$1714 \$I3294 \$I3293 \$I3296 VSS nfet_05v0 L=0.6U W=0.36U AS=0.0432P
+ AD=0.369P PS=0.6U PD=2.77U
* device instance $1715 m0 *1 543.625,799.75 pfet_05v0
M$1715 \$I3306 \$I3301 \$I3302 VDD_DEC pfet_05v0 L=0.5U W=0.36U AS=0.3456P
+ AD=0.0612P PS=2.64U PD=0.7U
* device instance $1716 m0 *1 544.465,799.75 pfet_05v0
M$1716 \$I3306 \$I3301 VDD_DEC VDD_DEC pfet_05v0 L=0.5U W=0.36U AS=0.379P
+ AD=0.0612P PS=2.37U PD=0.7U
* device instance $1717 m0 *1 546.115,800.07 pfet_05v0
M$1717 \$187 \$I3302 VDD_DEC VDD_DEC pfet_05v0 L=0.5U W=1.22U AS=0.379P
+ AD=0.5368P PS=2.37U PD=3.32U
* device instance $1718 m0 *1 539.385,799.64 pfet_05v0
M$1718 VDD_DEC \$I2276 \$I3300 VDD_DEC pfet_05v0 L=0.5U W=0.36U AS=0.3852P
+ AD=0.1116P PS=2.86U PD=0.98U
* device instance $1719 m0 *1 540.505,799.64 pfet_05v0
M$1719 \$I3305 \$I3300 VDD_DEC VDD_DEC pfet_05v0 L=0.5U W=0.36U AS=0.1116P
+ AD=0.0612P PS=0.98U PD=0.7U
* device instance $1720 m0 *1 541.345,799.64 pfet_05v0
M$1720 \$I3305 \$I3300 \$I3301 VDD_DEC pfet_05v0 L=0.5U W=0.36U AS=0.3852P
+ AD=0.0612P PS=2.86U PD=0.7U
* device instance $1721 m0 *1 543.675,802.518 nfet_05v0
M$1721 \$I3304 \$I3301 \$I3302 VSS nfet_05v0 L=0.6U W=0.365U AS=0.3705P
+ AD=0.0438P PS=2.77U PD=0.605U
* device instance $1722 m0 *1 544.515,802.518 nfet_05v0
M$1722 VSS \$I3301 \$I3304 VSS nfet_05v0 L=0.6U W=0.365U AS=0.0438P
+ AD=0.282625P PS=0.605U PD=1.87U
* device instance $1723 m0 *1 546.165,802.29 nfet_05v0
M$1723 \$187 \$I3302 VSS VSS nfet_05v0 L=0.6U W=0.82U AS=0.282625P AD=0.3608P
+ PS=1.87U PD=2.52U
* device instance $1724 m0 *1 539.435,802.52 nfet_05v0
M$1724 VSS \$I2276 \$I3300 VSS nfet_05v0 L=0.6U W=0.36U AS=0.333P AD=0.0936P
+ PS=2.57U PD=0.88U
* device instance $1725 m0 *1 540.555,802.52 nfet_05v0
M$1725 \$I3303 \$I3300 VSS VSS nfet_05v0 L=0.6U W=0.36U AS=0.0936P AD=0.0432P
+ PS=0.88U PD=0.6U
* device instance $1726 m0 *1 541.395,802.52 nfet_05v0
M$1726 \$I3301 \$I3300 \$I3303 VSS nfet_05v0 L=0.6U W=0.36U AS=0.0432P
+ AD=0.369P PS=0.6U PD=2.77U
* device instance $1727 r0 *1 541.945,798.49 pfet_05v0
M$1727 \$I3313 \$I3308 \$I3309 VDD_DEC pfet_05v0 L=0.5U W=0.36U AS=0.3456P
+ AD=0.0612P PS=2.64U PD=0.7U
* device instance $1728 r0 *1 542.785,798.49 pfet_05v0
M$1728 \$I3313 \$I3308 VDD_DEC VDD_DEC pfet_05v0 L=0.5U W=0.36U AS=0.379P
+ AD=0.0612P PS=2.37U PD=0.7U
* device instance $1729 r0 *1 544.435,798.17 pfet_05v0
M$1729 \$146 \$I3309 VDD_DEC VDD_DEC pfet_05v0 L=0.5U W=1.22U AS=0.379P
+ AD=0.5368P PS=2.37U PD=3.32U
* device instance $1730 r0 *1 537.705,798.6 pfet_05v0
M$1730 VDD_DEC \$I2236 \$I3307 VDD_DEC pfet_05v0 L=0.5U W=0.36U AS=0.3852P
+ AD=0.1116P PS=2.86U PD=0.98U
* device instance $1731 r0 *1 538.825,798.6 pfet_05v0
M$1731 \$I3312 \$I3307 VDD_DEC VDD_DEC pfet_05v0 L=0.5U W=0.36U AS=0.1116P
+ AD=0.0612P PS=0.98U PD=0.7U
* device instance $1732 r0 *1 539.665,798.6 pfet_05v0
M$1732 \$I3312 \$I3307 \$I3308 VDD_DEC pfet_05v0 L=0.5U W=0.36U AS=0.3852P
+ AD=0.0612P PS=2.86U PD=0.7U
* device instance $1733 r0 *1 541.995,795.722 nfet_05v0
M$1733 \$I3311 \$I3308 \$I3309 VSS nfet_05v0 L=0.6U W=0.365U AS=0.3705P
+ AD=0.0438P PS=2.77U PD=0.605U
* device instance $1734 r0 *1 542.835,795.722 nfet_05v0
M$1734 VSS \$I3308 \$I3311 VSS nfet_05v0 L=0.6U W=0.365U AS=0.0438P
+ AD=0.282625P PS=0.605U PD=1.87U
* device instance $1735 r0 *1 544.485,795.95 nfet_05v0
M$1735 \$146 \$I3309 VSS VSS nfet_05v0 L=0.6U W=0.82U AS=0.282625P AD=0.3608P
+ PS=1.87U PD=2.52U
* device instance $1736 r0 *1 537.755,795.72 nfet_05v0
M$1736 VSS \$I2236 \$I3307 VSS nfet_05v0 L=0.6U W=0.36U AS=0.333P AD=0.0936P
+ PS=2.57U PD=0.88U
* device instance $1737 r0 *1 538.875,795.72 nfet_05v0
M$1737 \$I3310 \$I3307 VSS VSS nfet_05v0 L=0.6U W=0.36U AS=0.0936P AD=0.0432P
+ PS=0.88U PD=0.6U
* device instance $1738 r0 *1 539.715,795.72 nfet_05v0
M$1738 \$I3308 \$I3307 \$I3310 VSS nfet_05v0 L=0.6U W=0.36U AS=0.0432P
+ AD=0.369P PS=0.6U PD=2.77U
* device instance $1739 m90 *1 550.215,806.33 pfet_05v0
M$1739 \$I3320 \$I3315 \$I3316 VDD_DEC pfet_05v0 L=0.5U W=0.36U AS=0.3456P
+ AD=0.0612P PS=2.64U PD=0.7U
* device instance $1740 m90 *1 549.375,806.33 pfet_05v0
M$1740 \$I3320 \$I3315 VDD_DEC VDD_DEC pfet_05v0 L=0.5U W=0.36U AS=0.379P
+ AD=0.0612P PS=2.37U PD=0.7U
* device instance $1741 m90 *1 547.725,806.01 pfet_05v0
M$1741 \$149 \$I3316 VDD_DEC VDD_DEC pfet_05v0 L=0.5U W=1.22U AS=0.379P
+ AD=0.5368P PS=2.37U PD=3.32U
* device instance $1742 m90 *1 554.455,806.44 pfet_05v0
M$1742 VDD_DEC \$I2309 \$I3314 VDD_DEC pfet_05v0 L=0.5U W=0.36U AS=0.3852P
+ AD=0.1116P PS=2.86U PD=0.98U
* device instance $1743 m90 *1 553.335,806.44 pfet_05v0
M$1743 \$I3319 \$I3314 VDD_DEC VDD_DEC pfet_05v0 L=0.5U W=0.36U AS=0.1116P
+ AD=0.0612P PS=0.98U PD=0.7U
* device instance $1744 m90 *1 552.495,806.44 pfet_05v0
M$1744 \$I3319 \$I3314 \$I3315 VDD_DEC pfet_05v0 L=0.5U W=0.36U AS=0.3852P
+ AD=0.0612P PS=2.86U PD=0.7U
* device instance $1745 m90 *1 550.165,803.562 nfet_05v0
M$1745 \$I3318 \$I3315 \$I3316 VSS nfet_05v0 L=0.6U W=0.365U AS=0.3705P
+ AD=0.0438P PS=2.77U PD=0.605U
* device instance $1746 m90 *1 549.325,803.562 nfet_05v0
M$1746 VSS \$I3315 \$I3318 VSS nfet_05v0 L=0.6U W=0.365U AS=0.0438P
+ AD=0.282625P PS=0.605U PD=1.87U
* device instance $1747 m90 *1 547.675,803.79 nfet_05v0
M$1747 \$149 \$I3316 VSS VSS nfet_05v0 L=0.6U W=0.82U AS=0.282625P AD=0.3608P
+ PS=1.87U PD=2.52U
* device instance $1748 m90 *1 554.405,803.56 nfet_05v0
M$1748 VSS \$I2309 \$I3314 VSS nfet_05v0 L=0.6U W=0.36U AS=0.333P AD=0.0936P
+ PS=2.57U PD=0.88U
* device instance $1749 m90 *1 553.285,803.56 nfet_05v0
M$1749 \$I3317 \$I3314 VSS VSS nfet_05v0 L=0.6U W=0.36U AS=0.0936P AD=0.0432P
+ PS=0.88U PD=0.6U
* device instance $1750 m90 *1 552.445,803.56 nfet_05v0
M$1750 \$I3315 \$I3314 \$I3317 VSS nfet_05v0 L=0.6U W=0.36U AS=0.0432P
+ AD=0.369P PS=0.6U PD=2.77U
* device instance $1751 m0 *1 552.585,799.75 pfet_05v0
M$1751 \$I3327 \$I3322 \$I3323 VDD_DEC pfet_05v0 L=0.5U W=0.36U AS=0.3456P
+ AD=0.0612P PS=2.64U PD=0.7U
* device instance $1752 m0 *1 553.425,799.75 pfet_05v0
M$1752 \$I3327 \$I3322 VDD_DEC VDD_DEC pfet_05v0 L=0.5U W=0.36U AS=0.379P
+ AD=0.0612P PS=2.37U PD=0.7U
* device instance $1753 m0 *1 555.075,800.07 pfet_05v0
M$1753 \$161 \$I3323 VDD_DEC VDD_DEC pfet_05v0 L=0.5U W=1.22U AS=0.379P
+ AD=0.5368P PS=2.37U PD=3.32U
* device instance $1754 m0 *1 548.345,799.64 pfet_05v0
M$1754 VDD_DEC \$I2278 \$I3321 VDD_DEC pfet_05v0 L=0.5U W=0.36U AS=0.3852P
+ AD=0.1116P PS=2.86U PD=0.98U
* device instance $1755 m0 *1 549.465,799.64 pfet_05v0
M$1755 \$I3326 \$I3321 VDD_DEC VDD_DEC pfet_05v0 L=0.5U W=0.36U AS=0.1116P
+ AD=0.0612P PS=0.98U PD=0.7U
* device instance $1756 m0 *1 550.305,799.64 pfet_05v0
M$1756 \$I3326 \$I3321 \$I3322 VDD_DEC pfet_05v0 L=0.5U W=0.36U AS=0.3852P
+ AD=0.0612P PS=2.86U PD=0.7U
* device instance $1757 m0 *1 552.635,802.518 nfet_05v0
M$1757 \$I3325 \$I3322 \$I3323 VSS nfet_05v0 L=0.6U W=0.365U AS=0.3705P
+ AD=0.0438P PS=2.77U PD=0.605U
* device instance $1758 m0 *1 553.475,802.518 nfet_05v0
M$1758 VSS \$I3322 \$I3325 VSS nfet_05v0 L=0.6U W=0.365U AS=0.0438P
+ AD=0.282625P PS=0.605U PD=1.87U
* device instance $1759 m0 *1 555.125,802.29 nfet_05v0
M$1759 \$161 \$I3323 VSS VSS nfet_05v0 L=0.6U W=0.82U AS=0.282625P AD=0.3608P
+ PS=1.87U PD=2.52U
* device instance $1760 m0 *1 548.395,802.52 nfet_05v0
M$1760 VSS \$I2278 \$I3321 VSS nfet_05v0 L=0.6U W=0.36U AS=0.333P AD=0.0936P
+ PS=2.57U PD=0.88U
* device instance $1761 m0 *1 549.515,802.52 nfet_05v0
M$1761 \$I3324 \$I3321 VSS VSS nfet_05v0 L=0.6U W=0.36U AS=0.0936P AD=0.0432P
+ PS=0.88U PD=0.6U
* device instance $1762 m0 *1 550.355,802.52 nfet_05v0
M$1762 \$I3322 \$I3321 \$I3324 VSS nfet_05v0 L=0.6U W=0.36U AS=0.0432P
+ AD=0.369P PS=0.6U PD=2.77U
* device instance $1763 m0 *1 552.585,791.91 pfet_05v0
M$1763 \$I3334 \$I3329 \$I3330 VDD_DEC pfet_05v0 L=0.5U W=0.36U AS=0.3456P
+ AD=0.0612P PS=2.64U PD=0.7U
* device instance $1764 m0 *1 553.425,791.91 pfet_05v0
M$1764 \$I3334 \$I3329 VDD_DEC VDD_DEC pfet_05v0 L=0.5U W=0.36U AS=0.379P
+ AD=0.0612P PS=2.37U PD=0.7U
* device instance $1765 m0 *1 555.075,792.23 pfet_05v0
M$1765 \$173 \$I3330 VDD_DEC VDD_DEC pfet_05v0 L=0.5U W=1.22U AS=0.379P
+ AD=0.5368P PS=2.37U PD=3.32U
* device instance $1766 m0 *1 548.345,791.8 pfet_05v0
M$1766 VDD_DEC \$I2206 \$I3328 VDD_DEC pfet_05v0 L=0.5U W=0.36U AS=0.3852P
+ AD=0.1116P PS=2.86U PD=0.98U
* device instance $1767 m0 *1 549.465,791.8 pfet_05v0
M$1767 \$I3333 \$I3328 VDD_DEC VDD_DEC pfet_05v0 L=0.5U W=0.36U AS=0.1116P
+ AD=0.0612P PS=0.98U PD=0.7U
* device instance $1768 m0 *1 550.305,791.8 pfet_05v0
M$1768 \$I3333 \$I3328 \$I3329 VDD_DEC pfet_05v0 L=0.5U W=0.36U AS=0.3852P
+ AD=0.0612P PS=2.86U PD=0.7U
* device instance $1769 m0 *1 552.635,794.678 nfet_05v0
M$1769 \$I3332 \$I3329 \$I3330 VSS nfet_05v0 L=0.6U W=0.365U AS=0.3705P
+ AD=0.0438P PS=2.77U PD=0.605U
* device instance $1770 m0 *1 553.475,794.678 nfet_05v0
M$1770 VSS \$I3329 \$I3332 VSS nfet_05v0 L=0.6U W=0.365U AS=0.0438P
+ AD=0.282625P PS=0.605U PD=1.87U
* device instance $1771 m0 *1 555.125,794.45 nfet_05v0
M$1771 \$173 \$I3330 VSS VSS nfet_05v0 L=0.6U W=0.82U AS=0.282625P AD=0.3608P
+ PS=1.87U PD=2.52U
* device instance $1772 m0 *1 548.395,794.68 nfet_05v0
M$1772 VSS \$I2206 \$I3328 VSS nfet_05v0 L=0.6U W=0.36U AS=0.333P AD=0.0936P
+ PS=2.57U PD=0.88U
* device instance $1773 m0 *1 549.515,794.68 nfet_05v0
M$1773 \$I3331 \$I3328 VSS VSS nfet_05v0 L=0.6U W=0.36U AS=0.0936P AD=0.0432P
+ PS=0.88U PD=0.6U
* device instance $1774 m0 *1 550.355,794.68 nfet_05v0
M$1774 \$I3329 \$I3328 \$I3331 VSS nfet_05v0 L=0.6U W=0.36U AS=0.0432P
+ AD=0.369P PS=0.6U PD=2.77U
* device instance $1775 r180 *1 559.735,799.75 pfet_05v0
M$1775 \$I3341 \$I3336 \$I3337 VDD_DEC pfet_05v0 L=0.5U W=0.36U AS=0.3456P
+ AD=0.0612P PS=2.64U PD=0.7U
* device instance $1776 r180 *1 558.895,799.75 pfet_05v0
M$1776 \$I3341 \$I3336 VDD_DEC VDD_DEC pfet_05v0 L=0.5U W=0.36U AS=0.379P
+ AD=0.0612P PS=2.37U PD=0.7U
* device instance $1777 r180 *1 557.245,800.07 pfet_05v0
M$1777 \$179 \$I3337 VDD_DEC VDD_DEC pfet_05v0 L=0.5U W=1.22U AS=0.379P
+ AD=0.5368P PS=2.37U PD=3.32U
* device instance $1778 r180 *1 563.975,799.64 pfet_05v0
M$1778 VDD_DEC \$I2279 \$I3335 VDD_DEC pfet_05v0 L=0.5U W=0.36U AS=0.3852P
+ AD=0.1116P PS=2.86U PD=0.98U
* device instance $1779 r180 *1 562.855,799.64 pfet_05v0
M$1779 \$I3340 \$I3335 VDD_DEC VDD_DEC pfet_05v0 L=0.5U W=0.36U AS=0.1116P
+ AD=0.0612P PS=0.98U PD=0.7U
* device instance $1780 r180 *1 562.015,799.64 pfet_05v0
M$1780 \$I3340 \$I3335 \$I3336 VDD_DEC pfet_05v0 L=0.5U W=0.36U AS=0.3852P
+ AD=0.0612P PS=2.86U PD=0.7U
* device instance $1781 r180 *1 559.685,802.518 nfet_05v0
M$1781 \$I3339 \$I3336 \$I3337 VSS nfet_05v0 L=0.6U W=0.365U AS=0.3705P
+ AD=0.0438P PS=2.77U PD=0.605U
* device instance $1782 r180 *1 558.845,802.518 nfet_05v0
M$1782 VSS \$I3336 \$I3339 VSS nfet_05v0 L=0.6U W=0.365U AS=0.0438P
+ AD=0.282625P PS=0.605U PD=1.87U
* device instance $1783 r180 *1 557.195,802.29 nfet_05v0
M$1783 \$179 \$I3337 VSS VSS nfet_05v0 L=0.6U W=0.82U AS=0.282625P AD=0.3608P
+ PS=1.87U PD=2.52U
* device instance $1784 r180 *1 563.925,802.52 nfet_05v0
M$1784 VSS \$I2279 \$I3335 VSS nfet_05v0 L=0.6U W=0.36U AS=0.333P AD=0.0936P
+ PS=2.57U PD=0.88U
* device instance $1785 r180 *1 562.805,802.52 nfet_05v0
M$1785 \$I3338 \$I3335 VSS VSS nfet_05v0 L=0.6U W=0.36U AS=0.0936P AD=0.0432P
+ PS=0.88U PD=0.6U
* device instance $1786 r180 *1 561.965,802.52 nfet_05v0
M$1786 \$I3336 \$I3335 \$I3338 VSS nfet_05v0 L=0.6U W=0.36U AS=0.0432P
+ AD=0.369P PS=0.6U PD=2.77U
* device instance $1787 r0 *1 554.265,790.65 pfet_05v0
M$1787 \$I3348 \$I3343 \$I3344 VDD_DEC pfet_05v0 L=0.5U W=0.36U AS=0.3456P
+ AD=0.0612P PS=2.64U PD=0.7U
* device instance $1788 r0 *1 555.105,790.65 pfet_05v0
M$1788 \$I3348 \$I3343 VDD_DEC VDD_DEC pfet_05v0 L=0.5U W=0.36U AS=0.379P
+ AD=0.0612P PS=2.37U PD=0.7U
* device instance $1789 r0 *1 556.755,790.33 pfet_05v0
M$1789 \$182 \$I3344 VDD_DEC VDD_DEC pfet_05v0 L=0.5U W=1.22U AS=0.379P
+ AD=0.5368P PS=2.37U PD=3.32U
* device instance $1790 r0 *1 550.025,790.76 pfet_05v0
M$1790 VDD_DEC \$I2163 \$I3342 VDD_DEC pfet_05v0 L=0.5U W=0.36U AS=0.3852P
+ AD=0.1116P PS=2.86U PD=0.98U
* device instance $1791 r0 *1 551.145,790.76 pfet_05v0
M$1791 \$I3347 \$I3342 VDD_DEC VDD_DEC pfet_05v0 L=0.5U W=0.36U AS=0.1116P
+ AD=0.0612P PS=0.98U PD=0.7U
* device instance $1792 r0 *1 551.985,790.76 pfet_05v0
M$1792 \$I3347 \$I3342 \$I3343 VDD_DEC pfet_05v0 L=0.5U W=0.36U AS=0.3852P
+ AD=0.0612P PS=2.86U PD=0.7U
* device instance $1793 r0 *1 554.315,787.882 nfet_05v0
M$1793 \$I3346 \$I3343 \$I3344 VSS nfet_05v0 L=0.6U W=0.365U AS=0.3705P
+ AD=0.0438P PS=2.77U PD=0.605U
* device instance $1794 r0 *1 555.155,787.882 nfet_05v0
M$1794 VSS \$I3343 \$I3346 VSS nfet_05v0 L=0.6U W=0.365U AS=0.0438P
+ AD=0.282625P PS=0.605U PD=1.87U
* device instance $1795 r0 *1 556.805,788.11 nfet_05v0
M$1795 \$182 \$I3344 VSS VSS nfet_05v0 L=0.6U W=0.82U AS=0.282625P AD=0.3608P
+ PS=1.87U PD=2.52U
* device instance $1796 r0 *1 550.075,787.88 nfet_05v0
M$1796 VSS \$I2163 \$I3342 VSS nfet_05v0 L=0.6U W=0.36U AS=0.333P AD=0.0936P
+ PS=2.57U PD=0.88U
* device instance $1797 r0 *1 551.195,787.88 nfet_05v0
M$1797 \$I3345 \$I3342 VSS VSS nfet_05v0 L=0.6U W=0.36U AS=0.0936P AD=0.0432P
+ PS=0.88U PD=0.6U
* device instance $1798 r0 *1 552.035,787.88 nfet_05v0
M$1798 \$I3343 \$I3342 \$I3345 VSS nfet_05v0 L=0.6U W=0.36U AS=0.0432P
+ AD=0.369P PS=0.6U PD=2.77U
* device instance $1799 m90 *1 565.895,798.49 pfet_05v0
M$1799 \$I3355 \$I3350 \$I3351 VDD_DEC pfet_05v0 L=0.5U W=0.36U AS=0.3456P
+ AD=0.0612P PS=2.64U PD=0.7U
* device instance $1800 m90 *1 565.055,798.49 pfet_05v0
M$1800 \$I3355 \$I3350 VDD_DEC VDD_DEC pfet_05v0 L=0.5U W=0.36U AS=0.379P
+ AD=0.0612P PS=2.37U PD=0.7U
* device instance $1801 m90 *1 563.405,798.17 pfet_05v0
M$1801 \$147 \$I3351 VDD_DEC VDD_DEC pfet_05v0 L=0.5U W=1.22U AS=0.379P
+ AD=0.5368P PS=2.37U PD=3.32U
* device instance $1802 m90 *1 570.135,798.6 pfet_05v0
M$1802 VDD_DEC \$I2281 \$I3349 VDD_DEC pfet_05v0 L=0.5U W=0.36U AS=0.3852P
+ AD=0.1116P PS=2.86U PD=0.98U
* device instance $1803 m90 *1 569.015,798.6 pfet_05v0
M$1803 \$I3354 \$I3349 VDD_DEC VDD_DEC pfet_05v0 L=0.5U W=0.36U AS=0.1116P
+ AD=0.0612P PS=0.98U PD=0.7U
* device instance $1804 m90 *1 568.175,798.6 pfet_05v0
M$1804 \$I3354 \$I3349 \$I3350 VDD_DEC pfet_05v0 L=0.5U W=0.36U AS=0.3852P
+ AD=0.0612P PS=2.86U PD=0.7U
* device instance $1805 m90 *1 565.845,795.722 nfet_05v0
M$1805 \$I3353 \$I3350 \$I3351 VSS nfet_05v0 L=0.6U W=0.365U AS=0.3705P
+ AD=0.0438P PS=2.77U PD=0.605U
* device instance $1806 m90 *1 565.005,795.722 nfet_05v0
M$1806 VSS \$I3350 \$I3353 VSS nfet_05v0 L=0.6U W=0.365U AS=0.0438P
+ AD=0.282625P PS=0.605U PD=1.87U
* device instance $1807 m90 *1 563.355,795.95 nfet_05v0
M$1807 \$147 \$I3351 VSS VSS nfet_05v0 L=0.6U W=0.82U AS=0.282625P AD=0.3608P
+ PS=1.87U PD=2.52U
* device instance $1808 m90 *1 570.085,795.72 nfet_05v0
M$1808 VSS \$I2281 \$I3349 VSS nfet_05v0 L=0.6U W=0.36U AS=0.333P AD=0.0936P
+ PS=2.57U PD=0.88U
* device instance $1809 m90 *1 568.965,795.72 nfet_05v0
M$1809 \$I3352 \$I3349 VSS VSS nfet_05v0 L=0.6U W=0.36U AS=0.0936P AD=0.0432P
+ PS=0.88U PD=0.6U
* device instance $1810 m90 *1 568.125,795.72 nfet_05v0
M$1810 \$I3350 \$I3349 \$I3352 VSS nfet_05v0 L=0.6U W=0.36U AS=0.0432P
+ AD=0.369P PS=0.6U PD=2.77U
* device instance $1811 r0 *1 563.225,782.81 pfet_05v0
M$1811 \$I3362 \$I3357 \$I3358 VDD_DEC pfet_05v0 L=0.5U W=0.36U AS=0.3456P
+ AD=0.0612P PS=2.64U PD=0.7U
* device instance $1812 r0 *1 564.065,782.81 pfet_05v0
M$1812 \$I3362 \$I3357 VDD_DEC VDD_DEC pfet_05v0 L=0.5U W=0.36U AS=0.379P
+ AD=0.0612P PS=2.37U PD=0.7U
* device instance $1813 r0 *1 565.715,782.49 pfet_05v0
M$1813 \$165 \$I3358 VDD_DEC VDD_DEC pfet_05v0 L=0.5U W=1.22U AS=0.379P
+ AD=0.5368P PS=2.37U PD=3.32U
* device instance $1814 r0 *1 558.985,782.92 pfet_05v0
M$1814 VDD_DEC \$I2065 \$I3356 VDD_DEC pfet_05v0 L=0.5U W=0.36U AS=0.3852P
+ AD=0.1116P PS=2.86U PD=0.98U
* device instance $1815 r0 *1 560.105,782.92 pfet_05v0
M$1815 \$I3361 \$I3356 VDD_DEC VDD_DEC pfet_05v0 L=0.5U W=0.36U AS=0.1116P
+ AD=0.0612P PS=0.98U PD=0.7U
* device instance $1816 r0 *1 560.945,782.92 pfet_05v0
M$1816 \$I3361 \$I3356 \$I3357 VDD_DEC pfet_05v0 L=0.5U W=0.36U AS=0.3852P
+ AD=0.0612P PS=2.86U PD=0.7U
* device instance $1817 r0 *1 563.275,780.042 nfet_05v0
M$1817 \$I3360 \$I3357 \$I3358 VSS nfet_05v0 L=0.6U W=0.365U AS=0.3705P
+ AD=0.0438P PS=2.77U PD=0.605U
* device instance $1818 r0 *1 564.115,780.042 nfet_05v0
M$1818 VSS \$I3357 \$I3360 VSS nfet_05v0 L=0.6U W=0.365U AS=0.0438P
+ AD=0.282625P PS=0.605U PD=1.87U
* device instance $1819 r0 *1 565.765,780.27 nfet_05v0
M$1819 \$165 \$I3358 VSS VSS nfet_05v0 L=0.6U W=0.82U AS=0.282625P AD=0.3608P
+ PS=1.87U PD=2.52U
* device instance $1820 r0 *1 559.035,780.04 nfet_05v0
M$1820 VSS \$I2065 \$I3356 VSS nfet_05v0 L=0.6U W=0.36U AS=0.333P AD=0.0936P
+ PS=2.57U PD=0.88U
* device instance $1821 r0 *1 560.155,780.04 nfet_05v0
M$1821 \$I3359 \$I3356 VSS VSS nfet_05v0 L=0.6U W=0.36U AS=0.0936P AD=0.0432P
+ PS=0.88U PD=0.6U
* device instance $1822 r0 *1 560.995,780.04 nfet_05v0
M$1822 \$I3357 \$I3356 \$I3359 VSS nfet_05v0 L=0.6U W=0.36U AS=0.0432P
+ AD=0.369P PS=0.6U PD=2.77U
* device instance $1823 m90 *1 570.375,790.65 pfet_05v0
M$1823 \$I3369 \$I3364 \$I3365 VDD_DEC pfet_05v0 L=0.5U W=0.36U AS=0.3456P
+ AD=0.0612P PS=2.64U PD=0.7U
* device instance $1824 m90 *1 569.535,790.65 pfet_05v0
M$1824 \$I3369 \$I3364 VDD_DEC VDD_DEC pfet_05v0 L=0.5U W=0.36U AS=0.379P
+ AD=0.0612P PS=2.37U PD=0.7U
* device instance $1825 m90 *1 567.885,790.33 pfet_05v0
M$1825 \$168 \$I3365 VDD_DEC VDD_DEC pfet_05v0 L=0.5U W=1.22U AS=0.379P
+ AD=0.5368P PS=2.37U PD=3.32U
* device instance $1826 m90 *1 574.615,790.76 pfet_05v0
M$1826 VDD_DEC \$I2165 \$I3363 VDD_DEC pfet_05v0 L=0.5U W=0.36U AS=0.3852P
+ AD=0.1116P PS=2.86U PD=0.98U
* device instance $1827 m90 *1 573.495,790.76 pfet_05v0
M$1827 \$I3368 \$I3363 VDD_DEC VDD_DEC pfet_05v0 L=0.5U W=0.36U AS=0.1116P
+ AD=0.0612P PS=0.98U PD=0.7U
* device instance $1828 m90 *1 572.655,790.76 pfet_05v0
M$1828 \$I3368 \$I3363 \$I3364 VDD_DEC pfet_05v0 L=0.5U W=0.36U AS=0.3852P
+ AD=0.0612P PS=2.86U PD=0.7U
* device instance $1829 m90 *1 570.325,787.882 nfet_05v0
M$1829 \$I3367 \$I3364 \$I3365 VSS nfet_05v0 L=0.6U W=0.365U AS=0.3705P
+ AD=0.0438P PS=2.77U PD=0.605U
* device instance $1830 m90 *1 569.485,787.882 nfet_05v0
M$1830 VSS \$I3364 \$I3367 VSS nfet_05v0 L=0.6U W=0.365U AS=0.0438P
+ AD=0.282625P PS=0.605U PD=1.87U
* device instance $1831 m90 *1 567.835,788.11 nfet_05v0
M$1831 \$168 \$I3365 VSS VSS nfet_05v0 L=0.6U W=0.82U AS=0.282625P AD=0.3608P
+ PS=1.87U PD=2.52U
* device instance $1832 m90 *1 574.565,787.88 nfet_05v0
M$1832 VSS \$I2165 \$I3363 VSS nfet_05v0 L=0.6U W=0.36U AS=0.333P AD=0.0936P
+ PS=2.57U PD=0.88U
* device instance $1833 m90 *1 573.445,787.88 nfet_05v0
M$1833 \$I3366 \$I3363 VSS VSS nfet_05v0 L=0.6U W=0.36U AS=0.0936P AD=0.0432P
+ PS=0.88U PD=0.6U
* device instance $1834 m90 *1 572.605,787.88 nfet_05v0
M$1834 \$I3364 \$I3363 \$I3366 VSS nfet_05v0 L=0.6U W=0.36U AS=0.0432P
+ AD=0.369P PS=0.6U PD=2.77U
* device instance $1835 m0 *1 572.185,784.07 pfet_05v0
M$1835 \$I3376 \$I3371 \$I3372 VDD_DEC pfet_05v0 L=0.5U W=0.36U AS=0.3456P
+ AD=0.0612P PS=2.64U PD=0.7U
* device instance $1836 m0 *1 573.025,784.07 pfet_05v0
M$1836 \$I3376 \$I3371 VDD_DEC VDD_DEC pfet_05v0 L=0.5U W=0.36U AS=0.379P
+ AD=0.0612P PS=2.37U PD=0.7U
* device instance $1837 m0 *1 574.675,784.39 pfet_05v0
M$1837 \$177 \$I3372 VDD_DEC VDD_DEC pfet_05v0 L=0.5U W=1.22U AS=0.379P
+ AD=0.5368P PS=2.37U PD=3.32U
* device instance $1838 m0 *1 567.945,783.96 pfet_05v0
M$1838 VDD_DEC \$I2132 \$I3370 VDD_DEC pfet_05v0 L=0.5U W=0.36U AS=0.3852P
+ AD=0.1116P PS=2.86U PD=0.98U
* device instance $1839 m0 *1 569.065,783.96 pfet_05v0
M$1839 \$I3375 \$I3370 VDD_DEC VDD_DEC pfet_05v0 L=0.5U W=0.36U AS=0.1116P
+ AD=0.0612P PS=0.98U PD=0.7U
* device instance $1840 m0 *1 569.905,783.96 pfet_05v0
M$1840 \$I3375 \$I3370 \$I3371 VDD_DEC pfet_05v0 L=0.5U W=0.36U AS=0.3852P
+ AD=0.0612P PS=2.86U PD=0.7U
* device instance $1841 m0 *1 572.235,786.838 nfet_05v0
M$1841 \$I3374 \$I3371 \$I3372 VSS nfet_05v0 L=0.6U W=0.365U AS=0.3705P
+ AD=0.0438P PS=2.77U PD=0.605U
* device instance $1842 m0 *1 573.075,786.838 nfet_05v0
M$1842 VSS \$I3371 \$I3374 VSS nfet_05v0 L=0.6U W=0.365U AS=0.0438P
+ AD=0.282625P PS=0.605U PD=1.87U
* device instance $1843 m0 *1 574.725,786.61 nfet_05v0
M$1843 \$177 \$I3372 VSS VSS nfet_05v0 L=0.6U W=0.82U AS=0.282625P AD=0.3608P
+ PS=1.87U PD=2.52U
* device instance $1844 m0 *1 567.995,786.84 nfet_05v0
M$1844 VSS \$I2132 \$I3370 VSS nfet_05v0 L=0.6U W=0.36U AS=0.333P AD=0.0936P
+ PS=2.57U PD=0.88U
* device instance $1845 m0 *1 569.115,786.84 nfet_05v0
M$1845 \$I3373 \$I3370 VSS VSS nfet_05v0 L=0.6U W=0.36U AS=0.0936P AD=0.0432P
+ PS=0.88U PD=0.6U
* device instance $1846 m0 *1 569.955,786.84 nfet_05v0
M$1846 \$I3371 \$I3370 \$I3373 VSS nfet_05v0 L=0.6U W=0.36U AS=0.0432P
+ AD=0.369P PS=0.6U PD=2.77U
* device instance $1847 r180 *1 578.215,791.91 pfet_05v0
M$1847 \$I3383 \$I3378 \$I3379 VDD_DEC pfet_05v0 L=0.5U W=0.36U AS=0.3456P
+ AD=0.0612P PS=2.64U PD=0.7U
* device instance $1848 r180 *1 577.375,791.91 pfet_05v0
M$1848 \$I3383 \$I3378 VDD_DEC VDD_DEC pfet_05v0 L=0.5U W=0.36U AS=0.379P
+ AD=0.0612P PS=2.37U PD=0.7U
* device instance $1849 r180 *1 575.725,792.23 pfet_05v0
M$1849 \$180 \$I3379 VDD_DEC VDD_DEC pfet_05v0 L=0.5U W=1.22U AS=0.379P
+ AD=0.5368P PS=2.37U PD=3.32U
* device instance $1850 r180 *1 582.455,791.8 pfet_05v0
M$1850 VDD_DEC \$I2210 \$I3377 VDD_DEC pfet_05v0 L=0.5U W=0.36U AS=0.3852P
+ AD=0.1116P PS=2.86U PD=0.98U
* device instance $1851 r180 *1 581.335,791.8 pfet_05v0
M$1851 \$I3382 \$I3377 VDD_DEC VDD_DEC pfet_05v0 L=0.5U W=0.36U AS=0.1116P
+ AD=0.0612P PS=0.98U PD=0.7U
* device instance $1852 r180 *1 580.495,791.8 pfet_05v0
M$1852 \$I3382 \$I3377 \$I3378 VDD_DEC pfet_05v0 L=0.5U W=0.36U AS=0.3852P
+ AD=0.0612P PS=2.86U PD=0.7U
* device instance $1853 r180 *1 578.165,794.678 nfet_05v0
M$1853 \$I3381 \$I3378 \$I3379 VSS nfet_05v0 L=0.6U W=0.365U AS=0.3705P
+ AD=0.0438P PS=2.77U PD=0.605U
* device instance $1854 r180 *1 577.325,794.678 nfet_05v0
M$1854 VSS \$I3378 \$I3381 VSS nfet_05v0 L=0.6U W=0.365U AS=0.0438P
+ AD=0.282625P PS=0.605U PD=1.87U
* device instance $1855 r180 *1 575.675,794.45 nfet_05v0
M$1855 \$180 \$I3379 VSS VSS nfet_05v0 L=0.6U W=0.82U AS=0.282625P AD=0.3608P
+ PS=1.87U PD=2.52U
* device instance $1856 r180 *1 582.405,794.68 nfet_05v0
M$1856 VSS \$I2210 \$I3377 VSS nfet_05v0 L=0.6U W=0.36U AS=0.333P AD=0.0936P
+ PS=2.57U PD=0.88U
* device instance $1857 r180 *1 581.285,794.68 nfet_05v0
M$1857 \$I3380 \$I3377 VSS VSS nfet_05v0 L=0.6U W=0.36U AS=0.0936P AD=0.0432P
+ PS=0.88U PD=0.6U
* device instance $1858 r180 *1 580.445,794.68 nfet_05v0
M$1858 \$I3378 \$I3377 \$I3380 VSS nfet_05v0 L=0.6U W=0.36U AS=0.0432P
+ AD=0.369P PS=0.6U PD=2.77U
* device instance $1859 m90 *1 579.335,790.65 pfet_05v0
M$1859 \$I3390 \$I3385 \$I3386 VDD_DEC pfet_05v0 L=0.5U W=0.36U AS=0.3456P
+ AD=0.0612P PS=2.64U PD=0.7U
* device instance $1860 m90 *1 578.495,790.65 pfet_05v0
M$1860 \$I3390 \$I3385 VDD_DEC VDD_DEC pfet_05v0 L=0.5U W=0.36U AS=0.379P
+ AD=0.0612P PS=2.37U PD=0.7U
* device instance $1861 m90 *1 576.845,790.33 pfet_05v0
M$1861 \$186 \$I3386 VDD_DEC VDD_DEC pfet_05v0 L=0.5U W=1.22U AS=0.379P
+ AD=0.5368P PS=2.37U PD=3.32U
* device instance $1862 m90 *1 583.575,790.76 pfet_05v0
M$1862 VDD_DEC \$I2171 \$I3384 VDD_DEC pfet_05v0 L=0.5U W=0.36U AS=0.3852P
+ AD=0.1116P PS=2.86U PD=0.98U
* device instance $1863 m90 *1 582.455,790.76 pfet_05v0
M$1863 \$I3389 \$I3384 VDD_DEC VDD_DEC pfet_05v0 L=0.5U W=0.36U AS=0.1116P
+ AD=0.0612P PS=0.98U PD=0.7U
* device instance $1864 m90 *1 581.615,790.76 pfet_05v0
M$1864 \$I3389 \$I3384 \$I3385 VDD_DEC pfet_05v0 L=0.5U W=0.36U AS=0.3852P
+ AD=0.0612P PS=2.86U PD=0.7U
* device instance $1865 m90 *1 579.285,787.882 nfet_05v0
M$1865 \$I3388 \$I3385 \$I3386 VSS nfet_05v0 L=0.6U W=0.365U AS=0.3705P
+ AD=0.0438P PS=2.77U PD=0.605U
* device instance $1866 m90 *1 578.445,787.882 nfet_05v0
M$1866 VSS \$I3385 \$I3388 VSS nfet_05v0 L=0.6U W=0.365U AS=0.0438P
+ AD=0.282625P PS=0.605U PD=1.87U
* device instance $1867 m90 *1 576.795,788.11 nfet_05v0
M$1867 \$186 \$I3386 VSS VSS nfet_05v0 L=0.6U W=0.82U AS=0.282625P AD=0.3608P
+ PS=1.87U PD=2.52U
* device instance $1868 m90 *1 583.525,787.88 nfet_05v0
M$1868 VSS \$I2171 \$I3384 VSS nfet_05v0 L=0.6U W=0.36U AS=0.333P AD=0.0936P
+ PS=2.57U PD=0.88U
* device instance $1869 m90 *1 582.405,787.88 nfet_05v0
M$1869 \$I3387 \$I3384 VSS VSS nfet_05v0 L=0.6U W=0.36U AS=0.0936P AD=0.0432P
+ PS=0.88U PD=0.6U
* device instance $1870 m90 *1 581.565,787.88 nfet_05v0
M$1870 \$I3385 \$I3384 \$I3387 VSS nfet_05v0 L=0.6U W=0.36U AS=0.0432P
+ AD=0.369P PS=0.6U PD=2.77U
* device instance $1871 r180 *1 579.335,784.07 pfet_05v0
M$1871 \$I3397 \$I3392 \$I3393 VDD_DEC pfet_05v0 L=0.5U W=0.36U AS=0.3456P
+ AD=0.0612P PS=2.64U PD=0.7U
* device instance $1872 r180 *1 578.495,784.07 pfet_05v0
M$1872 \$I3397 \$I3392 VDD_DEC VDD_DEC pfet_05v0 L=0.5U W=0.36U AS=0.379P
+ AD=0.0612P PS=2.37U PD=0.7U
* device instance $1873 r180 *1 576.845,784.39 pfet_05v0
M$1873 \$82 \$I3393 VDD_DEC VDD_DEC pfet_05v0 L=0.5U W=1.22U AS=0.379P
+ AD=0.5368P PS=2.37U PD=3.32U
* device instance $1874 r180 *1 583.575,783.96 pfet_05v0
M$1874 VDD_DEC \$I2134 \$I3391 VDD_DEC pfet_05v0 L=0.5U W=0.36U AS=0.3852P
+ AD=0.1116P PS=2.86U PD=0.98U
* device instance $1875 r180 *1 582.455,783.96 pfet_05v0
M$1875 \$I3396 \$I3391 VDD_DEC VDD_DEC pfet_05v0 L=0.5U W=0.36U AS=0.1116P
+ AD=0.0612P PS=0.98U PD=0.7U
* device instance $1876 r180 *1 581.615,783.96 pfet_05v0
M$1876 \$I3396 \$I3391 \$I3392 VDD_DEC pfet_05v0 L=0.5U W=0.36U AS=0.3852P
+ AD=0.0612P PS=2.86U PD=0.7U
* device instance $1877 r180 *1 579.285,786.838 nfet_05v0
M$1877 \$I3395 \$I3392 \$I3393 VSS nfet_05v0 L=0.6U W=0.365U AS=0.3705P
+ AD=0.0438P PS=2.77U PD=0.605U
* device instance $1878 r180 *1 578.445,786.838 nfet_05v0
M$1878 VSS \$I3392 \$I3395 VSS nfet_05v0 L=0.6U W=0.365U AS=0.0438P
+ AD=0.282625P PS=0.605U PD=1.87U
* device instance $1879 r180 *1 576.795,786.61 nfet_05v0
M$1879 \$82 \$I3393 VSS VSS nfet_05v0 L=0.6U W=0.82U AS=0.282625P AD=0.3608P
+ PS=1.87U PD=2.52U
* device instance $1880 r180 *1 583.525,786.84 nfet_05v0
M$1880 VSS \$I2134 \$I3391 VSS nfet_05v0 L=0.6U W=0.36U AS=0.333P AD=0.0936P
+ PS=2.57U PD=0.88U
* device instance $1881 r180 *1 582.405,786.84 nfet_05v0
M$1881 \$I3394 \$I3391 VSS VSS nfet_05v0 L=0.6U W=0.36U AS=0.0936P AD=0.0432P
+ PS=0.88U PD=0.6U
* device instance $1882 r180 *1 581.565,786.84 nfet_05v0
M$1882 \$I3392 \$I3391 \$I3394 VSS nfet_05v0 L=0.6U W=0.36U AS=0.0432P
+ AD=0.369P PS=0.6U PD=2.77U
* device instance $1883 r0 *1 578.345,774.97 pfet_05v0
M$1883 \$I3404 \$I3399 \$I3400 VDD_DEC pfet_05v0 L=0.5U W=0.36U AS=0.3456P
+ AD=0.0612P PS=2.64U PD=0.7U
* device instance $1884 r0 *1 579.185,774.97 pfet_05v0
M$1884 \$I3404 \$I3399 VDD_DEC VDD_DEC pfet_05v0 L=0.5U W=0.36U AS=0.379P
+ AD=0.0612P PS=2.37U PD=0.7U
* device instance $1885 r0 *1 580.835,774.65 pfet_05v0
M$1885 \$86 \$I3400 VDD_DEC VDD_DEC pfet_05v0 L=0.5U W=1.22U AS=0.379P
+ AD=0.5368P PS=2.37U PD=3.32U
* device instance $1886 r0 *1 574.105,775.08 pfet_05v0
M$1886 VDD_DEC \$I2028 \$I3398 VDD_DEC pfet_05v0 L=0.5U W=0.36U AS=0.3852P
+ AD=0.1116P PS=2.86U PD=0.98U
* device instance $1887 r0 *1 575.225,775.08 pfet_05v0
M$1887 \$I3403 \$I3398 VDD_DEC VDD_DEC pfet_05v0 L=0.5U W=0.36U AS=0.1116P
+ AD=0.0612P PS=0.98U PD=0.7U
* device instance $1888 r0 *1 576.065,775.08 pfet_05v0
M$1888 \$I3403 \$I3398 \$I3399 VDD_DEC pfet_05v0 L=0.5U W=0.36U AS=0.3852P
+ AD=0.0612P PS=2.86U PD=0.7U
* device instance $1889 r0 *1 578.395,772.202 nfet_05v0
M$1889 \$I3402 \$I3399 \$I3400 VSS nfet_05v0 L=0.6U W=0.365U AS=0.3705P
+ AD=0.0438P PS=2.77U PD=0.605U
* device instance $1890 r0 *1 579.235,772.202 nfet_05v0
M$1890 VSS \$I3399 \$I3402 VSS nfet_05v0 L=0.6U W=0.365U AS=0.0438P
+ AD=0.282625P PS=0.605U PD=1.87U
* device instance $1891 r0 *1 580.885,772.43 nfet_05v0
M$1891 \$86 \$I3400 VSS VSS nfet_05v0 L=0.6U W=0.82U AS=0.282625P AD=0.3608P
+ PS=1.87U PD=2.52U
* device instance $1892 r0 *1 574.155,772.2 nfet_05v0
M$1892 VSS \$I2028 \$I3398 VSS nfet_05v0 L=0.6U W=0.36U AS=0.333P AD=0.0936P
+ PS=2.57U PD=0.88U
* device instance $1893 r0 *1 575.275,772.2 nfet_05v0
M$1893 \$I3401 \$I3398 VSS VSS nfet_05v0 L=0.6U W=0.36U AS=0.0936P AD=0.0432P
+ PS=0.88U PD=0.6U
* device instance $1894 r0 *1 576.115,772.2 nfet_05v0
M$1894 \$I3399 \$I3398 \$I3401 VSS nfet_05v0 L=0.6U W=0.36U AS=0.0432P
+ AD=0.369P PS=0.6U PD=2.77U
* device instance $1895 r180 *1 588.295,784.07 pfet_05v0
M$1895 \$I3411 \$I3406 \$I3407 VDD_DEC pfet_05v0 L=0.5U W=0.36U AS=0.3456P
+ AD=0.0612P PS=2.64U PD=0.7U
* device instance $1896 r180 *1 587.455,784.07 pfet_05v0
M$1896 \$I3411 \$I3406 VDD_DEC VDD_DEC pfet_05v0 L=0.5U W=0.36U AS=0.379P
+ AD=0.0612P PS=2.37U PD=0.7U
* device instance $1897 r180 *1 585.805,784.39 pfet_05v0
M$1897 \$90 \$I3407 VDD_DEC VDD_DEC pfet_05v0 L=0.5U W=1.22U AS=0.379P
+ AD=0.5368P PS=2.37U PD=3.32U
* device instance $1898 r180 *1 592.535,783.96 pfet_05v0
M$1898 VDD_DEC \$I2135 \$I3405 VDD_DEC pfet_05v0 L=0.5U W=0.36U AS=0.3852P
+ AD=0.1116P PS=2.86U PD=0.98U
* device instance $1899 r180 *1 591.415,783.96 pfet_05v0
M$1899 \$I3410 \$I3405 VDD_DEC VDD_DEC pfet_05v0 L=0.5U W=0.36U AS=0.1116P
+ AD=0.0612P PS=0.98U PD=0.7U
* device instance $1900 r180 *1 590.575,783.96 pfet_05v0
M$1900 \$I3410 \$I3405 \$I3406 VDD_DEC pfet_05v0 L=0.5U W=0.36U AS=0.3852P
+ AD=0.0612P PS=2.86U PD=0.7U
* device instance $1901 r180 *1 588.245,786.838 nfet_05v0
M$1901 \$I3409 \$I3406 \$I3407 VSS nfet_05v0 L=0.6U W=0.365U AS=0.3705P
+ AD=0.0438P PS=2.77U PD=0.605U
* device instance $1902 r180 *1 587.405,786.838 nfet_05v0
M$1902 VSS \$I3406 \$I3409 VSS nfet_05v0 L=0.6U W=0.365U AS=0.0438P
+ AD=0.282625P PS=0.605U PD=1.87U
* device instance $1903 r180 *1 585.755,786.61 nfet_05v0
M$1903 \$90 \$I3407 VSS VSS nfet_05v0 L=0.6U W=0.82U AS=0.282625P AD=0.3608P
+ PS=1.87U PD=2.52U
* device instance $1904 r180 *1 592.485,786.84 nfet_05v0
M$1904 VSS \$I2135 \$I3405 VSS nfet_05v0 L=0.6U W=0.36U AS=0.333P AD=0.0936P
+ PS=2.57U PD=0.88U
* device instance $1905 r180 *1 591.365,786.84 nfet_05v0
M$1905 \$I3408 \$I3405 VSS VSS nfet_05v0 L=0.6U W=0.36U AS=0.0936P AD=0.0432P
+ PS=0.88U PD=0.6U
* device instance $1906 r180 *1 590.525,786.84 nfet_05v0
M$1906 \$I3406 \$I3405 \$I3408 VSS nfet_05v0 L=0.6U W=0.36U AS=0.0432P
+ AD=0.369P PS=0.6U PD=2.77U
* device instance $1907 r180 *1 589.415,776.23 pfet_05v0
M$1907 \$I3418 \$I3413 \$I3414 VDD_DEC pfet_05v0 L=0.5U W=0.36U AS=0.3456P
+ AD=0.0612P PS=2.64U PD=0.7U
* device instance $1908 r180 *1 588.575,776.23 pfet_05v0
M$1908 \$I3418 \$I3413 VDD_DEC VDD_DEC pfet_05v0 L=0.5U W=0.36U AS=0.379P
+ AD=0.0612P PS=2.37U PD=0.7U
* device instance $1909 r180 *1 586.925,776.55 pfet_05v0
M$1909 \$92 \$I3414 VDD_DEC VDD_DEC pfet_05v0 L=0.5U W=1.22U AS=0.379P
+ AD=0.5368P PS=2.37U PD=3.32U
* device instance $1910 r180 *1 593.655,776.12 pfet_05v0
M$1910 VDD_DEC \$I2070 \$I3412 VDD_DEC pfet_05v0 L=0.5U W=0.36U AS=0.3852P
+ AD=0.1116P PS=2.86U PD=0.98U
* device instance $1911 r180 *1 592.535,776.12 pfet_05v0
M$1911 \$I3417 \$I3412 VDD_DEC VDD_DEC pfet_05v0 L=0.5U W=0.36U AS=0.1116P
+ AD=0.0612P PS=0.98U PD=0.7U
* device instance $1912 r180 *1 591.695,776.12 pfet_05v0
M$1912 \$I3417 \$I3412 \$I3413 VDD_DEC pfet_05v0 L=0.5U W=0.36U AS=0.3852P
+ AD=0.0612P PS=2.86U PD=0.7U
* device instance $1913 r180 *1 589.365,778.998 nfet_05v0
M$1913 \$I3416 \$I3413 \$I3414 VSS nfet_05v0 L=0.6U W=0.365U AS=0.3705P
+ AD=0.0438P PS=2.77U PD=0.605U
* device instance $1914 r180 *1 588.525,778.998 nfet_05v0
M$1914 VSS \$I3413 \$I3416 VSS nfet_05v0 L=0.6U W=0.365U AS=0.0438P
+ AD=0.282625P PS=0.605U PD=1.87U
* device instance $1915 r180 *1 586.875,778.77 nfet_05v0
M$1915 \$92 \$I3414 VSS VSS nfet_05v0 L=0.6U W=0.82U AS=0.282625P AD=0.3608P
+ PS=1.87U PD=2.52U
* device instance $1916 r180 *1 593.605,779 nfet_05v0
M$1916 VSS \$I2070 \$I3412 VSS nfet_05v0 L=0.6U W=0.36U AS=0.333P AD=0.0936P
+ PS=2.57U PD=0.88U
* device instance $1917 r180 *1 592.485,779 nfet_05v0
M$1917 \$I3415 \$I3412 VSS VSS nfet_05v0 L=0.6U W=0.36U AS=0.0936P AD=0.0432P
+ PS=0.88U PD=0.6U
* device instance $1918 r180 *1 591.645,779 nfet_05v0
M$1918 \$I3413 \$I3412 \$I3415 VSS nfet_05v0 L=0.6U W=0.36U AS=0.0432P
+ AD=0.369P PS=0.6U PD=2.77U
* device instance $1919 m90 *1 590.535,774.97 pfet_05v0
M$1919 \$I3425 \$I3420 \$I3421 VDD_DEC pfet_05v0 L=0.5U W=0.36U AS=0.3456P
+ AD=0.0612P PS=2.64U PD=0.7U
* device instance $1920 m90 *1 589.695,774.97 pfet_05v0
M$1920 \$I3425 \$I3420 VDD_DEC VDD_DEC pfet_05v0 L=0.5U W=0.36U AS=0.379P
+ AD=0.0612P PS=2.37U PD=0.7U
* device instance $1921 m90 *1 588.045,774.65 pfet_05v0
M$1921 \$94 \$I3421 VDD_DEC VDD_DEC pfet_05v0 L=0.5U W=1.22U AS=0.379P
+ AD=0.5368P PS=2.37U PD=3.32U
* device instance $1922 m90 *1 594.775,775.08 pfet_05v0
M$1922 VDD_DEC \$I2029 \$I3419 VDD_DEC pfet_05v0 L=0.5U W=0.36U AS=0.3852P
+ AD=0.1116P PS=2.86U PD=0.98U
* device instance $1923 m90 *1 593.655,775.08 pfet_05v0
M$1923 \$I3424 \$I3419 VDD_DEC VDD_DEC pfet_05v0 L=0.5U W=0.36U AS=0.1116P
+ AD=0.0612P PS=0.98U PD=0.7U
* device instance $1924 m90 *1 592.815,775.08 pfet_05v0
M$1924 \$I3424 \$I3419 \$I3420 VDD_DEC pfet_05v0 L=0.5U W=0.36U AS=0.3852P
+ AD=0.0612P PS=2.86U PD=0.7U
* device instance $1925 m90 *1 590.485,772.202 nfet_05v0
M$1925 \$I3423 \$I3420 \$I3421 VSS nfet_05v0 L=0.6U W=0.365U AS=0.3705P
+ AD=0.0438P PS=2.77U PD=0.605U
* device instance $1926 m90 *1 589.645,772.202 nfet_05v0
M$1926 VSS \$I3420 \$I3423 VSS nfet_05v0 L=0.6U W=0.365U AS=0.0438P
+ AD=0.282625P PS=0.605U PD=1.87U
* device instance $1927 m90 *1 587.995,772.43 nfet_05v0
M$1927 \$94 \$I3421 VSS VSS nfet_05v0 L=0.6U W=0.82U AS=0.282625P AD=0.3608P
+ PS=1.87U PD=2.52U
* device instance $1928 m90 *1 594.725,772.2 nfet_05v0
M$1928 VSS \$I2029 \$I3419 VSS nfet_05v0 L=0.6U W=0.36U AS=0.333P AD=0.0936P
+ PS=2.57U PD=0.88U
* device instance $1929 m90 *1 593.605,772.2 nfet_05v0
M$1929 \$I3422 \$I3419 VSS VSS nfet_05v0 L=0.6U W=0.36U AS=0.0936P AD=0.0432P
+ PS=0.88U PD=0.6U
* device instance $1930 m90 *1 592.765,772.2 nfet_05v0
M$1930 \$I3420 \$I3419 \$I3422 VSS nfet_05v0 L=0.6U W=0.36U AS=0.0432P
+ AD=0.369P PS=0.6U PD=2.77U
* device instance $1931 m90 *1 591.655,782.81 pfet_05v0
M$1931 \$I3432 \$I3427 \$I3428 VDD_DEC pfet_05v0 L=0.5U W=0.36U AS=0.3456P
+ AD=0.0612P PS=2.64U PD=0.7U
* device instance $1932 m90 *1 590.815,782.81 pfet_05v0
M$1932 \$I3432 \$I3427 VDD_DEC VDD_DEC pfet_05v0 L=0.5U W=0.36U AS=0.379P
+ AD=0.0612P PS=2.37U PD=0.7U
* device instance $1933 m90 *1 589.165,782.49 pfet_05v0
M$1933 \$96 \$I3428 VDD_DEC VDD_DEC pfet_05v0 L=0.5U W=1.22U AS=0.379P
+ AD=0.5368P PS=2.37U PD=3.32U
* device instance $1934 m90 *1 595.895,782.92 pfet_05v0
M$1934 VDD_DEC \$I2069 \$I3426 VDD_DEC pfet_05v0 L=0.5U W=0.36U AS=0.3852P
+ AD=0.1116P PS=2.86U PD=0.98U
* device instance $1935 m90 *1 594.775,782.92 pfet_05v0
M$1935 \$I3431 \$I3426 VDD_DEC VDD_DEC pfet_05v0 L=0.5U W=0.36U AS=0.1116P
+ AD=0.0612P PS=0.98U PD=0.7U
* device instance $1936 m90 *1 593.935,782.92 pfet_05v0
M$1936 \$I3431 \$I3426 \$I3427 VDD_DEC pfet_05v0 L=0.5U W=0.36U AS=0.3852P
+ AD=0.0612P PS=2.86U PD=0.7U
* device instance $1937 m90 *1 591.605,780.042 nfet_05v0
M$1937 \$I3430 \$I3427 \$I3428 VSS nfet_05v0 L=0.6U W=0.365U AS=0.3705P
+ AD=0.0438P PS=2.77U PD=0.605U
* device instance $1938 m90 *1 590.765,780.042 nfet_05v0
M$1938 VSS \$I3427 \$I3430 VSS nfet_05v0 L=0.6U W=0.365U AS=0.0438P
+ AD=0.282625P PS=0.605U PD=1.87U
* device instance $1939 m90 *1 589.115,780.27 nfet_05v0
M$1939 \$96 \$I3428 VSS VSS nfet_05v0 L=0.6U W=0.82U AS=0.282625P AD=0.3608P
+ PS=1.87U PD=2.52U
* device instance $1940 m90 *1 595.845,780.04 nfet_05v0
M$1940 VSS \$I2069 \$I3426 VSS nfet_05v0 L=0.6U W=0.36U AS=0.333P AD=0.0936P
+ PS=2.57U PD=0.88U
* device instance $1941 m90 *1 594.725,780.04 nfet_05v0
M$1941 \$I3429 \$I3426 VSS VSS nfet_05v0 L=0.6U W=0.36U AS=0.0936P AD=0.0432P
+ PS=0.88U PD=0.6U
* device instance $1942 m90 *1 593.885,780.04 nfet_05v0
M$1942 \$I3427 \$I3426 \$I3429 VSS nfet_05v0 L=0.6U W=0.36U AS=0.0432P
+ AD=0.369P PS=0.6U PD=2.77U
* device instance $1943 r180 *1 598.375,776.23 pfet_05v0
M$1943 \$I3439 \$I3434 \$I3435 VDD_DEC pfet_05v0 L=0.5U W=0.36U AS=0.3456P
+ AD=0.0612P PS=2.64U PD=0.7U
* device instance $1944 r180 *1 597.535,776.23 pfet_05v0
M$1944 \$I3439 \$I3434 VDD_DEC VDD_DEC pfet_05v0 L=0.5U W=0.36U AS=0.379P
+ AD=0.0612P PS=2.37U PD=0.7U
* device instance $1945 r180 *1 595.885,776.55 pfet_05v0
M$1945 \$98 \$I3435 VDD_DEC VDD_DEC pfet_05v0 L=0.5U W=1.22U AS=0.379P
+ AD=0.5368P PS=2.37U PD=3.32U
* device instance $1946 r180 *1 602.615,776.12 pfet_05v0
M$1946 VDD_DEC \$I2239 \$I3433 VDD_DEC pfet_05v0 L=0.5U W=0.36U AS=0.3852P
+ AD=0.1116P PS=2.86U PD=0.98U
* device instance $1947 r180 *1 601.495,776.12 pfet_05v0
M$1947 \$I3438 \$I3433 VDD_DEC VDD_DEC pfet_05v0 L=0.5U W=0.36U AS=0.1116P
+ AD=0.0612P PS=0.98U PD=0.7U
* device instance $1948 r180 *1 600.655,776.12 pfet_05v0
M$1948 \$I3438 \$I3433 \$I3434 VDD_DEC pfet_05v0 L=0.5U W=0.36U AS=0.3852P
+ AD=0.0612P PS=2.86U PD=0.7U
* device instance $1949 r180 *1 598.325,778.998 nfet_05v0
M$1949 \$I3437 \$I3434 \$I3435 VSS nfet_05v0 L=0.6U W=0.365U AS=0.3705P
+ AD=0.0438P PS=2.77U PD=0.605U
* device instance $1950 r180 *1 597.485,778.998 nfet_05v0
M$1950 VSS \$I3434 \$I3437 VSS nfet_05v0 L=0.6U W=0.365U AS=0.0438P
+ AD=0.282625P PS=0.605U PD=1.87U
* device instance $1951 r180 *1 595.835,778.77 nfet_05v0
M$1951 \$98 \$I3435 VSS VSS nfet_05v0 L=0.6U W=0.82U AS=0.282625P AD=0.3608P
+ PS=1.87U PD=2.52U
* device instance $1952 r180 *1 602.565,779 nfet_05v0
M$1952 VSS \$I2239 \$I3433 VSS nfet_05v0 L=0.6U W=0.36U AS=0.333P AD=0.0936P
+ PS=2.57U PD=0.88U
* device instance $1953 r180 *1 601.445,779 nfet_05v0
M$1953 \$I3436 \$I3433 VSS VSS nfet_05v0 L=0.6U W=0.36U AS=0.0936P AD=0.0432P
+ PS=0.88U PD=0.6U
* device instance $1954 r180 *1 600.605,779 nfet_05v0
M$1954 \$I3434 \$I3433 \$I3436 VSS nfet_05v0 L=0.6U W=0.36U AS=0.0432P
+ AD=0.369P PS=0.6U PD=2.77U
* device instance $1955 m90 *1 605.655,774.97 pfet_05v0
M$1955 \$I3446 \$I3441 \$I3442 VDD_DEC pfet_05v0 L=0.5U W=0.36U AS=0.3456P
+ AD=0.0612P PS=2.64U PD=0.7U
* device instance $1956 m90 *1 604.815,774.97 pfet_05v0
M$1956 \$I3446 \$I3441 VDD_DEC VDD_DEC pfet_05v0 L=0.5U W=0.36U AS=0.379P
+ AD=0.0612P PS=2.37U PD=0.7U
* device instance $1957 m90 *1 603.165,774.65 pfet_05v0
M$1957 \$100 \$I3442 VDD_DEC VDD_DEC pfet_05v0 L=0.5U W=1.22U AS=0.379P
+ AD=0.5368P PS=2.37U PD=3.32U
* device instance $1958 m90 *1 609.895,775.08 pfet_05v0
M$1958 VDD_DEC \$I2253 \$I3440 VDD_DEC pfet_05v0 L=0.5U W=0.36U AS=0.3852P
+ AD=0.1116P PS=2.86U PD=0.98U
* device instance $1959 m90 *1 608.775,775.08 pfet_05v0
M$1959 \$I3445 \$I3440 VDD_DEC VDD_DEC pfet_05v0 L=0.5U W=0.36U AS=0.1116P
+ AD=0.0612P PS=0.98U PD=0.7U
* device instance $1960 m90 *1 607.935,775.08 pfet_05v0
M$1960 \$I3445 \$I3440 \$I3441 VDD_DEC pfet_05v0 L=0.5U W=0.36U AS=0.3852P
+ AD=0.0612P PS=2.86U PD=0.7U
* device instance $1961 m90 *1 605.605,772.202 nfet_05v0
M$1961 \$I3444 \$I3441 \$I3442 VSS nfet_05v0 L=0.6U W=0.365U AS=0.3705P
+ AD=0.0438P PS=2.77U PD=0.605U
* device instance $1962 m90 *1 604.765,772.202 nfet_05v0
M$1962 VSS \$I3441 \$I3444 VSS nfet_05v0 L=0.6U W=0.365U AS=0.0438P
+ AD=0.282625P PS=0.605U PD=1.87U
* device instance $1963 m90 *1 603.115,772.43 nfet_05v0
M$1963 \$100 \$I3442 VSS VSS nfet_05v0 L=0.6U W=0.82U AS=0.282625P AD=0.3608P
+ PS=1.87U PD=2.52U
* device instance $1964 m90 *1 609.845,772.2 nfet_05v0
M$1964 VSS \$I2253 \$I3440 VSS nfet_05v0 L=0.6U W=0.36U AS=0.333P AD=0.0936P
+ PS=2.57U PD=0.88U
* device instance $1965 m90 *1 608.725,772.2 nfet_05v0
M$1965 \$I3443 \$I3440 VSS VSS nfet_05v0 L=0.6U W=0.36U AS=0.0936P AD=0.0432P
+ PS=0.88U PD=0.6U
* device instance $1966 m90 *1 607.885,772.2 nfet_05v0
M$1966 \$I3441 \$I3440 \$I3443 VSS nfet_05v0 L=0.6U W=0.36U AS=0.0432P
+ AD=0.369P PS=0.6U PD=2.77U
* device instance $1967 m90 *1 600.615,782.81 pfet_05v0
M$1967 \$I3453 \$I3448 \$I3449 VDD_DEC pfet_05v0 L=0.5U W=0.36U AS=0.3456P
+ AD=0.0612P PS=2.64U PD=0.7U
* device instance $1968 m90 *1 599.775,782.81 pfet_05v0
M$1968 \$I3453 \$I3448 VDD_DEC VDD_DEC pfet_05v0 L=0.5U W=0.36U AS=0.379P
+ AD=0.0612P PS=2.37U PD=0.7U
* device instance $1969 m90 *1 598.125,782.49 pfet_05v0
M$1969 \$102 \$I3449 VDD_DEC VDD_DEC pfet_05v0 L=0.5U W=1.22U AS=0.379P
+ AD=0.5368P PS=2.37U PD=3.32U
* device instance $1970 m90 *1 604.855,782.92 pfet_05v0
M$1970 VDD_DEC \$I2167 \$I3447 VDD_DEC pfet_05v0 L=0.5U W=0.36U AS=0.3852P
+ AD=0.1116P PS=2.86U PD=0.98U
* device instance $1971 m90 *1 603.735,782.92 pfet_05v0
M$1971 \$I3452 \$I3447 VDD_DEC VDD_DEC pfet_05v0 L=0.5U W=0.36U AS=0.1116P
+ AD=0.0612P PS=0.98U PD=0.7U
* device instance $1972 m90 *1 602.895,782.92 pfet_05v0
M$1972 \$I3452 \$I3447 \$I3448 VDD_DEC pfet_05v0 L=0.5U W=0.36U AS=0.3852P
+ AD=0.0612P PS=2.86U PD=0.7U
* device instance $1973 m90 *1 600.565,780.042 nfet_05v0
M$1973 \$I3451 \$I3448 \$I3449 VSS nfet_05v0 L=0.6U W=0.365U AS=0.3705P
+ AD=0.0438P PS=2.77U PD=0.605U
* device instance $1974 m90 *1 599.725,780.042 nfet_05v0
M$1974 VSS \$I3448 \$I3451 VSS nfet_05v0 L=0.6U W=0.365U AS=0.0438P
+ AD=0.282625P PS=0.605U PD=1.87U
* device instance $1975 m90 *1 598.075,780.27 nfet_05v0
M$1975 \$102 \$I3449 VSS VSS nfet_05v0 L=0.6U W=0.82U AS=0.282625P AD=0.3608P
+ PS=1.87U PD=2.52U
* device instance $1976 m90 *1 604.805,780.04 nfet_05v0
M$1976 VSS \$I2167 \$I3447 VSS nfet_05v0 L=0.6U W=0.36U AS=0.333P AD=0.0936P
+ PS=2.57U PD=0.88U
* device instance $1977 m90 *1 603.685,780.04 nfet_05v0
M$1977 \$I3450 \$I3447 VSS VSS nfet_05v0 L=0.6U W=0.36U AS=0.0936P AD=0.0432P
+ PS=0.88U PD=0.6U
* device instance $1978 m90 *1 602.845,780.04 nfet_05v0
M$1978 \$I3448 \$I3447 \$I3450 VSS nfet_05v0 L=0.6U W=0.36U AS=0.0432P
+ AD=0.369P PS=0.6U PD=2.77U
* device instance $1979 r180 *1 597.255,784.07 pfet_05v0
M$1979 \$I3460 \$I3455 \$I3456 VDD_DEC pfet_05v0 L=0.5U W=0.36U AS=0.3456P
+ AD=0.0612P PS=2.64U PD=0.7U
* device instance $1980 r180 *1 596.415,784.07 pfet_05v0
M$1980 \$I3460 \$I3455 VDD_DEC VDD_DEC pfet_05v0 L=0.5U W=0.36U AS=0.379P
+ AD=0.0612P PS=2.37U PD=0.7U
* device instance $1981 r180 *1 594.765,784.39 pfet_05v0
M$1981 \$104 \$I3456 VDD_DEC VDD_DEC pfet_05v0 L=0.5U W=1.22U AS=0.379P
+ AD=0.5368P PS=2.37U PD=3.32U
* device instance $1982 r180 *1 601.495,783.96 pfet_05v0
M$1982 VDD_DEC \$I2133 \$I3454 VDD_DEC pfet_05v0 L=0.5U W=0.36U AS=0.3852P
+ AD=0.1116P PS=2.86U PD=0.98U
* device instance $1983 r180 *1 600.375,783.96 pfet_05v0
M$1983 \$I3459 \$I3454 VDD_DEC VDD_DEC pfet_05v0 L=0.5U W=0.36U AS=0.1116P
+ AD=0.0612P PS=0.98U PD=0.7U
* device instance $1984 r180 *1 599.535,783.96 pfet_05v0
M$1984 \$I3459 \$I3454 \$I3455 VDD_DEC pfet_05v0 L=0.5U W=0.36U AS=0.3852P
+ AD=0.0612P PS=2.86U PD=0.7U
* device instance $1985 r180 *1 597.205,786.838 nfet_05v0
M$1985 \$I3458 \$I3455 \$I3456 VSS nfet_05v0 L=0.6U W=0.365U AS=0.3705P
+ AD=0.0438P PS=2.77U PD=0.605U
* device instance $1986 r180 *1 596.365,786.838 nfet_05v0
M$1986 VSS \$I3455 \$I3458 VSS nfet_05v0 L=0.6U W=0.365U AS=0.0438P
+ AD=0.282625P PS=0.605U PD=1.87U
* device instance $1987 r180 *1 594.715,786.61 nfet_05v0
M$1987 \$104 \$I3456 VSS VSS nfet_05v0 L=0.6U W=0.82U AS=0.282625P AD=0.3608P
+ PS=1.87U PD=2.52U
* device instance $1988 r180 *1 601.445,786.84 nfet_05v0
M$1988 VSS \$I2133 \$I3454 VSS nfet_05v0 L=0.6U W=0.36U AS=0.333P AD=0.0936P
+ PS=2.57U PD=0.88U
* device instance $1989 r180 *1 600.325,786.84 nfet_05v0
M$1989 \$I3457 \$I3454 VSS VSS nfet_05v0 L=0.6U W=0.36U AS=0.0936P AD=0.0432P
+ PS=0.88U PD=0.6U
* device instance $1990 r180 *1 599.485,786.84 nfet_05v0
M$1990 \$I3455 \$I3454 \$I3457 VSS nfet_05v0 L=0.6U W=0.36U AS=0.0432P
+ AD=0.369P PS=0.6U PD=2.77U
* device instance $1991 m90 *1 597.255,790.65 pfet_05v0
M$1991 \$I3467 \$I3462 \$I3463 VDD_DEC pfet_05v0 L=0.5U W=0.36U AS=0.3456P
+ AD=0.0612P PS=2.64U PD=0.7U
* device instance $1992 m90 *1 596.415,790.65 pfet_05v0
M$1992 \$I3467 \$I3462 VDD_DEC VDD_DEC pfet_05v0 L=0.5U W=0.36U AS=0.379P
+ AD=0.0612P PS=2.37U PD=0.7U
* device instance $1993 m90 *1 594.765,790.33 pfet_05v0
M$1993 \$106 \$I3463 VDD_DEC VDD_DEC pfet_05v0 L=0.5U W=1.22U AS=0.379P
+ AD=0.5368P PS=2.37U PD=3.32U
* device instance $1994 m90 *1 601.495,790.76 pfet_05v0
M$1994 VDD_DEC \$I2367 \$I3461 VDD_DEC pfet_05v0 L=0.5U W=0.36U AS=0.3852P
+ AD=0.1116P PS=2.86U PD=0.98U
* device instance $1995 m90 *1 600.375,790.76 pfet_05v0
M$1995 \$I3466 \$I3461 VDD_DEC VDD_DEC pfet_05v0 L=0.5U W=0.36U AS=0.1116P
+ AD=0.0612P PS=0.98U PD=0.7U
* device instance $1996 m90 *1 599.535,790.76 pfet_05v0
M$1996 \$I3466 \$I3461 \$I3462 VDD_DEC pfet_05v0 L=0.5U W=0.36U AS=0.3852P
+ AD=0.0612P PS=2.86U PD=0.7U
* device instance $1997 m90 *1 597.205,787.882 nfet_05v0
M$1997 \$I3465 \$I3462 \$I3463 VSS nfet_05v0 L=0.6U W=0.365U AS=0.3705P
+ AD=0.0438P PS=2.77U PD=0.605U
* device instance $1998 m90 *1 596.365,787.882 nfet_05v0
M$1998 VSS \$I3462 \$I3465 VSS nfet_05v0 L=0.6U W=0.365U AS=0.0438P
+ AD=0.282625P PS=0.605U PD=1.87U
* device instance $1999 m90 *1 594.715,788.11 nfet_05v0
M$1999 \$106 \$I3463 VSS VSS nfet_05v0 L=0.6U W=0.82U AS=0.282625P AD=0.3608P
+ PS=1.87U PD=2.52U
* device instance $2000 m90 *1 601.445,787.88 nfet_05v0
M$2000 VSS \$I2367 \$I3461 VSS nfet_05v0 L=0.6U W=0.36U AS=0.333P AD=0.0936P
+ PS=2.57U PD=0.88U
* device instance $2001 m90 *1 600.325,787.88 nfet_05v0
M$2001 \$I3464 \$I3461 VSS VSS nfet_05v0 L=0.6U W=0.36U AS=0.0936P AD=0.0432P
+ PS=0.88U PD=0.6U
* device instance $2002 m90 *1 599.485,787.88 nfet_05v0
M$2002 \$I3462 \$I3461 \$I3464 VSS nfet_05v0 L=0.6U W=0.36U AS=0.0432P
+ AD=0.369P PS=0.6U PD=2.77U
* device instance $2003 r180 *1 609.015,776.23 pfet_05v0
M$2003 \$I3474 \$I3469 \$I3470 VDD_DEC pfet_05v0 L=0.5U W=0.36U AS=0.3456P
+ AD=0.0612P PS=2.64U PD=0.7U
* device instance $2004 r180 *1 608.175,776.23 pfet_05v0
M$2004 \$I3474 \$I3469 VDD_DEC VDD_DEC pfet_05v0 L=0.5U W=0.36U AS=0.379P
+ AD=0.0612P PS=2.37U PD=0.7U
* device instance $2005 r180 *1 606.525,776.55 pfet_05v0
M$2005 \$108 \$I3470 VDD_DEC VDD_DEC pfet_05v0 L=0.5U W=1.22U AS=0.379P
+ AD=0.5368P PS=2.37U PD=3.32U
* device instance $2006 r180 *1 613.255,776.12 pfet_05v0
M$2006 VDD_DEC \$I2072 \$I3468 VDD_DEC pfet_05v0 L=0.5U W=0.36U AS=0.3852P
+ AD=0.1116P PS=2.86U PD=0.98U
* device instance $2007 r180 *1 612.135,776.12 pfet_05v0
M$2007 \$I3473 \$I3468 VDD_DEC VDD_DEC pfet_05v0 L=0.5U W=0.36U AS=0.1116P
+ AD=0.0612P PS=0.98U PD=0.7U
* device instance $2008 r180 *1 611.295,776.12 pfet_05v0
M$2008 \$I3473 \$I3468 \$I3469 VDD_DEC pfet_05v0 L=0.5U W=0.36U AS=0.3852P
+ AD=0.0612P PS=2.86U PD=0.7U
* device instance $2009 r180 *1 608.965,778.998 nfet_05v0
M$2009 \$I3472 \$I3469 \$I3470 VSS nfet_05v0 L=0.6U W=0.365U AS=0.3705P
+ AD=0.0438P PS=2.77U PD=0.605U
* device instance $2010 r180 *1 608.125,778.998 nfet_05v0
M$2010 VSS \$I3469 \$I3472 VSS nfet_05v0 L=0.6U W=0.365U AS=0.0438P
+ AD=0.282625P PS=0.605U PD=1.87U
* device instance $2011 r180 *1 606.475,778.77 nfet_05v0
M$2011 \$108 \$I3470 VSS VSS nfet_05v0 L=0.6U W=0.82U AS=0.282625P AD=0.3608P
+ PS=1.87U PD=2.52U
* device instance $2012 r180 *1 613.205,779 nfet_05v0
M$2012 VSS \$I2072 \$I3468 VSS nfet_05v0 L=0.6U W=0.36U AS=0.333P AD=0.0936P
+ PS=2.57U PD=0.88U
* device instance $2013 r180 *1 612.085,779 nfet_05v0
M$2013 \$I3471 \$I3468 VSS VSS nfet_05v0 L=0.6U W=0.36U AS=0.0936P AD=0.0432P
+ PS=0.88U PD=0.6U
* device instance $2014 r180 *1 611.245,779 nfet_05v0
M$2014 \$I3469 \$I3468 \$I3471 VSS nfet_05v0 L=0.6U W=0.36U AS=0.0432P
+ AD=0.369P PS=0.6U PD=2.77U
* device instance $2015 m90 *1 614.615,774.97 pfet_05v0
M$2015 \$I3481 \$I3476 \$I3477 VDD_DEC pfet_05v0 L=0.5U W=0.36U AS=0.3456P
+ AD=0.0612P PS=2.64U PD=0.7U
* device instance $2016 m90 *1 613.775,774.97 pfet_05v0
M$2016 \$I3481 \$I3476 VDD_DEC VDD_DEC pfet_05v0 L=0.5U W=0.36U AS=0.379P
+ AD=0.0612P PS=2.37U PD=0.7U
* device instance $2017 m90 *1 612.125,774.65 pfet_05v0
M$2017 \$110 \$I3477 VDD_DEC VDD_DEC pfet_05v0 L=0.5U W=1.22U AS=0.379P
+ AD=0.5368P PS=2.37U PD=3.32U
* device instance $2018 m90 *1 618.855,775.08 pfet_05v0
M$2018 VDD_DEC \$I2071 \$I3475 VDD_DEC pfet_05v0 L=0.5U W=0.36U AS=0.3852P
+ AD=0.1116P PS=2.86U PD=0.98U
* device instance $2019 m90 *1 617.735,775.08 pfet_05v0
M$2019 \$I3480 \$I3475 VDD_DEC VDD_DEC pfet_05v0 L=0.5U W=0.36U AS=0.1116P
+ AD=0.0612P PS=0.98U PD=0.7U
* device instance $2020 m90 *1 616.895,775.08 pfet_05v0
M$2020 \$I3480 \$I3475 \$I3476 VDD_DEC pfet_05v0 L=0.5U W=0.36U AS=0.3852P
+ AD=0.0612P PS=2.86U PD=0.7U
* device instance $2021 m90 *1 614.565,772.202 nfet_05v0
M$2021 \$I3479 \$I3476 \$I3477 VSS nfet_05v0 L=0.6U W=0.365U AS=0.3705P
+ AD=0.0438P PS=2.77U PD=0.605U
* device instance $2022 m90 *1 613.725,772.202 nfet_05v0
M$2022 VSS \$I3476 \$I3479 VSS nfet_05v0 L=0.6U W=0.365U AS=0.0438P
+ AD=0.282625P PS=0.605U PD=1.87U
* device instance $2023 m90 *1 612.075,772.43 nfet_05v0
M$2023 \$110 \$I3477 VSS VSS nfet_05v0 L=0.6U W=0.82U AS=0.282625P AD=0.3608P
+ PS=1.87U PD=2.52U
* device instance $2024 m90 *1 618.805,772.2 nfet_05v0
M$2024 VSS \$I2071 \$I3475 VSS nfet_05v0 L=0.6U W=0.36U AS=0.333P AD=0.0936P
+ PS=2.57U PD=0.88U
* device instance $2025 m90 *1 617.685,772.2 nfet_05v0
M$2025 \$I3478 \$I3475 VSS VSS nfet_05v0 L=0.6U W=0.36U AS=0.0936P AD=0.0432P
+ PS=0.88U PD=0.6U
* device instance $2026 m90 *1 616.845,772.2 nfet_05v0
M$2026 \$I3476 \$I3475 \$I3478 VSS nfet_05v0 L=0.6U W=0.36U AS=0.0432P
+ AD=0.369P PS=0.6U PD=2.77U
* device instance $2027 m90 *1 609.575,782.81 pfet_05v0
M$2027 \$I3488 \$I3483 \$I3484 VDD_DEC pfet_05v0 L=0.5U W=0.36U AS=0.3456P
+ AD=0.0612P PS=2.64U PD=0.7U
* device instance $2028 m90 *1 608.735,782.81 pfet_05v0
M$2028 \$I3488 \$I3483 VDD_DEC VDD_DEC pfet_05v0 L=0.5U W=0.36U AS=0.379P
+ AD=0.0612P PS=2.37U PD=0.7U
* device instance $2029 m90 *1 607.085,782.49 pfet_05v0
M$2029 \$112 \$I3484 VDD_DEC VDD_DEC pfet_05v0 L=0.5U W=1.22U AS=0.379P
+ AD=0.5368P PS=2.37U PD=3.32U
* device instance $2030 m90 *1 613.815,782.92 pfet_05v0
M$2030 VDD_DEC \$I2103 \$I3482 VDD_DEC pfet_05v0 L=0.5U W=0.36U AS=0.3852P
+ AD=0.1116P PS=2.86U PD=0.98U
* device instance $2031 m90 *1 612.695,782.92 pfet_05v0
M$2031 \$I3487 \$I3482 VDD_DEC VDD_DEC pfet_05v0 L=0.5U W=0.36U AS=0.1116P
+ AD=0.0612P PS=0.98U PD=0.7U
* device instance $2032 m90 *1 611.855,782.92 pfet_05v0
M$2032 \$I3487 \$I3482 \$I3483 VDD_DEC pfet_05v0 L=0.5U W=0.36U AS=0.3852P
+ AD=0.0612P PS=2.86U PD=0.7U
* device instance $2033 m90 *1 609.525,780.042 nfet_05v0
M$2033 \$I3486 \$I3483 \$I3484 VSS nfet_05v0 L=0.6U W=0.365U AS=0.3705P
+ AD=0.0438P PS=2.77U PD=0.605U
* device instance $2034 m90 *1 608.685,780.042 nfet_05v0
M$2034 VSS \$I3483 \$I3486 VSS nfet_05v0 L=0.6U W=0.365U AS=0.0438P
+ AD=0.282625P PS=0.605U PD=1.87U
* device instance $2035 m90 *1 607.035,780.27 nfet_05v0
M$2035 \$112 \$I3484 VSS VSS nfet_05v0 L=0.6U W=0.82U AS=0.282625P AD=0.3608P
+ PS=1.87U PD=2.52U
* device instance $2036 m90 *1 613.765,780.04 nfet_05v0
M$2036 VSS \$I2103 \$I3482 VSS nfet_05v0 L=0.6U W=0.36U AS=0.333P AD=0.0936P
+ PS=2.57U PD=0.88U
* device instance $2037 m90 *1 612.645,780.04 nfet_05v0
M$2037 \$I3485 \$I3482 VSS VSS nfet_05v0 L=0.6U W=0.36U AS=0.0936P AD=0.0432P
+ PS=0.88U PD=0.6U
* device instance $2038 m90 *1 611.805,780.04 nfet_05v0
M$2038 \$I3483 \$I3482 \$I3485 VSS nfet_05v0 L=0.6U W=0.36U AS=0.0432P
+ AD=0.369P PS=0.6U PD=2.77U
* device instance $2039 r180 *1 609.015,784.07 pfet_05v0
M$2039 \$I3495 \$I3490 \$I3491 VDD_DEC pfet_05v0 L=0.5U W=0.36U AS=0.3456P
+ AD=0.0612P PS=2.64U PD=0.7U
* device instance $2040 r180 *1 608.175,784.07 pfet_05v0
M$2040 \$I3495 \$I3490 VDD_DEC VDD_DEC pfet_05v0 L=0.5U W=0.36U AS=0.379P
+ AD=0.0612P PS=2.37U PD=0.7U
* device instance $2041 r180 *1 606.525,784.39 pfet_05v0
M$2041 \$83 \$I3491 VDD_DEC VDD_DEC pfet_05v0 L=0.5U W=1.22U AS=0.379P
+ AD=0.5368P PS=2.37U PD=3.32U
* device instance $2042 r180 *1 613.255,783.96 pfet_05v0
M$2042 VDD_DEC \$I2174 \$I3489 VDD_DEC pfet_05v0 L=0.5U W=0.36U AS=0.3852P
+ AD=0.1116P PS=2.86U PD=0.98U
* device instance $2043 r180 *1 612.135,783.96 pfet_05v0
M$2043 \$I3494 \$I3489 VDD_DEC VDD_DEC pfet_05v0 L=0.5U W=0.36U AS=0.1116P
+ AD=0.0612P PS=0.98U PD=0.7U
* device instance $2044 r180 *1 611.295,783.96 pfet_05v0
M$2044 \$I3494 \$I3489 \$I3490 VDD_DEC pfet_05v0 L=0.5U W=0.36U AS=0.3852P
+ AD=0.0612P PS=2.86U PD=0.7U
* device instance $2045 r180 *1 608.965,786.838 nfet_05v0
M$2045 \$I3493 \$I3490 \$I3491 VSS nfet_05v0 L=0.6U W=0.365U AS=0.3705P
+ AD=0.0438P PS=2.77U PD=0.605U
* device instance $2046 r180 *1 608.125,786.838 nfet_05v0
M$2046 VSS \$I3490 \$I3493 VSS nfet_05v0 L=0.6U W=0.365U AS=0.0438P
+ AD=0.282625P PS=0.605U PD=1.87U
* device instance $2047 r180 *1 606.475,786.61 nfet_05v0
M$2047 \$83 \$I3491 VSS VSS nfet_05v0 L=0.6U W=0.82U AS=0.282625P AD=0.3608P
+ PS=1.87U PD=2.52U
* device instance $2048 r180 *1 613.205,786.84 nfet_05v0
M$2048 VSS \$I2174 \$I3489 VSS nfet_05v0 L=0.6U W=0.36U AS=0.333P AD=0.0936P
+ PS=2.57U PD=0.88U
* device instance $2049 r180 *1 612.085,786.84 nfet_05v0
M$2049 \$I3492 \$I3489 VSS VSS nfet_05v0 L=0.6U W=0.36U AS=0.0936P AD=0.0432P
+ PS=0.88U PD=0.6U
* device instance $2050 r180 *1 611.245,786.84 nfet_05v0
M$2050 \$I3490 \$I3489 \$I3492 VSS nfet_05v0 L=0.6U W=0.36U AS=0.0432P
+ AD=0.369P PS=0.6U PD=2.77U
* device instance $2051 m90 *1 606.215,790.65 pfet_05v0
M$2051 \$I3502 \$I3497 \$I3498 VDD_DEC pfet_05v0 L=0.5U W=0.36U AS=0.3456P
+ AD=0.0612P PS=2.64U PD=0.7U
* device instance $2052 m90 *1 605.375,790.65 pfet_05v0
M$2052 \$I3502 \$I3497 VDD_DEC VDD_DEC pfet_05v0 L=0.5U W=0.36U AS=0.379P
+ AD=0.0612P PS=2.37U PD=0.7U
* device instance $2053 m90 *1 603.725,790.33 pfet_05v0
M$2053 \$85 \$I3498 VDD_DEC VDD_DEC pfet_05v0 L=0.5U W=1.22U AS=0.379P
+ AD=0.5368P PS=2.37U PD=3.32U
* device instance $2054 m90 *1 610.455,790.76 pfet_05v0
M$2054 VDD_DEC \$I2254 \$I3496 VDD_DEC pfet_05v0 L=0.5U W=0.36U AS=0.3852P
+ AD=0.1116P PS=2.86U PD=0.98U
* device instance $2055 m90 *1 609.335,790.76 pfet_05v0
M$2055 \$I3501 \$I3496 VDD_DEC VDD_DEC pfet_05v0 L=0.5U W=0.36U AS=0.1116P
+ AD=0.0612P PS=0.98U PD=0.7U
* device instance $2056 m90 *1 608.495,790.76 pfet_05v0
M$2056 \$I3501 \$I3496 \$I3497 VDD_DEC pfet_05v0 L=0.5U W=0.36U AS=0.3852P
+ AD=0.0612P PS=2.86U PD=0.7U
* device instance $2057 m90 *1 606.165,787.882 nfet_05v0
M$2057 \$I3500 \$I3497 \$I3498 VSS nfet_05v0 L=0.6U W=0.365U AS=0.3705P
+ AD=0.0438P PS=2.77U PD=0.605U
* device instance $2058 m90 *1 605.325,787.882 nfet_05v0
M$2058 VSS \$I3497 \$I3500 VSS nfet_05v0 L=0.6U W=0.365U AS=0.0438P
+ AD=0.282625P PS=0.605U PD=1.87U
* device instance $2059 m90 *1 603.675,788.11 nfet_05v0
M$2059 \$85 \$I3498 VSS VSS nfet_05v0 L=0.6U W=0.82U AS=0.282625P AD=0.3608P
+ PS=1.87U PD=2.52U
* device instance $2060 m90 *1 610.405,787.88 nfet_05v0
M$2060 VSS \$I2254 \$I3496 VSS nfet_05v0 L=0.6U W=0.36U AS=0.333P AD=0.0936P
+ PS=2.57U PD=0.88U
* device instance $2061 m90 *1 609.285,787.88 nfet_05v0
M$2061 \$I3499 \$I3496 VSS VSS nfet_05v0 L=0.6U W=0.36U AS=0.0936P AD=0.0432P
+ PS=0.88U PD=0.6U
* device instance $2062 m90 *1 608.445,787.88 nfet_05v0
M$2062 \$I3497 \$I3496 \$I3499 VSS nfet_05v0 L=0.6U W=0.36U AS=0.0432P
+ AD=0.369P PS=0.6U PD=2.77U
* device instance $2063 r180 *1 617.975,776.23 pfet_05v0
M$2063 \$I3509 \$I3504 \$I3505 VDD_DEC pfet_05v0 L=0.5U W=0.36U AS=0.3456P
+ AD=0.0612P PS=2.64U PD=0.7U
* device instance $2064 r180 *1 617.135,776.23 pfet_05v0
M$2064 \$I3509 \$I3504 VDD_DEC VDD_DEC pfet_05v0 L=0.5U W=0.36U AS=0.379P
+ AD=0.0612P PS=2.37U PD=0.7U
* device instance $2065 r180 *1 615.485,776.55 pfet_05v0
M$2065 \$87 \$I3505 VDD_DEC VDD_DEC pfet_05v0 L=0.5U W=1.22U AS=0.379P
+ AD=0.5368P PS=2.37U PD=3.32U
* device instance $2066 r180 *1 622.215,776.12 pfet_05v0
M$2066 VDD_DEC \$I2213 \$I3503 VDD_DEC pfet_05v0 L=0.5U W=0.36U AS=0.3852P
+ AD=0.1116P PS=2.86U PD=0.98U
* device instance $2067 r180 *1 621.095,776.12 pfet_05v0
M$2067 \$I3508 \$I3503 VDD_DEC VDD_DEC pfet_05v0 L=0.5U W=0.36U AS=0.1116P
+ AD=0.0612P PS=0.98U PD=0.7U
* device instance $2068 r180 *1 620.255,776.12 pfet_05v0
M$2068 \$I3508 \$I3503 \$I3504 VDD_DEC pfet_05v0 L=0.5U W=0.36U AS=0.3852P
+ AD=0.0612P PS=2.86U PD=0.7U
* device instance $2069 r180 *1 617.925,778.998 nfet_05v0
M$2069 \$I3507 \$I3504 \$I3505 VSS nfet_05v0 L=0.6U W=0.365U AS=0.3705P
+ AD=0.0438P PS=2.77U PD=0.605U
* device instance $2070 r180 *1 617.085,778.998 nfet_05v0
M$2070 VSS \$I3504 \$I3507 VSS nfet_05v0 L=0.6U W=0.365U AS=0.0438P
+ AD=0.282625P PS=0.605U PD=1.87U
* device instance $2071 r180 *1 615.435,778.77 nfet_05v0
M$2071 \$87 \$I3505 VSS VSS nfet_05v0 L=0.6U W=0.82U AS=0.282625P AD=0.3608P
+ PS=1.87U PD=2.52U
* device instance $2072 r180 *1 622.165,779 nfet_05v0
M$2072 VSS \$I2213 \$I3503 VSS nfet_05v0 L=0.6U W=0.36U AS=0.333P AD=0.0936P
+ PS=2.57U PD=0.88U
* device instance $2073 r180 *1 621.045,779 nfet_05v0
M$2073 \$I3506 \$I3503 VSS VSS nfet_05v0 L=0.6U W=0.36U AS=0.0936P AD=0.0432P
+ PS=0.88U PD=0.6U
* device instance $2074 r180 *1 620.205,779 nfet_05v0
M$2074 \$I3504 \$I3503 \$I3506 VSS nfet_05v0 L=0.6U W=0.36U AS=0.0432P
+ AD=0.369P PS=0.6U PD=2.77U
* device instance $2075 m90 *1 624.695,774.97 pfet_05v0
M$2075 \$I3516 \$I3511 \$I3512 VDD_DEC pfet_05v0 L=0.5U W=0.36U AS=0.3456P
+ AD=0.0612P PS=2.64U PD=0.7U
* device instance $2076 m90 *1 623.855,774.97 pfet_05v0
M$2076 \$I3516 \$I3511 VDD_DEC VDD_DEC pfet_05v0 L=0.5U W=0.36U AS=0.379P
+ AD=0.0612P PS=2.37U PD=0.7U
* device instance $2077 m90 *1 622.205,774.65 pfet_05v0
M$2077 \$89 \$I3512 VDD_DEC VDD_DEC pfet_05v0 L=0.5U W=1.22U AS=0.379P
+ AD=0.5368P PS=2.37U PD=3.32U
* device instance $2078 m90 *1 628.935,775.08 pfet_05v0
M$2078 VDD_DEC \$I2257 \$I3510 VDD_DEC pfet_05v0 L=0.5U W=0.36U AS=0.3852P
+ AD=0.1116P PS=2.86U PD=0.98U
* device instance $2079 m90 *1 627.815,775.08 pfet_05v0
M$2079 \$I3515 \$I3510 VDD_DEC VDD_DEC pfet_05v0 L=0.5U W=0.36U AS=0.1116P
+ AD=0.0612P PS=0.98U PD=0.7U
* device instance $2080 m90 *1 626.975,775.08 pfet_05v0
M$2080 \$I3515 \$I3510 \$I3511 VDD_DEC pfet_05v0 L=0.5U W=0.36U AS=0.3852P
+ AD=0.0612P PS=2.86U PD=0.7U
* device instance $2081 m90 *1 624.645,772.202 nfet_05v0
M$2081 \$I3514 \$I3511 \$I3512 VSS nfet_05v0 L=0.6U W=0.365U AS=0.3705P
+ AD=0.0438P PS=2.77U PD=0.605U
* device instance $2082 m90 *1 623.805,772.202 nfet_05v0
M$2082 VSS \$I3511 \$I3514 VSS nfet_05v0 L=0.6U W=0.365U AS=0.0438P
+ AD=0.282625P PS=0.605U PD=1.87U
* device instance $2083 m90 *1 622.155,772.43 nfet_05v0
M$2083 \$89 \$I3512 VSS VSS nfet_05v0 L=0.6U W=0.82U AS=0.282625P AD=0.3608P
+ PS=1.87U PD=2.52U
* device instance $2084 m90 *1 628.885,772.2 nfet_05v0
M$2084 VSS \$I2257 \$I3510 VSS nfet_05v0 L=0.6U W=0.36U AS=0.333P AD=0.0936P
+ PS=2.57U PD=0.88U
* device instance $2085 m90 *1 627.765,772.2 nfet_05v0
M$2085 \$I3513 \$I3510 VSS VSS nfet_05v0 L=0.6U W=0.36U AS=0.0936P AD=0.0432P
+ PS=0.88U PD=0.6U
* device instance $2086 m90 *1 626.925,772.2 nfet_05v0
M$2086 \$I3511 \$I3510 \$I3513 VSS nfet_05v0 L=0.6U W=0.36U AS=0.0432P
+ AD=0.369P PS=0.6U PD=2.77U
* device instance $2087 m90 *1 618.535,782.81 pfet_05v0
M$2087 \$I3523 \$I3518 \$I3519 VDD_DEC pfet_05v0 L=0.5U W=0.36U AS=0.3456P
+ AD=0.0612P PS=2.64U PD=0.7U
* device instance $2088 m90 *1 617.695,782.81 pfet_05v0
M$2088 \$I3523 \$I3518 VDD_DEC VDD_DEC pfet_05v0 L=0.5U W=0.36U AS=0.379P
+ AD=0.0612P PS=2.37U PD=0.7U
* device instance $2089 m90 *1 616.045,782.49 pfet_05v0
M$2089 \$91 \$I3519 VDD_DEC VDD_DEC pfet_05v0 L=0.5U W=1.22U AS=0.379P
+ AD=0.5368P PS=2.37U PD=3.32U
* device instance $2090 m90 *1 622.775,782.92 pfet_05v0
M$2090 VDD_DEC \$I2073 \$I3517 VDD_DEC pfet_05v0 L=0.5U W=0.36U AS=0.3852P
+ AD=0.1116P PS=2.86U PD=0.98U
* device instance $2091 m90 *1 621.655,782.92 pfet_05v0
M$2091 \$I3522 \$I3517 VDD_DEC VDD_DEC pfet_05v0 L=0.5U W=0.36U AS=0.1116P
+ AD=0.0612P PS=0.98U PD=0.7U
* device instance $2092 m90 *1 620.815,782.92 pfet_05v0
M$2092 \$I3522 \$I3517 \$I3518 VDD_DEC pfet_05v0 L=0.5U W=0.36U AS=0.3852P
+ AD=0.0612P PS=2.86U PD=0.7U
* device instance $2093 m90 *1 618.485,780.042 nfet_05v0
M$2093 \$I3521 \$I3518 \$I3519 VSS nfet_05v0 L=0.6U W=0.365U AS=0.3705P
+ AD=0.0438P PS=2.77U PD=0.605U
* device instance $2094 m90 *1 617.645,780.042 nfet_05v0
M$2094 VSS \$I3518 \$I3521 VSS nfet_05v0 L=0.6U W=0.365U AS=0.0438P
+ AD=0.282625P PS=0.605U PD=1.87U
* device instance $2095 m90 *1 615.995,780.27 nfet_05v0
M$2095 \$91 \$I3519 VSS VSS nfet_05v0 L=0.6U W=0.82U AS=0.282625P AD=0.3608P
+ PS=1.87U PD=2.52U
* device instance $2096 m90 *1 622.725,780.04 nfet_05v0
M$2096 VSS \$I2073 \$I3517 VSS nfet_05v0 L=0.6U W=0.36U AS=0.333P AD=0.0936P
+ PS=2.57U PD=0.88U
* device instance $2097 m90 *1 621.605,780.04 nfet_05v0
M$2097 \$I3520 \$I3517 VSS VSS nfet_05v0 L=0.6U W=0.36U AS=0.0936P AD=0.0432P
+ PS=0.88U PD=0.6U
* device instance $2098 m90 *1 620.765,780.04 nfet_05v0
M$2098 \$I3518 \$I3517 \$I3520 VSS nfet_05v0 L=0.6U W=0.36U AS=0.0432P
+ AD=0.369P PS=0.6U PD=2.77U
* device instance $2099 r180 *1 609.015,791.91 pfet_05v0
M$2099 \$I3530 \$I3525 \$I3526 VDD_DEC pfet_05v0 L=0.5U W=0.36U AS=0.3456P
+ AD=0.0612P PS=2.64U PD=0.7U
* device instance $2100 r180 *1 608.175,791.91 pfet_05v0
M$2100 \$I3530 \$I3525 VDD_DEC VDD_DEC pfet_05v0 L=0.5U W=0.36U AS=0.379P
+ AD=0.0612P PS=2.37U PD=0.7U
* device instance $2101 r180 *1 606.525,792.23 pfet_05v0
M$2101 \$93 \$I3526 VDD_DEC VDD_DEC pfet_05v0 L=0.5U W=1.22U AS=0.379P
+ AD=0.5368P PS=2.37U PD=3.32U
* device instance $2102 r180 *1 613.255,791.8 pfet_05v0
M$2102 VDD_DEC \$I2242 \$I3524 VDD_DEC pfet_05v0 L=0.5U W=0.36U AS=0.3852P
+ AD=0.1116P PS=2.86U PD=0.98U
* device instance $2103 r180 *1 612.135,791.8 pfet_05v0
M$2103 \$I3529 \$I3524 VDD_DEC VDD_DEC pfet_05v0 L=0.5U W=0.36U AS=0.1116P
+ AD=0.0612P PS=0.98U PD=0.7U
* device instance $2104 r180 *1 611.295,791.8 pfet_05v0
M$2104 \$I3529 \$I3524 \$I3525 VDD_DEC pfet_05v0 L=0.5U W=0.36U AS=0.3852P
+ AD=0.0612P PS=2.86U PD=0.7U
* device instance $2105 r180 *1 608.965,794.678 nfet_05v0
M$2105 \$I3528 \$I3525 \$I3526 VSS nfet_05v0 L=0.6U W=0.365U AS=0.3705P
+ AD=0.0438P PS=2.77U PD=0.605U
* device instance $2106 r180 *1 608.125,794.678 nfet_05v0
M$2106 VSS \$I3525 \$I3528 VSS nfet_05v0 L=0.6U W=0.365U AS=0.0438P
+ AD=0.282625P PS=0.605U PD=1.87U
* device instance $2107 r180 *1 606.475,794.45 nfet_05v0
M$2107 \$93 \$I3526 VSS VSS nfet_05v0 L=0.6U W=0.82U AS=0.282625P AD=0.3608P
+ PS=1.87U PD=2.52U
* device instance $2108 r180 *1 613.205,794.68 nfet_05v0
M$2108 VSS \$I2242 \$I3524 VSS nfet_05v0 L=0.6U W=0.36U AS=0.333P AD=0.0936P
+ PS=2.57U PD=0.88U
* device instance $2109 r180 *1 612.085,794.68 nfet_05v0
M$2109 \$I3527 \$I3524 VSS VSS nfet_05v0 L=0.6U W=0.36U AS=0.0936P AD=0.0432P
+ PS=0.88U PD=0.6U
* device instance $2110 r180 *1 611.245,794.68 nfet_05v0
M$2110 \$I3525 \$I3524 \$I3527 VSS nfet_05v0 L=0.6U W=0.36U AS=0.0432P
+ AD=0.369P PS=0.6U PD=2.77U
* device instance $2111 r180 *1 617.975,784.07 pfet_05v0
M$2111 \$I3537 \$I3532 \$I3533 VDD_DEC pfet_05v0 L=0.5U W=0.36U AS=0.3456P
+ AD=0.0612P PS=2.64U PD=0.7U
* device instance $2112 r180 *1 617.135,784.07 pfet_05v0
M$2112 \$I3537 \$I3532 VDD_DEC VDD_DEC pfet_05v0 L=0.5U W=0.36U AS=0.379P
+ AD=0.0612P PS=2.37U PD=0.7U
* device instance $2113 r180 *1 615.485,784.39 pfet_05v0
M$2113 \$95 \$I3533 VDD_DEC VDD_DEC pfet_05v0 L=0.5U W=1.22U AS=0.379P
+ AD=0.5368P PS=2.37U PD=3.32U
* device instance $2114 r180 *1 622.215,783.96 pfet_05v0
M$2114 VDD_DEC \$I2136 \$I3531 VDD_DEC pfet_05v0 L=0.5U W=0.36U AS=0.3852P
+ AD=0.1116P PS=2.86U PD=0.98U
* device instance $2115 r180 *1 621.095,783.96 pfet_05v0
M$2115 \$I3536 \$I3531 VDD_DEC VDD_DEC pfet_05v0 L=0.5U W=0.36U AS=0.1116P
+ AD=0.0612P PS=0.98U PD=0.7U
* device instance $2116 r180 *1 620.255,783.96 pfet_05v0
M$2116 \$I3536 \$I3531 \$I3532 VDD_DEC pfet_05v0 L=0.5U W=0.36U AS=0.3852P
+ AD=0.0612P PS=2.86U PD=0.7U
* device instance $2117 r180 *1 617.925,786.838 nfet_05v0
M$2117 \$I3535 \$I3532 \$I3533 VSS nfet_05v0 L=0.6U W=0.365U AS=0.3705P
+ AD=0.0438P PS=2.77U PD=0.605U
* device instance $2118 r180 *1 617.085,786.838 nfet_05v0
M$2118 VSS \$I3532 \$I3535 VSS nfet_05v0 L=0.6U W=0.365U AS=0.0438P
+ AD=0.282625P PS=0.605U PD=1.87U
* device instance $2119 r180 *1 615.435,786.61 nfet_05v0
M$2119 \$95 \$I3533 VSS VSS nfet_05v0 L=0.6U W=0.82U AS=0.282625P AD=0.3608P
+ PS=1.87U PD=2.52U
* device instance $2120 r180 *1 622.165,786.84 nfet_05v0
M$2120 VSS \$I2136 \$I3531 VSS nfet_05v0 L=0.6U W=0.36U AS=0.333P AD=0.0936P
+ PS=2.57U PD=0.88U
* device instance $2121 r180 *1 621.045,786.84 nfet_05v0
M$2121 \$I3534 \$I3531 VSS VSS nfet_05v0 L=0.6U W=0.36U AS=0.0936P AD=0.0432P
+ PS=0.88U PD=0.6U
* device instance $2122 r180 *1 620.205,786.84 nfet_05v0
M$2122 \$I3532 \$I3531 \$I3534 VSS nfet_05v0 L=0.6U W=0.36U AS=0.0432P
+ AD=0.369P PS=0.6U PD=2.77U
* device instance $2123 m90 *1 615.175,790.65 pfet_05v0
M$2123 \$I3544 \$I3539 \$I3540 VDD_DEC pfet_05v0 L=0.5U W=0.36U AS=0.3456P
+ AD=0.0612P PS=2.64U PD=0.7U
* device instance $2124 m90 *1 614.335,790.65 pfet_05v0
M$2124 \$I3544 \$I3539 VDD_DEC VDD_DEC pfet_05v0 L=0.5U W=0.36U AS=0.379P
+ AD=0.0612P PS=2.37U PD=0.7U
* device instance $2125 m90 *1 612.685,790.33 pfet_05v0
M$2125 \$97 \$I3540 VDD_DEC VDD_DEC pfet_05v0 L=0.5U W=1.22U AS=0.379P
+ AD=0.5368P PS=2.37U PD=3.32U
* device instance $2126 m90 *1 619.415,790.76 pfet_05v0
M$2126 VDD_DEC \$I2255 \$I3538 VDD_DEC pfet_05v0 L=0.5U W=0.36U AS=0.3852P
+ AD=0.1116P PS=2.86U PD=0.98U
* device instance $2127 m90 *1 618.295,790.76 pfet_05v0
M$2127 \$I3543 \$I3538 VDD_DEC VDD_DEC pfet_05v0 L=0.5U W=0.36U AS=0.1116P
+ AD=0.0612P PS=0.98U PD=0.7U
* device instance $2128 m90 *1 617.455,790.76 pfet_05v0
M$2128 \$I3543 \$I3538 \$I3539 VDD_DEC pfet_05v0 L=0.5U W=0.36U AS=0.3852P
+ AD=0.0612P PS=2.86U PD=0.7U
* device instance $2129 m90 *1 615.125,787.882 nfet_05v0
M$2129 \$I3542 \$I3539 \$I3540 VSS nfet_05v0 L=0.6U W=0.365U AS=0.3705P
+ AD=0.0438P PS=2.77U PD=0.605U
* device instance $2130 m90 *1 614.285,787.882 nfet_05v0
M$2130 VSS \$I3539 \$I3542 VSS nfet_05v0 L=0.6U W=0.365U AS=0.0438P
+ AD=0.282625P PS=0.605U PD=1.87U
* device instance $2131 m90 *1 612.635,788.11 nfet_05v0
M$2131 \$97 \$I3540 VSS VSS nfet_05v0 L=0.6U W=0.82U AS=0.282625P AD=0.3608P
+ PS=1.87U PD=2.52U
* device instance $2132 m90 *1 619.365,787.88 nfet_05v0
M$2132 VSS \$I2255 \$I3538 VSS nfet_05v0 L=0.6U W=0.36U AS=0.333P AD=0.0936P
+ PS=2.57U PD=0.88U
* device instance $2133 m90 *1 618.245,787.88 nfet_05v0
M$2133 \$I3541 \$I3538 VSS VSS nfet_05v0 L=0.6U W=0.36U AS=0.0936P AD=0.0432P
+ PS=0.88U PD=0.6U
* device instance $2134 m90 *1 617.405,787.88 nfet_05v0
M$2134 \$I3539 \$I3538 \$I3541 VSS nfet_05v0 L=0.6U W=0.36U AS=0.0432P
+ AD=0.369P PS=0.6U PD=2.77U
* device instance $2135 r180 *1 626.935,776.23 pfet_05v0
M$2135 \$I3551 \$I3546 \$I3547 VDD_DEC pfet_05v0 L=0.5U W=0.36U AS=0.3456P
+ AD=0.0612P PS=2.64U PD=0.7U
* device instance $2136 r180 *1 626.095,776.23 pfet_05v0
M$2136 \$I3551 \$I3546 VDD_DEC VDD_DEC pfet_05v0 L=0.5U W=0.36U AS=0.379P
+ AD=0.0612P PS=2.37U PD=0.7U
* device instance $2137 r180 *1 624.445,776.55 pfet_05v0
M$2137 \$99 \$I3547 VDD_DEC VDD_DEC pfet_05v0 L=0.5U W=1.22U AS=0.379P
+ AD=0.5368P PS=2.37U PD=3.32U
* device instance $2138 r180 *1 631.175,776.12 pfet_05v0
M$2138 VDD_DEC \$I2104 \$I3545 VDD_DEC pfet_05v0 L=0.5U W=0.36U AS=0.3852P
+ AD=0.1116P PS=2.86U PD=0.98U
* device instance $2139 r180 *1 630.055,776.12 pfet_05v0
M$2139 \$I3550 \$I3545 VDD_DEC VDD_DEC pfet_05v0 L=0.5U W=0.36U AS=0.1116P
+ AD=0.0612P PS=0.98U PD=0.7U
* device instance $2140 r180 *1 629.215,776.12 pfet_05v0
M$2140 \$I3550 \$I3545 \$I3546 VDD_DEC pfet_05v0 L=0.5U W=0.36U AS=0.3852P
+ AD=0.0612P PS=2.86U PD=0.7U
* device instance $2141 r180 *1 626.885,778.998 nfet_05v0
M$2141 \$I3549 \$I3546 \$I3547 VSS nfet_05v0 L=0.6U W=0.365U AS=0.3705P
+ AD=0.0438P PS=2.77U PD=0.605U
* device instance $2142 r180 *1 626.045,778.998 nfet_05v0
M$2142 VSS \$I3546 \$I3549 VSS nfet_05v0 L=0.6U W=0.365U AS=0.0438P
+ AD=0.282625P PS=0.605U PD=1.87U
* device instance $2143 r180 *1 624.395,778.77 nfet_05v0
M$2143 \$99 \$I3547 VSS VSS nfet_05v0 L=0.6U W=0.82U AS=0.282625P AD=0.3608P
+ PS=1.87U PD=2.52U
* device instance $2144 r180 *1 631.125,779 nfet_05v0
M$2144 VSS \$I2104 \$I3545 VSS nfet_05v0 L=0.6U W=0.36U AS=0.333P AD=0.0936P
+ PS=2.57U PD=0.88U
* device instance $2145 r180 *1 630.005,779 nfet_05v0
M$2145 \$I3548 \$I3545 VSS VSS nfet_05v0 L=0.6U W=0.36U AS=0.0936P AD=0.0432P
+ PS=0.88U PD=0.6U
* device instance $2146 r180 *1 629.165,779 nfet_05v0
M$2146 \$I3546 \$I3545 \$I3548 VSS nfet_05v0 L=0.6U W=0.36U AS=0.0432P
+ AD=0.369P PS=0.6U PD=2.77U
* device instance $2147 m90 *1 633.655,774.97 pfet_05v0
M$2147 \$I3558 \$I3553 \$I3554 VDD_DEC pfet_05v0 L=0.5U W=0.36U AS=0.3456P
+ AD=0.0612P PS=2.64U PD=0.7U
* device instance $2148 m90 *1 632.815,774.97 pfet_05v0
M$2148 \$I3558 \$I3553 VDD_DEC VDD_DEC pfet_05v0 L=0.5U W=0.36U AS=0.379P
+ AD=0.0612P PS=2.37U PD=0.7U
* device instance $2149 m90 *1 631.165,774.65 pfet_05v0
M$2149 \$101 \$I3554 VDD_DEC VDD_DEC pfet_05v0 L=0.5U W=1.22U AS=0.379P
+ AD=0.5368P PS=2.37U PD=3.32U
* device instance $2150 m90 *1 637.895,775.08 pfet_05v0
M$2150 VDD_DEC \$I2031 \$I3552 VDD_DEC pfet_05v0 L=0.5U W=0.36U AS=0.3852P
+ AD=0.1116P PS=2.86U PD=0.98U
* device instance $2151 m90 *1 636.775,775.08 pfet_05v0
M$2151 \$I3557 \$I3552 VDD_DEC VDD_DEC pfet_05v0 L=0.5U W=0.36U AS=0.1116P
+ AD=0.0612P PS=0.98U PD=0.7U
* device instance $2152 m90 *1 635.935,775.08 pfet_05v0
M$2152 \$I3557 \$I3552 \$I3553 VDD_DEC pfet_05v0 L=0.5U W=0.36U AS=0.3852P
+ AD=0.0612P PS=2.86U PD=0.7U
* device instance $2153 m90 *1 633.605,772.202 nfet_05v0
M$2153 \$I3556 \$I3553 \$I3554 VSS nfet_05v0 L=0.6U W=0.365U AS=0.3705P
+ AD=0.0438P PS=2.77U PD=0.605U
* device instance $2154 m90 *1 632.765,772.202 nfet_05v0
M$2154 VSS \$I3553 \$I3556 VSS nfet_05v0 L=0.6U W=0.365U AS=0.0438P
+ AD=0.282625P PS=0.605U PD=1.87U
* device instance $2155 m90 *1 631.115,772.43 nfet_05v0
M$2155 \$101 \$I3554 VSS VSS nfet_05v0 L=0.6U W=0.82U AS=0.282625P AD=0.3608P
+ PS=1.87U PD=2.52U
* device instance $2156 m90 *1 637.845,772.2 nfet_05v0
M$2156 VSS \$I2031 \$I3552 VSS nfet_05v0 L=0.6U W=0.36U AS=0.333P AD=0.0936P
+ PS=2.57U PD=0.88U
* device instance $2157 m90 *1 636.725,772.2 nfet_05v0
M$2157 \$I3555 \$I3552 VSS VSS nfet_05v0 L=0.6U W=0.36U AS=0.0936P AD=0.0432P
+ PS=0.88U PD=0.6U
* device instance $2158 m90 *1 635.885,772.2 nfet_05v0
M$2158 \$I3553 \$I3552 \$I3555 VSS nfet_05v0 L=0.6U W=0.36U AS=0.0432P
+ AD=0.369P PS=0.6U PD=2.77U
* device instance $2159 m90 *1 612.935,798.49 pfet_05v0
M$2159 \$I3565 \$I3560 \$I3561 VDD_DEC pfet_05v0 L=0.5U W=0.36U AS=0.3456P
+ AD=0.0612P PS=2.64U PD=0.7U
* device instance $2160 m90 *1 612.095,798.49 pfet_05v0
M$2160 \$I3565 \$I3560 VDD_DEC VDD_DEC pfet_05v0 L=0.5U W=0.36U AS=0.379P
+ AD=0.0612P PS=2.37U PD=0.7U
* device instance $2161 m90 *1 610.445,798.17 pfet_05v0
M$2161 \$103 \$I3561 VDD_DEC VDD_DEC pfet_05v0 L=0.5U W=1.22U AS=0.379P
+ AD=0.5368P PS=2.37U PD=3.32U
* device instance $2162 m90 *1 617.175,798.6 pfet_05v0
M$2162 VDD_DEC \$I2244 \$I3559 VDD_DEC pfet_05v0 L=0.5U W=0.36U AS=0.3852P
+ AD=0.1116P PS=2.86U PD=0.98U
* device instance $2163 m90 *1 616.055,798.6 pfet_05v0
M$2163 \$I3564 \$I3559 VDD_DEC VDD_DEC pfet_05v0 L=0.5U W=0.36U AS=0.1116P
+ AD=0.0612P PS=0.98U PD=0.7U
* device instance $2164 m90 *1 615.215,798.6 pfet_05v0
M$2164 \$I3564 \$I3559 \$I3560 VDD_DEC pfet_05v0 L=0.5U W=0.36U AS=0.3852P
+ AD=0.0612P PS=2.86U PD=0.7U
* device instance $2165 m90 *1 612.885,795.722 nfet_05v0
M$2165 \$I3563 \$I3560 \$I3561 VSS nfet_05v0 L=0.6U W=0.365U AS=0.3705P
+ AD=0.0438P PS=2.77U PD=0.605U
* device instance $2166 m90 *1 612.045,795.722 nfet_05v0
M$2166 VSS \$I3560 \$I3563 VSS nfet_05v0 L=0.6U W=0.365U AS=0.0438P
+ AD=0.282625P PS=0.605U PD=1.87U
* device instance $2167 m90 *1 610.395,795.95 nfet_05v0
M$2167 \$103 \$I3561 VSS VSS nfet_05v0 L=0.6U W=0.82U AS=0.282625P AD=0.3608P
+ PS=1.87U PD=2.52U
* device instance $2168 m90 *1 617.125,795.72 nfet_05v0
M$2168 VSS \$I2244 \$I3559 VSS nfet_05v0 L=0.6U W=0.36U AS=0.333P AD=0.0936P
+ PS=2.57U PD=0.88U
* device instance $2169 m90 *1 616.005,795.72 nfet_05v0
M$2169 \$I3562 \$I3559 VSS VSS nfet_05v0 L=0.6U W=0.36U AS=0.0936P AD=0.0432P
+ PS=0.88U PD=0.6U
* device instance $2170 m90 *1 615.165,795.72 nfet_05v0
M$2170 \$I3560 \$I3559 \$I3562 VSS nfet_05v0 L=0.6U W=0.36U AS=0.0432P
+ AD=0.369P PS=0.6U PD=2.77U
* device instance $2171 m90 *1 628.615,782.81 pfet_05v0
M$2171 \$I3572 \$I3567 \$I3568 VDD_DEC pfet_05v0 L=0.5U W=0.36U AS=0.3456P
+ AD=0.0612P PS=2.64U PD=0.7U
* device instance $2172 m90 *1 627.775,782.81 pfet_05v0
M$2172 \$I3572 \$I3567 VDD_DEC VDD_DEC pfet_05v0 L=0.5U W=0.36U AS=0.379P
+ AD=0.0612P PS=2.37U PD=0.7U
* device instance $2173 m90 *1 626.125,782.49 pfet_05v0
M$2173 \$105 \$I3568 VDD_DEC VDD_DEC pfet_05v0 L=0.5U W=1.22U AS=0.379P
+ AD=0.5368P PS=2.37U PD=3.32U
* device instance $2174 m90 *1 632.855,782.92 pfet_05v0
M$2174 VDD_DEC \$I2074 \$I3566 VDD_DEC pfet_05v0 L=0.5U W=0.36U AS=0.3852P
+ AD=0.1116P PS=2.86U PD=0.98U
* device instance $2175 m90 *1 631.735,782.92 pfet_05v0
M$2175 \$I3571 \$I3566 VDD_DEC VDD_DEC pfet_05v0 L=0.5U W=0.36U AS=0.1116P
+ AD=0.0612P PS=0.98U PD=0.7U
* device instance $2176 m90 *1 630.895,782.92 pfet_05v0
M$2176 \$I3571 \$I3566 \$I3567 VDD_DEC pfet_05v0 L=0.5U W=0.36U AS=0.3852P
+ AD=0.0612P PS=2.86U PD=0.7U
* device instance $2177 m90 *1 628.565,780.042 nfet_05v0
M$2177 \$I3570 \$I3567 \$I3568 VSS nfet_05v0 L=0.6U W=0.365U AS=0.3705P
+ AD=0.0438P PS=2.77U PD=0.605U
* device instance $2178 m90 *1 627.725,780.042 nfet_05v0
M$2178 VSS \$I3567 \$I3570 VSS nfet_05v0 L=0.6U W=0.365U AS=0.0438P
+ AD=0.282625P PS=0.605U PD=1.87U
* device instance $2179 m90 *1 626.075,780.27 nfet_05v0
M$2179 \$105 \$I3568 VSS VSS nfet_05v0 L=0.6U W=0.82U AS=0.282625P AD=0.3608P
+ PS=1.87U PD=2.52U
* device instance $2180 m90 *1 632.805,780.04 nfet_05v0
M$2180 VSS \$I2074 \$I3566 VSS nfet_05v0 L=0.6U W=0.36U AS=0.333P AD=0.0936P
+ PS=2.57U PD=0.88U
* device instance $2181 m90 *1 631.685,780.04 nfet_05v0
M$2181 \$I3569 \$I3566 VSS VSS nfet_05v0 L=0.6U W=0.36U AS=0.0936P AD=0.0432P
+ PS=0.88U PD=0.6U
* device instance $2182 m90 *1 630.845,780.04 nfet_05v0
M$2182 \$I3567 \$I3566 \$I3569 VSS nfet_05v0 L=0.6U W=0.36U AS=0.0432P
+ AD=0.369P PS=0.6U PD=2.77U
* device instance $2183 r180 *1 626.935,784.07 pfet_05v0
M$2183 \$I3579 \$I3574 \$I3575 VDD_DEC pfet_05v0 L=0.5U W=0.36U AS=0.3456P
+ AD=0.0612P PS=2.64U PD=0.7U
* device instance $2184 r180 *1 626.095,784.07 pfet_05v0
M$2184 \$I3579 \$I3574 VDD_DEC VDD_DEC pfet_05v0 L=0.5U W=0.36U AS=0.379P
+ AD=0.0612P PS=2.37U PD=0.7U
* device instance $2185 r180 *1 624.445,784.39 pfet_05v0
M$2185 \$107 \$I3575 VDD_DEC VDD_DEC pfet_05v0 L=0.5U W=1.22U AS=0.379P
+ AD=0.5368P PS=2.37U PD=3.32U
* device instance $2186 r180 *1 631.175,783.96 pfet_05v0
M$2186 VDD_DEC \$I2137 \$I3573 VDD_DEC pfet_05v0 L=0.5U W=0.36U AS=0.3852P
+ AD=0.1116P PS=2.86U PD=0.98U
* device instance $2187 r180 *1 630.055,783.96 pfet_05v0
M$2187 \$I3578 \$I3573 VDD_DEC VDD_DEC pfet_05v0 L=0.5U W=0.36U AS=0.1116P
+ AD=0.0612P PS=0.98U PD=0.7U
* device instance $2188 r180 *1 629.215,783.96 pfet_05v0
M$2188 \$I3578 \$I3573 \$I3574 VDD_DEC pfet_05v0 L=0.5U W=0.36U AS=0.3852P
+ AD=0.0612P PS=2.86U PD=0.7U
* device instance $2189 r180 *1 626.885,786.838 nfet_05v0
M$2189 \$I3577 \$I3574 \$I3575 VSS nfet_05v0 L=0.6U W=0.365U AS=0.3705P
+ AD=0.0438P PS=2.77U PD=0.605U
* device instance $2190 r180 *1 626.045,786.838 nfet_05v0
M$2190 VSS \$I3574 \$I3577 VSS nfet_05v0 L=0.6U W=0.365U AS=0.0438P
+ AD=0.282625P PS=0.605U PD=1.87U
* device instance $2191 r180 *1 624.395,786.61 nfet_05v0
M$2191 \$107 \$I3575 VSS VSS nfet_05v0 L=0.6U W=0.82U AS=0.282625P AD=0.3608P
+ PS=1.87U PD=2.52U
* device instance $2192 r180 *1 631.125,786.84 nfet_05v0
M$2192 VSS \$I2137 \$I3573 VSS nfet_05v0 L=0.6U W=0.36U AS=0.333P AD=0.0936P
+ PS=2.57U PD=0.88U
* device instance $2193 r180 *1 630.005,786.84 nfet_05v0
M$2193 \$I3576 \$I3573 VSS VSS nfet_05v0 L=0.6U W=0.36U AS=0.0936P AD=0.0432P
+ PS=0.88U PD=0.6U
* device instance $2194 r180 *1 629.165,786.84 nfet_05v0
M$2194 \$I3574 \$I3573 \$I3576 VSS nfet_05v0 L=0.6U W=0.36U AS=0.0432P
+ AD=0.369P PS=0.6U PD=2.77U
* device instance $2195 r180 *1 635.895,776.23 pfet_05v0
M$2195 \$I3586 \$I3581 \$I3582 VDD_DEC pfet_05v0 L=0.5U W=0.36U AS=0.3456P
+ AD=0.0612P PS=2.64U PD=0.7U
* device instance $2196 r180 *1 635.055,776.23 pfet_05v0
M$2196 \$I3586 \$I3581 VDD_DEC VDD_DEC pfet_05v0 L=0.5U W=0.36U AS=0.379P
+ AD=0.0612P PS=2.37U PD=0.7U
* device instance $2197 r180 *1 633.405,776.55 pfet_05v0
M$2197 \$109 \$I3582 VDD_DEC VDD_DEC pfet_05v0 L=0.5U W=1.22U AS=0.379P
+ AD=0.5368P PS=2.37U PD=3.32U
* device instance $2198 r180 *1 640.135,776.12 pfet_05v0
M$2198 VDD_DEC \$I2076 \$I3580 VDD_DEC pfet_05v0 L=0.5U W=0.36U AS=0.3852P
+ AD=0.1116P PS=2.86U PD=0.98U
* device instance $2199 r180 *1 639.015,776.12 pfet_05v0
M$2199 \$I3585 \$I3580 VDD_DEC VDD_DEC pfet_05v0 L=0.5U W=0.36U AS=0.1116P
+ AD=0.0612P PS=0.98U PD=0.7U
* device instance $2200 r180 *1 638.175,776.12 pfet_05v0
M$2200 \$I3585 \$I3580 \$I3581 VDD_DEC pfet_05v0 L=0.5U W=0.36U AS=0.3852P
+ AD=0.0612P PS=2.86U PD=0.7U
* device instance $2201 r180 *1 635.845,778.998 nfet_05v0
M$2201 \$I3584 \$I3581 \$I3582 VSS nfet_05v0 L=0.6U W=0.365U AS=0.3705P
+ AD=0.0438P PS=2.77U PD=0.605U
* device instance $2202 r180 *1 635.005,778.998 nfet_05v0
M$2202 VSS \$I3581 \$I3584 VSS nfet_05v0 L=0.6U W=0.365U AS=0.0438P
+ AD=0.282625P PS=0.605U PD=1.87U
* device instance $2203 r180 *1 633.355,778.77 nfet_05v0
M$2203 \$109 \$I3582 VSS VSS nfet_05v0 L=0.6U W=0.82U AS=0.282625P AD=0.3608P
+ PS=1.87U PD=2.52U
* device instance $2204 r180 *1 640.085,779 nfet_05v0
M$2204 VSS \$I2076 \$I3580 VSS nfet_05v0 L=0.6U W=0.36U AS=0.333P AD=0.0936P
+ PS=2.57U PD=0.88U
* device instance $2205 r180 *1 638.965,779 nfet_05v0
M$2205 \$I3583 \$I3580 VSS VSS nfet_05v0 L=0.6U W=0.36U AS=0.0936P AD=0.0432P
+ PS=0.88U PD=0.6U
* device instance $2206 r180 *1 638.125,779 nfet_05v0
M$2206 \$I3581 \$I3580 \$I3583 VSS nfet_05v0 L=0.6U W=0.36U AS=0.0432P
+ AD=0.369P PS=0.6U PD=2.77U
* device instance $2207 m90 *1 643.735,774.97 pfet_05v0
M$2207 \$I3593 \$I3588 \$I3589 VDD_DEC pfet_05v0 L=0.5U W=0.36U AS=0.3456P
+ AD=0.0612P PS=2.64U PD=0.7U
* device instance $2208 m90 *1 642.895,774.97 pfet_05v0
M$2208 \$I3593 \$I3588 VDD_DEC VDD_DEC pfet_05v0 L=0.5U W=0.36U AS=0.379P
+ AD=0.0612P PS=2.37U PD=0.7U
* device instance $2209 m90 *1 641.245,774.65 pfet_05v0
M$2209 \$111 \$I3589 VDD_DEC VDD_DEC pfet_05v0 L=0.5U W=1.22U AS=0.379P
+ AD=0.5368P PS=2.37U PD=3.32U
* device instance $2210 m90 *1 647.975,775.08 pfet_05v0
M$2210 VDD_DEC \$I2168 \$I3587 VDD_DEC pfet_05v0 L=0.5U W=0.36U AS=0.3852P
+ AD=0.1116P PS=2.86U PD=0.98U
* device instance $2211 m90 *1 646.855,775.08 pfet_05v0
M$2211 \$I3592 \$I3587 VDD_DEC VDD_DEC pfet_05v0 L=0.5U W=0.36U AS=0.1116P
+ AD=0.0612P PS=0.98U PD=0.7U
* device instance $2212 m90 *1 646.015,775.08 pfet_05v0
M$2212 \$I3592 \$I3587 \$I3588 VDD_DEC pfet_05v0 L=0.5U W=0.36U AS=0.3852P
+ AD=0.0612P PS=2.86U PD=0.7U
* device instance $2213 m90 *1 643.685,772.202 nfet_05v0
M$2213 \$I3591 \$I3588 \$I3589 VSS nfet_05v0 L=0.6U W=0.365U AS=0.3705P
+ AD=0.0438P PS=2.77U PD=0.605U
* device instance $2214 m90 *1 642.845,772.202 nfet_05v0
M$2214 VSS \$I3588 \$I3591 VSS nfet_05v0 L=0.6U W=0.365U AS=0.0438P
+ AD=0.282625P PS=0.605U PD=1.87U
* device instance $2215 m90 *1 641.195,772.43 nfet_05v0
M$2215 \$111 \$I3589 VSS VSS nfet_05v0 L=0.6U W=0.82U AS=0.282625P AD=0.3608P
+ PS=1.87U PD=2.52U
* device instance $2216 m90 *1 647.925,772.2 nfet_05v0
M$2216 VSS \$I2168 \$I3587 VSS nfet_05v0 L=0.6U W=0.36U AS=0.333P AD=0.0936P
+ PS=2.57U PD=0.88U
* device instance $2217 m90 *1 646.805,772.2 nfet_05v0
M$2217 \$I3590 \$I3587 VSS VSS nfet_05v0 L=0.6U W=0.36U AS=0.0936P AD=0.0432P
+ PS=0.88U PD=0.6U
* device instance $2218 m90 *1 645.965,772.2 nfet_05v0
M$2218 \$I3588 \$I3587 \$I3590 VSS nfet_05v0 L=0.6U W=0.36U AS=0.0432P
+ AD=0.369P PS=0.6U PD=2.77U
* device instance $2219 m90 *1 628.615,790.65 pfet_05v0
M$2219 \$I3600 \$I3595 \$I3596 VDD_DEC pfet_05v0 L=0.5U W=0.36U AS=0.3456P
+ AD=0.0612P PS=2.64U PD=0.7U
* device instance $2220 m90 *1 627.775,790.65 pfet_05v0
M$2220 \$I3600 \$I3595 VDD_DEC VDD_DEC pfet_05v0 L=0.5U W=0.36U AS=0.379P
+ AD=0.0612P PS=2.37U PD=0.7U
* device instance $2221 m90 *1 626.125,790.33 pfet_05v0
M$2221 \$113 \$I3596 VDD_DEC VDD_DEC pfet_05v0 L=0.5U W=1.22U AS=0.379P
+ AD=0.5368P PS=2.37U PD=3.32U
* device instance $2222 m90 *1 632.855,790.76 pfet_05v0
M$2222 VDD_DEC \$I2420 \$I3594 VDD_DEC pfet_05v0 L=0.5U W=0.36U AS=0.3852P
+ AD=0.1116P PS=2.86U PD=0.98U
* device instance $2223 m90 *1 631.735,790.76 pfet_05v0
M$2223 \$I3599 \$I3594 VDD_DEC VDD_DEC pfet_05v0 L=0.5U W=0.36U AS=0.1116P
+ AD=0.0612P PS=0.98U PD=0.7U
* device instance $2224 m90 *1 630.895,790.76 pfet_05v0
M$2224 \$I3599 \$I3594 \$I3595 VDD_DEC pfet_05v0 L=0.5U W=0.36U AS=0.3852P
+ AD=0.0612P PS=2.86U PD=0.7U
* device instance $2225 m90 *1 628.565,787.882 nfet_05v0
M$2225 \$I3598 \$I3595 \$I3596 VSS nfet_05v0 L=0.6U W=0.365U AS=0.3705P
+ AD=0.0438P PS=2.77U PD=0.605U
* device instance $2226 m90 *1 627.725,787.882 nfet_05v0
M$2226 VSS \$I3595 \$I3598 VSS nfet_05v0 L=0.6U W=0.365U AS=0.0438P
+ AD=0.282625P PS=0.605U PD=1.87U
* device instance $2227 m90 *1 626.075,788.11 nfet_05v0
M$2227 \$113 \$I3596 VSS VSS nfet_05v0 L=0.6U W=0.82U AS=0.282625P AD=0.3608P
+ PS=1.87U PD=2.52U
* device instance $2228 m90 *1 632.805,787.88 nfet_05v0
M$2228 VSS \$I2420 \$I3594 VSS nfet_05v0 L=0.6U W=0.36U AS=0.333P AD=0.0936P
+ PS=2.57U PD=0.88U
* device instance $2229 m90 *1 631.685,787.88 nfet_05v0
M$2229 \$I3597 \$I3594 VSS VSS nfet_05v0 L=0.6U W=0.36U AS=0.0936P AD=0.0432P
+ PS=0.88U PD=0.6U
* device instance $2230 m90 *1 630.845,787.88 nfet_05v0
M$2230 \$I3595 \$I3594 \$I3597 VSS nfet_05v0 L=0.6U W=0.36U AS=0.0432P
+ AD=0.369P PS=0.6U PD=2.77U
* device instance $2231 m90 *1 637.575,782.81 pfet_05v0
M$2231 \$I3607 \$I3602 \$I3603 VDD_DEC pfet_05v0 L=0.5U W=0.36U AS=0.3456P
+ AD=0.0612P PS=2.64U PD=0.7U
* device instance $2232 m90 *1 636.735,782.81 pfet_05v0
M$2232 \$I3607 \$I3602 VDD_DEC VDD_DEC pfet_05v0 L=0.5U W=0.36U AS=0.379P
+ AD=0.0612P PS=2.37U PD=0.7U
* device instance $2233 m90 *1 635.085,782.49 pfet_05v0
M$2233 \$25 \$I3603 VDD_DEC VDD_DEC pfet_05v0 L=0.5U W=1.22U AS=0.379P
+ AD=0.5368P PS=2.37U PD=3.32U
* device instance $2234 m90 *1 641.815,782.92 pfet_05v0
M$2234 VDD_DEC \$I2075 \$I3601 VDD_DEC pfet_05v0 L=0.5U W=0.36U AS=0.3852P
+ AD=0.1116P PS=2.86U PD=0.98U
* device instance $2235 m90 *1 640.695,782.92 pfet_05v0
M$2235 \$I3606 \$I3601 VDD_DEC VDD_DEC pfet_05v0 L=0.5U W=0.36U AS=0.1116P
+ AD=0.0612P PS=0.98U PD=0.7U
* device instance $2236 m90 *1 639.855,782.92 pfet_05v0
M$2236 \$I3606 \$I3601 \$I3602 VDD_DEC pfet_05v0 L=0.5U W=0.36U AS=0.3852P
+ AD=0.0612P PS=2.86U PD=0.7U
* device instance $2237 m90 *1 637.525,780.042 nfet_05v0
M$2237 \$I3605 \$I3602 \$I3603 VSS nfet_05v0 L=0.6U W=0.365U AS=0.3705P
+ AD=0.0438P PS=2.77U PD=0.605U
* device instance $2238 m90 *1 636.685,780.042 nfet_05v0
M$2238 VSS \$I3602 \$I3605 VSS nfet_05v0 L=0.6U W=0.365U AS=0.0438P
+ AD=0.282625P PS=0.605U PD=1.87U
* device instance $2239 m90 *1 635.035,780.27 nfet_05v0
M$2239 \$25 \$I3603 VSS VSS nfet_05v0 L=0.6U W=0.82U AS=0.282625P AD=0.3608P
+ PS=1.87U PD=2.52U
* device instance $2240 m90 *1 641.765,780.04 nfet_05v0
M$2240 VSS \$I2075 \$I3601 VSS nfet_05v0 L=0.6U W=0.36U AS=0.333P AD=0.0936P
+ PS=2.57U PD=0.88U
* device instance $2241 m90 *1 640.645,780.04 nfet_05v0
M$2241 \$I3604 \$I3601 VSS VSS nfet_05v0 L=0.6U W=0.36U AS=0.0936P AD=0.0432P
+ PS=0.88U PD=0.6U
* device instance $2242 m90 *1 639.805,780.04 nfet_05v0
M$2242 \$I3602 \$I3601 \$I3604 VSS nfet_05v0 L=0.6U W=0.36U AS=0.0432P
+ AD=0.369P PS=0.6U PD=2.77U
* device instance $2243 r180 *1 635.895,784.07 pfet_05v0
M$2243 \$I3614 \$I3609 \$I3610 VDD_DEC pfet_05v0 L=0.5U W=0.36U AS=0.3456P
+ AD=0.0612P PS=2.64U PD=0.7U
* device instance $2244 r180 *1 635.055,784.07 pfet_05v0
M$2244 \$I3614 \$I3609 VDD_DEC VDD_DEC pfet_05v0 L=0.5U W=0.36U AS=0.379P
+ AD=0.0612P PS=2.37U PD=0.7U
* device instance $2245 r180 *1 633.405,784.39 pfet_05v0
M$2245 \$26 \$I3610 VDD_DEC VDD_DEC pfet_05v0 L=0.5U W=1.22U AS=0.379P
+ AD=0.5368P PS=2.37U PD=3.32U
* device instance $2246 r180 *1 640.135,783.96 pfet_05v0
M$2246 VDD_DEC \$I2325 \$I3608 VDD_DEC pfet_05v0 L=0.5U W=0.36U AS=0.3852P
+ AD=0.1116P PS=2.86U PD=0.98U
* device instance $2247 r180 *1 639.015,783.96 pfet_05v0
M$2247 \$I3613 \$I3608 VDD_DEC VDD_DEC pfet_05v0 L=0.5U W=0.36U AS=0.1116P
+ AD=0.0612P PS=0.98U PD=0.7U
* device instance $2248 r180 *1 638.175,783.96 pfet_05v0
M$2248 \$I3613 \$I3608 \$I3609 VDD_DEC pfet_05v0 L=0.5U W=0.36U AS=0.3852P
+ AD=0.0612P PS=2.86U PD=0.7U
* device instance $2249 r180 *1 635.845,786.838 nfet_05v0
M$2249 \$I3612 \$I3609 \$I3610 VSS nfet_05v0 L=0.6U W=0.365U AS=0.3705P
+ AD=0.0438P PS=2.77U PD=0.605U
* device instance $2250 r180 *1 635.005,786.838 nfet_05v0
M$2250 VSS \$I3609 \$I3612 VSS nfet_05v0 L=0.6U W=0.365U AS=0.0438P
+ AD=0.282625P PS=0.605U PD=1.87U
* device instance $2251 r180 *1 633.355,786.61 nfet_05v0
M$2251 \$26 \$I3610 VSS VSS nfet_05v0 L=0.6U W=0.82U AS=0.282625P AD=0.3608P
+ PS=1.87U PD=2.52U
* device instance $2252 r180 *1 640.085,786.84 nfet_05v0
M$2252 VSS \$I2325 \$I3608 VSS nfet_05v0 L=0.6U W=0.36U AS=0.333P AD=0.0936P
+ PS=2.57U PD=0.88U
* device instance $2253 r180 *1 638.965,786.84 nfet_05v0
M$2253 \$I3611 \$I3608 VSS VSS nfet_05v0 L=0.6U W=0.36U AS=0.0936P AD=0.0432P
+ PS=0.88U PD=0.6U
* device instance $2254 r180 *1 638.125,786.84 nfet_05v0
M$2254 \$I3609 \$I3608 \$I3611 VSS nfet_05v0 L=0.6U W=0.36U AS=0.0432P
+ AD=0.369P PS=0.6U PD=2.77U
* device instance $2255 r180 *1 629.175,791.91 pfet_05v0
M$2255 \$I3621 \$I3616 \$I3617 VDD_DEC pfet_05v0 L=0.5U W=0.36U AS=0.3456P
+ AD=0.0612P PS=2.64U PD=0.7U
* device instance $2256 r180 *1 628.335,791.91 pfet_05v0
M$2256 \$I3621 \$I3616 VDD_DEC VDD_DEC pfet_05v0 L=0.5U W=0.36U AS=0.379P
+ AD=0.0612P PS=2.37U PD=0.7U
* device instance $2257 r180 *1 626.685,792.23 pfet_05v0
M$2257 \$27 \$I3617 VDD_DEC VDD_DEC pfet_05v0 L=0.5U W=1.22U AS=0.379P
+ AD=0.5368P PS=2.37U PD=3.32U
* device instance $2258 r180 *1 633.415,791.8 pfet_05v0
M$2258 VDD_DEC \$I2256 \$I3615 VDD_DEC pfet_05v0 L=0.5U W=0.36U AS=0.3852P
+ AD=0.1116P PS=2.86U PD=0.98U
* device instance $2259 r180 *1 632.295,791.8 pfet_05v0
M$2259 \$I3620 \$I3615 VDD_DEC VDD_DEC pfet_05v0 L=0.5U W=0.36U AS=0.1116P
+ AD=0.0612P PS=0.98U PD=0.7U
* device instance $2260 r180 *1 631.455,791.8 pfet_05v0
M$2260 \$I3620 \$I3615 \$I3616 VDD_DEC pfet_05v0 L=0.5U W=0.36U AS=0.3852P
+ AD=0.0612P PS=2.86U PD=0.7U
* device instance $2261 r180 *1 629.125,794.678 nfet_05v0
M$2261 \$I3619 \$I3616 \$I3617 VSS nfet_05v0 L=0.6U W=0.365U AS=0.3705P
+ AD=0.0438P PS=2.77U PD=0.605U
* device instance $2262 r180 *1 628.285,794.678 nfet_05v0
M$2262 VSS \$I3616 \$I3619 VSS nfet_05v0 L=0.6U W=0.365U AS=0.0438P
+ AD=0.282625P PS=0.605U PD=1.87U
* device instance $2263 r180 *1 626.635,794.45 nfet_05v0
M$2263 \$27 \$I3617 VSS VSS nfet_05v0 L=0.6U W=0.82U AS=0.282625P AD=0.3608P
+ PS=1.87U PD=2.52U
* device instance $2264 r180 *1 633.365,794.68 nfet_05v0
M$2264 VSS \$I2256 \$I3615 VSS nfet_05v0 L=0.6U W=0.36U AS=0.333P AD=0.0936P
+ PS=2.57U PD=0.88U
* device instance $2265 r180 *1 632.245,794.68 nfet_05v0
M$2265 \$I3618 \$I3615 VSS VSS nfet_05v0 L=0.6U W=0.36U AS=0.0936P AD=0.0432P
+ PS=0.88U PD=0.6U
* device instance $2266 r180 *1 631.405,794.68 nfet_05v0
M$2266 \$I3616 \$I3615 \$I3618 VSS nfet_05v0 L=0.6U W=0.36U AS=0.0432P
+ AD=0.369P PS=0.6U PD=2.77U
* device instance $2267 m90 *1 628.615,798.49 pfet_05v0
M$2267 \$I3628 \$I3623 \$I3624 VDD_DEC pfet_05v0 L=0.5U W=0.36U AS=0.3456P
+ AD=0.0612P PS=2.64U PD=0.7U
* device instance $2268 m90 *1 627.775,798.49 pfet_05v0
M$2268 \$I3628 \$I3623 VDD_DEC VDD_DEC pfet_05v0 L=0.5U W=0.36U AS=0.379P
+ AD=0.0612P PS=2.37U PD=0.7U
* device instance $2269 m90 *1 626.125,798.17 pfet_05v0
M$2269 \$28 \$I3624 VDD_DEC VDD_DEC pfet_05v0 L=0.5U W=1.22U AS=0.379P
+ AD=0.5368P PS=2.37U PD=3.32U
* device instance $2270 m90 *1 632.855,798.6 pfet_05v0
M$2270 VDD_DEC \$I2246 \$I3622 VDD_DEC pfet_05v0 L=0.5U W=0.36U AS=0.3852P
+ AD=0.1116P PS=2.86U PD=0.98U
* device instance $2271 m90 *1 631.735,798.6 pfet_05v0
M$2271 \$I3627 \$I3622 VDD_DEC VDD_DEC pfet_05v0 L=0.5U W=0.36U AS=0.1116P
+ AD=0.0612P PS=0.98U PD=0.7U
* device instance $2272 m90 *1 630.895,798.6 pfet_05v0
M$2272 \$I3627 \$I3622 \$I3623 VDD_DEC pfet_05v0 L=0.5U W=0.36U AS=0.3852P
+ AD=0.0612P PS=2.86U PD=0.7U
* device instance $2273 m90 *1 628.565,795.722 nfet_05v0
M$2273 \$I3626 \$I3623 \$I3624 VSS nfet_05v0 L=0.6U W=0.365U AS=0.3705P
+ AD=0.0438P PS=2.77U PD=0.605U
* device instance $2274 m90 *1 627.725,795.722 nfet_05v0
M$2274 VSS \$I3623 \$I3626 VSS nfet_05v0 L=0.6U W=0.365U AS=0.0438P
+ AD=0.282625P PS=0.605U PD=1.87U
* device instance $2275 m90 *1 626.075,795.95 nfet_05v0
M$2275 \$28 \$I3624 VSS VSS nfet_05v0 L=0.6U W=0.82U AS=0.282625P AD=0.3608P
+ PS=1.87U PD=2.52U
* device instance $2276 m90 *1 632.805,795.72 nfet_05v0
M$2276 VSS \$I2246 \$I3622 VSS nfet_05v0 L=0.6U W=0.36U AS=0.333P AD=0.0936P
+ PS=2.57U PD=0.88U
* device instance $2277 m90 *1 631.685,795.72 nfet_05v0
M$2277 \$I3625 \$I3622 VSS VSS nfet_05v0 L=0.6U W=0.36U AS=0.0936P AD=0.0432P
+ PS=0.88U PD=0.6U
* device instance $2278 m90 *1 630.845,795.72 nfet_05v0
M$2278 \$I3623 \$I3622 \$I3625 VSS nfet_05v0 L=0.6U W=0.36U AS=0.0432P
+ AD=0.369P PS=0.6U PD=2.77U
* device instance $2279 r180 *1 648.215,776.23 pfet_05v0
M$2279 \$I3635 \$I3630 \$I3631 VDD_DEC pfet_05v0 L=0.5U W=0.36U AS=0.3456P
+ AD=0.0612P PS=2.64U PD=0.7U
* device instance $2280 r180 *1 647.375,776.23 pfet_05v0
M$2280 \$I3635 \$I3630 VDD_DEC VDD_DEC pfet_05v0 L=0.5U W=0.36U AS=0.379P
+ AD=0.0612P PS=2.37U PD=0.7U
* device instance $2281 r180 *1 645.725,776.55 pfet_05v0
M$2281 \$29 \$I3631 VDD_DEC VDD_DEC pfet_05v0 L=0.5U W=1.22U AS=0.379P
+ AD=0.5368P PS=2.37U PD=3.32U
* device instance $2282 r180 *1 652.455,776.12 pfet_05v0
M$2282 VDD_DEC \$I2032 \$I3629 VDD_DEC pfet_05v0 L=0.5U W=0.36U AS=0.3852P
+ AD=0.1116P PS=2.86U PD=0.98U
* device instance $2283 r180 *1 651.335,776.12 pfet_05v0
M$2283 \$I3634 \$I3629 VDD_DEC VDD_DEC pfet_05v0 L=0.5U W=0.36U AS=0.1116P
+ AD=0.0612P PS=0.98U PD=0.7U
* device instance $2284 r180 *1 650.495,776.12 pfet_05v0
M$2284 \$I3634 \$I3629 \$I3630 VDD_DEC pfet_05v0 L=0.5U W=0.36U AS=0.3852P
+ AD=0.0612P PS=2.86U PD=0.7U
* device instance $2285 r180 *1 648.165,778.998 nfet_05v0
M$2285 \$I3633 \$I3630 \$I3631 VSS nfet_05v0 L=0.6U W=0.365U AS=0.3705P
+ AD=0.0438P PS=2.77U PD=0.605U
* device instance $2286 r180 *1 647.325,778.998 nfet_05v0
M$2286 VSS \$I3630 \$I3633 VSS nfet_05v0 L=0.6U W=0.365U AS=0.0438P
+ AD=0.282625P PS=0.605U PD=1.87U
* device instance $2287 r180 *1 645.675,778.77 nfet_05v0
M$2287 \$29 \$I3631 VSS VSS nfet_05v0 L=0.6U W=0.82U AS=0.282625P AD=0.3608P
+ PS=1.87U PD=2.52U
* device instance $2288 r180 *1 652.405,779 nfet_05v0
M$2288 VSS \$I2032 \$I3629 VSS nfet_05v0 L=0.6U W=0.36U AS=0.333P AD=0.0936P
+ PS=2.57U PD=0.88U
* device instance $2289 r180 *1 651.285,779 nfet_05v0
M$2289 \$I3632 \$I3629 VSS VSS nfet_05v0 L=0.6U W=0.36U AS=0.0936P AD=0.0432P
+ PS=0.88U PD=0.6U
* device instance $2290 r180 *1 650.445,779 nfet_05v0
M$2290 \$I3630 \$I3629 \$I3632 VSS nfet_05v0 L=0.6U W=0.36U AS=0.0432P
+ AD=0.369P PS=0.6U PD=2.77U
* device instance $2291 m90 *1 652.695,774.97 pfet_05v0
M$2291 \$I3642 \$I3637 \$I3638 VDD_DEC pfet_05v0 L=0.5U W=0.36U AS=0.3456P
+ AD=0.0612P PS=2.64U PD=0.7U
* device instance $2292 m90 *1 651.855,774.97 pfet_05v0
M$2292 \$I3642 \$I3637 VDD_DEC VDD_DEC pfet_05v0 L=0.5U W=0.36U AS=0.379P
+ AD=0.0612P PS=2.37U PD=0.7U
* device instance $2293 m90 *1 650.205,774.65 pfet_05v0
M$2293 \$30 \$I3638 VDD_DEC VDD_DEC pfet_05v0 L=0.5U W=1.22U AS=0.379P
+ AD=0.5368P PS=2.37U PD=3.32U
* device instance $2294 m90 *1 656.935,775.08 pfet_05v0
M$2294 VDD_DEC \$I2030 \$I3636 VDD_DEC pfet_05v0 L=0.5U W=0.36U AS=0.3852P
+ AD=0.1116P PS=2.86U PD=0.98U
* device instance $2295 m90 *1 655.815,775.08 pfet_05v0
M$2295 \$I3641 \$I3636 VDD_DEC VDD_DEC pfet_05v0 L=0.5U W=0.36U AS=0.1116P
+ AD=0.0612P PS=0.98U PD=0.7U
* device instance $2296 m90 *1 654.975,775.08 pfet_05v0
M$2296 \$I3641 \$I3636 \$I3637 VDD_DEC pfet_05v0 L=0.5U W=0.36U AS=0.3852P
+ AD=0.0612P PS=2.86U PD=0.7U
* device instance $2297 m90 *1 652.645,772.202 nfet_05v0
M$2297 \$I3640 \$I3637 \$I3638 VSS nfet_05v0 L=0.6U W=0.365U AS=0.3705P
+ AD=0.0438P PS=2.77U PD=0.605U
* device instance $2298 m90 *1 651.805,772.202 nfet_05v0
M$2298 VSS \$I3637 \$I3640 VSS nfet_05v0 L=0.6U W=0.365U AS=0.0438P
+ AD=0.282625P PS=0.605U PD=1.87U
* device instance $2299 m90 *1 650.155,772.43 nfet_05v0
M$2299 \$30 \$I3638 VSS VSS nfet_05v0 L=0.6U W=0.82U AS=0.282625P AD=0.3608P
+ PS=1.87U PD=2.52U
* device instance $2300 m90 *1 656.885,772.2 nfet_05v0
M$2300 VSS \$I2030 \$I3636 VSS nfet_05v0 L=0.6U W=0.36U AS=0.333P AD=0.0936P
+ PS=2.57U PD=0.88U
* device instance $2301 m90 *1 655.765,772.2 nfet_05v0
M$2301 \$I3639 \$I3636 VSS VSS nfet_05v0 L=0.6U W=0.36U AS=0.0936P AD=0.0432P
+ PS=0.88U PD=0.6U
* device instance $2302 m90 *1 654.925,772.2 nfet_05v0
M$2302 \$I3637 \$I3636 \$I3639 VSS nfet_05v0 L=0.6U W=0.36U AS=0.0432P
+ AD=0.369P PS=0.6U PD=2.77U
* device instance $2303 m90 *1 637.575,790.65 pfet_05v0
M$2303 \$I3649 \$I3644 \$I3645 VDD_DEC pfet_05v0 L=0.5U W=0.36U AS=0.3456P
+ AD=0.0612P PS=2.64U PD=0.7U
* device instance $2304 m90 *1 636.735,790.65 pfet_05v0
M$2304 \$I3649 \$I3644 VDD_DEC VDD_DEC pfet_05v0 L=0.5U W=0.36U AS=0.379P
+ AD=0.0612P PS=2.37U PD=0.7U
* device instance $2305 m90 *1 635.085,790.33 pfet_05v0
M$2305 \$31 \$I3645 VDD_DEC VDD_DEC pfet_05v0 L=0.5U W=1.22U AS=0.379P
+ AD=0.5368P PS=2.37U PD=3.32U
* device instance $2306 m90 *1 641.815,790.76 pfet_05v0
M$2306 VDD_DEC \$I2312 \$I3643 VDD_DEC pfet_05v0 L=0.5U W=0.36U AS=0.3852P
+ AD=0.1116P PS=2.86U PD=0.98U
* device instance $2307 m90 *1 640.695,790.76 pfet_05v0
M$2307 \$I3648 \$I3643 VDD_DEC VDD_DEC pfet_05v0 L=0.5U W=0.36U AS=0.1116P
+ AD=0.0612P PS=0.98U PD=0.7U
* device instance $2308 m90 *1 639.855,790.76 pfet_05v0
M$2308 \$I3648 \$I3643 \$I3644 VDD_DEC pfet_05v0 L=0.5U W=0.36U AS=0.3852P
+ AD=0.0612P PS=2.86U PD=0.7U
* device instance $2309 m90 *1 637.525,787.882 nfet_05v0
M$2309 \$I3647 \$I3644 \$I3645 VSS nfet_05v0 L=0.6U W=0.365U AS=0.3705P
+ AD=0.0438P PS=2.77U PD=0.605U
* device instance $2310 m90 *1 636.685,787.882 nfet_05v0
M$2310 VSS \$I3644 \$I3647 VSS nfet_05v0 L=0.6U W=0.365U AS=0.0438P
+ AD=0.282625P PS=0.605U PD=1.87U
* device instance $2311 m90 *1 635.035,788.11 nfet_05v0
M$2311 \$31 \$I3645 VSS VSS nfet_05v0 L=0.6U W=0.82U AS=0.282625P AD=0.3608P
+ PS=1.87U PD=2.52U
* device instance $2312 m90 *1 641.765,787.88 nfet_05v0
M$2312 VSS \$I2312 \$I3643 VSS nfet_05v0 L=0.6U W=0.36U AS=0.333P AD=0.0936P
+ PS=2.57U PD=0.88U
* device instance $2313 m90 *1 640.645,787.88 nfet_05v0
M$2313 \$I3646 \$I3643 VSS VSS nfet_05v0 L=0.6U W=0.36U AS=0.0936P AD=0.0432P
+ PS=0.88U PD=0.6U
* device instance $2314 m90 *1 639.805,787.88 nfet_05v0
M$2314 \$I3644 \$I3643 \$I3646 VSS nfet_05v0 L=0.6U W=0.36U AS=0.0432P
+ AD=0.369P PS=0.6U PD=2.77U
* device instance $2315 m90 *1 646.535,782.81 pfet_05v0
M$2315 \$I3656 \$I3651 \$I3652 VDD_DEC pfet_05v0 L=0.5U W=0.36U AS=0.3456P
+ AD=0.0612P PS=2.64U PD=0.7U
* device instance $2316 m90 *1 645.695,782.81 pfet_05v0
M$2316 \$I3656 \$I3651 VDD_DEC VDD_DEC pfet_05v0 L=0.5U W=0.36U AS=0.379P
+ AD=0.0612P PS=2.37U PD=0.7U
* device instance $2317 m90 *1 644.045,782.49 pfet_05v0
M$2317 \$32 \$I3652 VDD_DEC VDD_DEC pfet_05v0 L=0.5U W=1.22U AS=0.379P
+ AD=0.5368P PS=2.37U PD=3.32U
* device instance $2318 m90 *1 650.775,782.92 pfet_05v0
M$2318 VDD_DEC \$I2079 \$I3650 VDD_DEC pfet_05v0 L=0.5U W=0.36U AS=0.3852P
+ AD=0.1116P PS=2.86U PD=0.98U
* device instance $2319 m90 *1 649.655,782.92 pfet_05v0
M$2319 \$I3655 \$I3650 VDD_DEC VDD_DEC pfet_05v0 L=0.5U W=0.36U AS=0.1116P
+ AD=0.0612P PS=0.98U PD=0.7U
* device instance $2320 m90 *1 648.815,782.92 pfet_05v0
M$2320 \$I3655 \$I3650 \$I3651 VDD_DEC pfet_05v0 L=0.5U W=0.36U AS=0.3852P
+ AD=0.0612P PS=2.86U PD=0.7U
* device instance $2321 m90 *1 646.485,780.042 nfet_05v0
M$2321 \$I3654 \$I3651 \$I3652 VSS nfet_05v0 L=0.6U W=0.365U AS=0.3705P
+ AD=0.0438P PS=2.77U PD=0.605U
* device instance $2322 m90 *1 645.645,780.042 nfet_05v0
M$2322 VSS \$I3651 \$I3654 VSS nfet_05v0 L=0.6U W=0.365U AS=0.0438P
+ AD=0.282625P PS=0.605U PD=1.87U
* device instance $2323 m90 *1 643.995,780.27 nfet_05v0
M$2323 \$32 \$I3652 VSS VSS nfet_05v0 L=0.6U W=0.82U AS=0.282625P AD=0.3608P
+ PS=1.87U PD=2.52U
* device instance $2324 m90 *1 650.725,780.04 nfet_05v0
M$2324 VSS \$I2079 \$I3650 VSS nfet_05v0 L=0.6U W=0.36U AS=0.333P AD=0.0936P
+ PS=2.57U PD=0.88U
* device instance $2325 m90 *1 649.605,780.04 nfet_05v0
M$2325 \$I3653 \$I3650 VSS VSS nfet_05v0 L=0.6U W=0.36U AS=0.0936P AD=0.0432P
+ PS=0.88U PD=0.6U
* device instance $2326 m90 *1 648.765,780.04 nfet_05v0
M$2326 \$I3651 \$I3650 \$I3653 VSS nfet_05v0 L=0.6U W=0.36U AS=0.0432P
+ AD=0.369P PS=0.6U PD=2.77U
* device instance $2327 m90 *1 628.615,806.33 pfet_05v0
M$2327 \$I3663 \$I3658 \$I3659 VDD_DEC pfet_05v0 L=0.5U W=0.36U AS=0.3456P
+ AD=0.0612P PS=2.64U PD=0.7U
* device instance $2328 m90 *1 627.775,806.33 pfet_05v0
M$2328 \$I3663 \$I3658 VDD_DEC VDD_DEC pfet_05v0 L=0.5U W=0.36U AS=0.379P
+ AD=0.0612P PS=2.37U PD=0.7U
* device instance $2329 m90 *1 626.125,806.01 pfet_05v0
M$2329 \$33 \$I3659 VDD_DEC VDD_DEC pfet_05v0 L=0.5U W=1.22U AS=0.379P
+ AD=0.5368P PS=2.37U PD=3.32U
* device instance $2330 m90 *1 632.855,806.44 pfet_05v0
M$2330 VDD_DEC \$I2175 \$I3657 VDD_DEC pfet_05v0 L=0.5U W=0.36U AS=0.3852P
+ AD=0.1116P PS=2.86U PD=0.98U
* device instance $2331 m90 *1 631.735,806.44 pfet_05v0
M$2331 \$I3662 \$I3657 VDD_DEC VDD_DEC pfet_05v0 L=0.5U W=0.36U AS=0.1116P
+ AD=0.0612P PS=0.98U PD=0.7U
* device instance $2332 m90 *1 630.895,806.44 pfet_05v0
M$2332 \$I3662 \$I3657 \$I3658 VDD_DEC pfet_05v0 L=0.5U W=0.36U AS=0.3852P
+ AD=0.0612P PS=2.86U PD=0.7U
* device instance $2333 m90 *1 628.565,803.562 nfet_05v0
M$2333 \$I3661 \$I3658 \$I3659 VSS nfet_05v0 L=0.6U W=0.365U AS=0.3705P
+ AD=0.0438P PS=2.77U PD=0.605U
* device instance $2334 m90 *1 627.725,803.562 nfet_05v0
M$2334 VSS \$I3658 \$I3661 VSS nfet_05v0 L=0.6U W=0.365U AS=0.0438P
+ AD=0.282625P PS=0.605U PD=1.87U
* device instance $2335 m90 *1 626.075,803.79 nfet_05v0
M$2335 \$33 \$I3659 VSS VSS nfet_05v0 L=0.6U W=0.82U AS=0.282625P AD=0.3608P
+ PS=1.87U PD=2.52U
* device instance $2336 m90 *1 632.805,803.56 nfet_05v0
M$2336 VSS \$I2175 \$I3657 VSS nfet_05v0 L=0.6U W=0.36U AS=0.333P AD=0.0936P
+ PS=2.57U PD=0.88U
* device instance $2337 m90 *1 631.685,803.56 nfet_05v0
M$2337 \$I3660 \$I3657 VSS VSS nfet_05v0 L=0.6U W=0.36U AS=0.0936P AD=0.0432P
+ PS=0.88U PD=0.6U
* device instance $2338 m90 *1 630.845,803.56 nfet_05v0
M$2338 \$I3658 \$I3657 \$I3660 VSS nfet_05v0 L=0.6U W=0.36U AS=0.0432P
+ AD=0.369P PS=0.6U PD=2.77U
* device instance $2339 r180 *1 657.175,776.23 pfet_05v0
M$2339 \$I3670 \$I3665 \$I3666 VDD_DEC pfet_05v0 L=0.5U W=0.36U AS=0.3456P
+ AD=0.0612P PS=2.64U PD=0.7U
* device instance $2340 r180 *1 656.335,776.23 pfet_05v0
M$2340 \$I3670 \$I3665 VDD_DEC VDD_DEC pfet_05v0 L=0.5U W=0.36U AS=0.379P
+ AD=0.0612P PS=2.37U PD=0.7U
* device instance $2341 r180 *1 654.685,776.55 pfet_05v0
M$2341 \$34 \$I3666 VDD_DEC VDD_DEC pfet_05v0 L=0.5U W=1.22U AS=0.379P
+ AD=0.5368P PS=2.37U PD=3.32U
* device instance $2342 r180 *1 661.415,776.12 pfet_05v0
M$2342 VDD_DEC \$I2080 \$I3664 VDD_DEC pfet_05v0 L=0.5U W=0.36U AS=0.3852P
+ AD=0.1116P PS=2.86U PD=0.98U
* device instance $2343 r180 *1 660.295,776.12 pfet_05v0
M$2343 \$I3669 \$I3664 VDD_DEC VDD_DEC pfet_05v0 L=0.5U W=0.36U AS=0.1116P
+ AD=0.0612P PS=0.98U PD=0.7U
* device instance $2344 r180 *1 659.455,776.12 pfet_05v0
M$2344 \$I3669 \$I3664 \$I3665 VDD_DEC pfet_05v0 L=0.5U W=0.36U AS=0.3852P
+ AD=0.0612P PS=2.86U PD=0.7U
* device instance $2345 r180 *1 657.125,778.998 nfet_05v0
M$2345 \$I3668 \$I3665 \$I3666 VSS nfet_05v0 L=0.6U W=0.365U AS=0.3705P
+ AD=0.0438P PS=2.77U PD=0.605U
* device instance $2346 r180 *1 656.285,778.998 nfet_05v0
M$2346 VSS \$I3665 \$I3668 VSS nfet_05v0 L=0.6U W=0.365U AS=0.0438P
+ AD=0.282625P PS=0.605U PD=1.87U
* device instance $2347 r180 *1 654.635,778.77 nfet_05v0
M$2347 \$34 \$I3666 VSS VSS nfet_05v0 L=0.6U W=0.82U AS=0.282625P AD=0.3608P
+ PS=1.87U PD=2.52U
* device instance $2348 r180 *1 661.365,779 nfet_05v0
M$2348 VSS \$I2080 \$I3664 VSS nfet_05v0 L=0.6U W=0.36U AS=0.333P AD=0.0936P
+ PS=2.57U PD=0.88U
* device instance $2349 r180 *1 660.245,779 nfet_05v0
M$2349 \$I3667 \$I3664 VSS VSS nfet_05v0 L=0.6U W=0.36U AS=0.0936P AD=0.0432P
+ PS=0.88U PD=0.6U
* device instance $2350 r180 *1 659.405,779 nfet_05v0
M$2350 \$I3665 \$I3664 \$I3667 VSS nfet_05v0 L=0.6U W=0.36U AS=0.0432P
+ AD=0.369P PS=0.6U PD=2.77U
* device instance $2351 m90 *1 662.775,774.97 pfet_05v0
M$2351 \$I3677 \$I3672 \$I3673 VDD_DEC pfet_05v0 L=0.5U W=0.36U AS=0.3456P
+ AD=0.0612P PS=2.64U PD=0.7U
* device instance $2352 m90 *1 661.935,774.97 pfet_05v0
M$2352 \$I3677 \$I3672 VDD_DEC VDD_DEC pfet_05v0 L=0.5U W=0.36U AS=0.379P
+ AD=0.0612P PS=2.37U PD=0.7U
* device instance $2353 m90 *1 660.285,774.65 pfet_05v0
M$2353 \$35 \$I3673 VDD_DEC VDD_DEC pfet_05v0 L=0.5U W=1.22U AS=0.379P
+ AD=0.5368P PS=2.37U PD=3.32U
* device instance $2354 m90 *1 667.015,775.08 pfet_05v0
M$2354 VDD_DEC \$I2078 \$I3671 VDD_DEC pfet_05v0 L=0.5U W=0.36U AS=0.3852P
+ AD=0.1116P PS=2.86U PD=0.98U
* device instance $2355 m90 *1 665.895,775.08 pfet_05v0
M$2355 \$I3676 \$I3671 VDD_DEC VDD_DEC pfet_05v0 L=0.5U W=0.36U AS=0.1116P
+ AD=0.0612P PS=0.98U PD=0.7U
* device instance $2356 m90 *1 665.055,775.08 pfet_05v0
M$2356 \$I3676 \$I3671 \$I3672 VDD_DEC pfet_05v0 L=0.5U W=0.36U AS=0.3852P
+ AD=0.0612P PS=2.86U PD=0.7U
* device instance $2357 m90 *1 662.725,772.202 nfet_05v0
M$2357 \$I3675 \$I3672 \$I3673 VSS nfet_05v0 L=0.6U W=0.365U AS=0.3705P
+ AD=0.0438P PS=2.77U PD=0.605U
* device instance $2358 m90 *1 661.885,772.202 nfet_05v0
M$2358 VSS \$I3672 \$I3675 VSS nfet_05v0 L=0.6U W=0.365U AS=0.0438P
+ AD=0.282625P PS=0.605U PD=1.87U
* device instance $2359 m90 *1 660.235,772.43 nfet_05v0
M$2359 \$35 \$I3673 VSS VSS nfet_05v0 L=0.6U W=0.82U AS=0.282625P AD=0.3608P
+ PS=1.87U PD=2.52U
* device instance $2360 m90 *1 666.965,772.2 nfet_05v0
M$2360 VSS \$I2078 \$I3671 VSS nfet_05v0 L=0.6U W=0.36U AS=0.333P AD=0.0936P
+ PS=2.57U PD=0.88U
* device instance $2361 m90 *1 665.845,772.2 nfet_05v0
M$2361 \$I3674 \$I3671 VSS VSS nfet_05v0 L=0.6U W=0.36U AS=0.0936P AD=0.0432P
+ PS=0.88U PD=0.6U
* device instance $2362 m90 *1 665.005,772.2 nfet_05v0
M$2362 \$I3672 \$I3671 \$I3674 VSS nfet_05v0 L=0.6U W=0.36U AS=0.0432P
+ AD=0.369P PS=0.6U PD=2.77U
* device instance $2363 m90 *1 655.495,782.81 pfet_05v0
M$2363 \$I3684 \$I3679 \$I3680 VDD_DEC pfet_05v0 L=0.5U W=0.36U AS=0.3456P
+ AD=0.0612P PS=2.64U PD=0.7U
* device instance $2364 m90 *1 654.655,782.81 pfet_05v0
M$2364 \$I3684 \$I3679 VDD_DEC VDD_DEC pfet_05v0 L=0.5U W=0.36U AS=0.379P
+ AD=0.0612P PS=2.37U PD=0.7U
* device instance $2365 m90 *1 653.005,782.49 pfet_05v0
M$2365 \$36 \$I3680 VDD_DEC VDD_DEC pfet_05v0 L=0.5U W=1.22U AS=0.379P
+ AD=0.5368P PS=2.37U PD=3.32U
* device instance $2366 m90 *1 659.735,782.92 pfet_05v0
M$2366 VDD_DEC \$I2077 \$I3678 VDD_DEC pfet_05v0 L=0.5U W=0.36U AS=0.3852P
+ AD=0.1116P PS=2.86U PD=0.98U
* device instance $2367 m90 *1 658.615,782.92 pfet_05v0
M$2367 \$I3683 \$I3678 VDD_DEC VDD_DEC pfet_05v0 L=0.5U W=0.36U AS=0.1116P
+ AD=0.0612P PS=0.98U PD=0.7U
* device instance $2368 m90 *1 657.775,782.92 pfet_05v0
M$2368 \$I3683 \$I3678 \$I3679 VDD_DEC pfet_05v0 L=0.5U W=0.36U AS=0.3852P
+ AD=0.0612P PS=2.86U PD=0.7U
* device instance $2369 m90 *1 655.445,780.042 nfet_05v0
M$2369 \$I3682 \$I3679 \$I3680 VSS nfet_05v0 L=0.6U W=0.365U AS=0.3705P
+ AD=0.0438P PS=2.77U PD=0.605U
* device instance $2370 m90 *1 654.605,780.042 nfet_05v0
M$2370 VSS \$I3679 \$I3682 VSS nfet_05v0 L=0.6U W=0.365U AS=0.0438P
+ AD=0.282625P PS=0.605U PD=1.87U
* device instance $2371 m90 *1 652.955,780.27 nfet_05v0
M$2371 \$36 \$I3680 VSS VSS nfet_05v0 L=0.6U W=0.82U AS=0.282625P AD=0.3608P
+ PS=1.87U PD=2.52U
* device instance $2372 m90 *1 659.685,780.04 nfet_05v0
M$2372 VSS \$I2077 \$I3678 VSS nfet_05v0 L=0.6U W=0.36U AS=0.333P AD=0.0936P
+ PS=2.57U PD=0.88U
* device instance $2373 m90 *1 658.565,780.04 nfet_05v0
M$2373 \$I3681 \$I3678 VSS VSS nfet_05v0 L=0.6U W=0.36U AS=0.0936P AD=0.0432P
+ PS=0.88U PD=0.6U
* device instance $2374 m90 *1 657.725,780.04 nfet_05v0
M$2374 \$I3679 \$I3678 \$I3681 VSS nfet_05v0 L=0.6U W=0.36U AS=0.0432P
+ AD=0.369P PS=0.6U PD=2.77U
* device instance $2375 r180 *1 658.295,784.07 pfet_05v0
M$2375 \$I3691 \$I3686 \$I3687 VDD_DEC pfet_05v0 L=0.5U W=0.36U AS=0.3456P
+ AD=0.0612P PS=2.64U PD=0.7U
* device instance $2376 r180 *1 657.455,784.07 pfet_05v0
M$2376 \$I3691 \$I3686 VDD_DEC VDD_DEC pfet_05v0 L=0.5U W=0.36U AS=0.379P
+ AD=0.0612P PS=2.37U PD=0.7U
* device instance $2377 r180 *1 655.805,784.39 pfet_05v0
M$2377 \$37 \$I3687 VDD_DEC VDD_DEC pfet_05v0 L=0.5U W=1.22U AS=0.379P
+ AD=0.5368P PS=2.37U PD=3.32U
* device instance $2378 r180 *1 662.535,783.96 pfet_05v0
M$2378 VDD_DEC \$I2327 \$I3685 VDD_DEC pfet_05v0 L=0.5U W=0.36U AS=0.3852P
+ AD=0.1116P PS=2.86U PD=0.98U
* device instance $2379 r180 *1 661.415,783.96 pfet_05v0
M$2379 \$I3690 \$I3685 VDD_DEC VDD_DEC pfet_05v0 L=0.5U W=0.36U AS=0.1116P
+ AD=0.0612P PS=0.98U PD=0.7U
* device instance $2380 r180 *1 660.575,783.96 pfet_05v0
M$2380 \$I3690 \$I3685 \$I3686 VDD_DEC pfet_05v0 L=0.5U W=0.36U AS=0.3852P
+ AD=0.0612P PS=2.86U PD=0.7U
* device instance $2381 r180 *1 658.245,786.838 nfet_05v0
M$2381 \$I3689 \$I3686 \$I3687 VSS nfet_05v0 L=0.6U W=0.365U AS=0.3705P
+ AD=0.0438P PS=2.77U PD=0.605U
* device instance $2382 r180 *1 657.405,786.838 nfet_05v0
M$2382 VSS \$I3686 \$I3689 VSS nfet_05v0 L=0.6U W=0.365U AS=0.0438P
+ AD=0.282625P PS=0.605U PD=1.87U
* device instance $2383 r180 *1 655.755,786.61 nfet_05v0
M$2383 \$37 \$I3687 VSS VSS nfet_05v0 L=0.6U W=0.82U AS=0.282625P AD=0.3608P
+ PS=1.87U PD=2.52U
* device instance $2384 r180 *1 662.485,786.84 nfet_05v0
M$2384 VSS \$I2327 \$I3685 VSS nfet_05v0 L=0.6U W=0.36U AS=0.333P AD=0.0936P
+ PS=2.57U PD=0.88U
* device instance $2385 r180 *1 661.365,786.84 nfet_05v0
M$2385 \$I3688 \$I3685 VSS VSS nfet_05v0 L=0.6U W=0.36U AS=0.0936P AD=0.0432P
+ PS=0.88U PD=0.6U
* device instance $2386 r180 *1 660.525,786.84 nfet_05v0
M$2386 \$I3686 \$I3685 \$I3688 VSS nfet_05v0 L=0.6U W=0.36U AS=0.0432P
+ AD=0.369P PS=0.6U PD=2.77U
* device instance $2387 r180 *1 666.135,776.23 pfet_05v0
M$2387 \$I3698 \$I3693 \$I3694 VDD_DEC pfet_05v0 L=0.5U W=0.36U AS=0.3456P
+ AD=0.0612P PS=2.64U PD=0.7U
* device instance $2388 r180 *1 665.295,776.23 pfet_05v0
M$2388 \$I3698 \$I3693 VDD_DEC VDD_DEC pfet_05v0 L=0.5U W=0.36U AS=0.379P
+ AD=0.0612P PS=2.37U PD=0.7U
* device instance $2389 r180 *1 663.645,776.55 pfet_05v0
M$2389 \$38 \$I3694 VDD_DEC VDD_DEC pfet_05v0 L=0.5U W=1.22U AS=0.379P
+ AD=0.5368P PS=2.37U PD=3.32U
* device instance $2390 r180 *1 670.375,776.12 pfet_05v0
M$2390 VDD_DEC \$I2082 \$I3692 VDD_DEC pfet_05v0 L=0.5U W=0.36U AS=0.3852P
+ AD=0.1116P PS=2.86U PD=0.98U
* device instance $2391 r180 *1 669.255,776.12 pfet_05v0
M$2391 \$I3697 \$I3692 VDD_DEC VDD_DEC pfet_05v0 L=0.5U W=0.36U AS=0.1116P
+ AD=0.0612P PS=0.98U PD=0.7U
* device instance $2392 r180 *1 668.415,776.12 pfet_05v0
M$2392 \$I3697 \$I3692 \$I3693 VDD_DEC pfet_05v0 L=0.5U W=0.36U AS=0.3852P
+ AD=0.0612P PS=2.86U PD=0.7U
* device instance $2393 r180 *1 666.085,778.998 nfet_05v0
M$2393 \$I3696 \$I3693 \$I3694 VSS nfet_05v0 L=0.6U W=0.365U AS=0.3705P
+ AD=0.0438P PS=2.77U PD=0.605U
* device instance $2394 r180 *1 665.245,778.998 nfet_05v0
M$2394 VSS \$I3693 \$I3696 VSS nfet_05v0 L=0.6U W=0.365U AS=0.0438P
+ AD=0.282625P PS=0.605U PD=1.87U
* device instance $2395 r180 *1 663.595,778.77 nfet_05v0
M$2395 \$38 \$I3694 VSS VSS nfet_05v0 L=0.6U W=0.82U AS=0.282625P AD=0.3608P
+ PS=1.87U PD=2.52U
* device instance $2396 r180 *1 670.325,779 nfet_05v0
M$2396 VSS \$I2082 \$I3692 VSS nfet_05v0 L=0.6U W=0.36U AS=0.333P AD=0.0936P
+ PS=2.57U PD=0.88U
* device instance $2397 r180 *1 669.205,779 nfet_05v0
M$2397 \$I3695 \$I3692 VSS VSS nfet_05v0 L=0.6U W=0.36U AS=0.0936P AD=0.0432P
+ PS=0.88U PD=0.6U
* device instance $2398 r180 *1 668.365,779 nfet_05v0
M$2398 \$I3693 \$I3692 \$I3695 VSS nfet_05v0 L=0.6U W=0.36U AS=0.0432P
+ AD=0.369P PS=0.6U PD=2.77U
* device instance $2399 m90 *1 657.735,790.65 pfet_05v0
M$2399 \$I3705 \$I3700 \$I3701 VDD_DEC pfet_05v0 L=0.5U W=0.36U AS=0.3456P
+ AD=0.0612P PS=2.64U PD=0.7U
* device instance $2400 m90 *1 656.895,790.65 pfet_05v0
M$2400 \$I3705 \$I3700 VDD_DEC VDD_DEC pfet_05v0 L=0.5U W=0.36U AS=0.379P
+ AD=0.0612P PS=2.37U PD=0.7U
* device instance $2401 m90 *1 655.245,790.33 pfet_05v0
M$2401 \$39 \$I3701 VDD_DEC VDD_DEC pfet_05v0 L=0.5U W=1.22U AS=0.379P
+ AD=0.5368P PS=2.37U PD=3.32U
* device instance $2402 m90 *1 661.975,790.76 pfet_05v0
M$2402 VDD_DEC \$I2169 \$I3699 VDD_DEC pfet_05v0 L=0.5U W=0.36U AS=0.3852P
+ AD=0.1116P PS=2.86U PD=0.98U
* device instance $2403 m90 *1 660.855,790.76 pfet_05v0
M$2403 \$I3704 \$I3699 VDD_DEC VDD_DEC pfet_05v0 L=0.5U W=0.36U AS=0.1116P
+ AD=0.0612P PS=0.98U PD=0.7U
* device instance $2404 m90 *1 660.015,790.76 pfet_05v0
M$2404 \$I3704 \$I3699 \$I3700 VDD_DEC pfet_05v0 L=0.5U W=0.36U AS=0.3852P
+ AD=0.0612P PS=2.86U PD=0.7U
* device instance $2405 m90 *1 657.685,787.882 nfet_05v0
M$2405 \$I3703 \$I3700 \$I3701 VSS nfet_05v0 L=0.6U W=0.365U AS=0.3705P
+ AD=0.0438P PS=2.77U PD=0.605U
* device instance $2406 m90 *1 656.845,787.882 nfet_05v0
M$2406 VSS \$I3700 \$I3703 VSS nfet_05v0 L=0.6U W=0.365U AS=0.0438P
+ AD=0.282625P PS=0.605U PD=1.87U
* device instance $2407 m90 *1 655.195,788.11 nfet_05v0
M$2407 \$39 \$I3701 VSS VSS nfet_05v0 L=0.6U W=0.82U AS=0.282625P AD=0.3608P
+ PS=1.87U PD=2.52U
* device instance $2408 m90 *1 661.925,787.88 nfet_05v0
M$2408 VSS \$I2169 \$I3699 VSS nfet_05v0 L=0.6U W=0.36U AS=0.333P AD=0.0936P
+ PS=2.57U PD=0.88U
* device instance $2409 m90 *1 660.805,787.88 nfet_05v0
M$2409 \$I3702 \$I3699 VSS VSS nfet_05v0 L=0.6U W=0.36U AS=0.0936P AD=0.0432P
+ PS=0.88U PD=0.6U
* device instance $2410 m90 *1 659.965,787.88 nfet_05v0
M$2410 \$I3700 \$I3699 \$I3702 VSS nfet_05v0 L=0.6U W=0.36U AS=0.0432P
+ AD=0.369P PS=0.6U PD=2.77U
* device instance $2411 r180 *1 657.175,791.91 pfet_05v0
M$2411 \$I3712 \$I3707 \$I3708 VDD_DEC pfet_05v0 L=0.5U W=0.36U AS=0.3456P
+ AD=0.0612P PS=2.64U PD=0.7U
* device instance $2412 r180 *1 656.335,791.91 pfet_05v0
M$2412 \$I3712 \$I3707 VDD_DEC VDD_DEC pfet_05v0 L=0.5U W=0.36U AS=0.379P
+ AD=0.0612P PS=2.37U PD=0.7U
* device instance $2413 r180 *1 654.685,792.23 pfet_05v0
M$2413 \$40 \$I3708 VDD_DEC VDD_DEC pfet_05v0 L=0.5U W=1.22U AS=0.379P
+ AD=0.5368P PS=2.37U PD=3.32U
* device instance $2414 r180 *1 661.415,791.8 pfet_05v0
M$2414 VDD_DEC \$I2343 \$I3706 VDD_DEC pfet_05v0 L=0.5U W=0.36U AS=0.3852P
+ AD=0.1116P PS=2.86U PD=0.98U
* device instance $2415 r180 *1 660.295,791.8 pfet_05v0
M$2415 \$I3711 \$I3706 VDD_DEC VDD_DEC pfet_05v0 L=0.5U W=0.36U AS=0.1116P
+ AD=0.0612P PS=0.98U PD=0.7U
* device instance $2416 r180 *1 659.455,791.8 pfet_05v0
M$2416 \$I3711 \$I3706 \$I3707 VDD_DEC pfet_05v0 L=0.5U W=0.36U AS=0.3852P
+ AD=0.0612P PS=2.86U PD=0.7U
* device instance $2417 r180 *1 657.125,794.678 nfet_05v0
M$2417 \$I3710 \$I3707 \$I3708 VSS nfet_05v0 L=0.6U W=0.365U AS=0.3705P
+ AD=0.0438P PS=2.77U PD=0.605U
* device instance $2418 r180 *1 656.285,794.678 nfet_05v0
M$2418 VSS \$I3707 \$I3710 VSS nfet_05v0 L=0.6U W=0.365U AS=0.0438P
+ AD=0.282625P PS=0.605U PD=1.87U
* device instance $2419 r180 *1 654.635,794.45 nfet_05v0
M$2419 \$40 \$I3708 VSS VSS nfet_05v0 L=0.6U W=0.82U AS=0.282625P AD=0.3608P
+ PS=1.87U PD=2.52U
* device instance $2420 r180 *1 661.365,794.68 nfet_05v0
M$2420 VSS \$I2343 \$I3706 VSS nfet_05v0 L=0.6U W=0.36U AS=0.333P AD=0.0936P
+ PS=2.57U PD=0.88U
* device instance $2421 r180 *1 660.245,794.68 nfet_05v0
M$2421 \$I3709 \$I3706 VSS VSS nfet_05v0 L=0.6U W=0.36U AS=0.0936P AD=0.0432P
+ PS=0.88U PD=0.6U
* device instance $2422 r180 *1 659.405,794.68 nfet_05v0
M$2422 \$I3707 \$I3706 \$I3709 VSS nfet_05v0 L=0.6U W=0.36U AS=0.0432P
+ AD=0.369P PS=0.6U PD=2.77U
* device instance $2423 r180 *1 637.575,815.43 pfet_05v0
M$2423 \$I3719 \$I3714 \$I3715 VDD_DEC pfet_05v0 L=0.5U W=0.36U AS=0.3456P
+ AD=0.0612P PS=2.64U PD=0.7U
* device instance $2424 r180 *1 636.735,815.43 pfet_05v0
M$2424 \$I3719 \$I3714 VDD_DEC VDD_DEC pfet_05v0 L=0.5U W=0.36U AS=0.379P
+ AD=0.0612P PS=2.37U PD=0.7U
* device instance $2425 r180 *1 635.085,815.75 pfet_05v0
M$2425 \$6 \$I3715 VDD_DEC VDD_DEC pfet_05v0 L=0.5U W=1.22U AS=0.379P
+ AD=0.5368P PS=2.37U PD=3.32U
* device instance $2426 r180 *1 641.815,815.32 pfet_05v0
M$2426 VDD_DEC \$I2408 \$I3713 VDD_DEC pfet_05v0 L=0.5U W=0.36U AS=0.3852P
+ AD=0.1116P PS=2.86U PD=0.98U
* device instance $2427 r180 *1 640.695,815.32 pfet_05v0
M$2427 \$I3718 \$I3713 VDD_DEC VDD_DEC pfet_05v0 L=0.5U W=0.36U AS=0.1116P
+ AD=0.0612P PS=0.98U PD=0.7U
* device instance $2428 r180 *1 639.855,815.32 pfet_05v0
M$2428 \$I3718 \$I3713 \$I3714 VDD_DEC pfet_05v0 L=0.5U W=0.36U AS=0.3852P
+ AD=0.0612P PS=2.86U PD=0.7U
* device instance $2429 r180 *1 637.525,818.198 nfet_05v0
M$2429 \$I3717 \$I3714 \$I3715 VSS nfet_05v0 L=0.6U W=0.365U AS=0.3705P
+ AD=0.0438P PS=2.77U PD=0.605U
* device instance $2430 r180 *1 636.685,818.198 nfet_05v0
M$2430 VSS \$I3714 \$I3717 VSS nfet_05v0 L=0.6U W=0.365U AS=0.0438P
+ AD=0.282625P PS=0.605U PD=1.87U
* device instance $2431 r180 *1 635.035,817.97 nfet_05v0
M$2431 \$6 \$I3715 VSS VSS nfet_05v0 L=0.6U W=0.82U AS=0.282625P AD=0.3608P
+ PS=1.87U PD=2.52U
* device instance $2432 r180 *1 641.765,818.2 nfet_05v0
M$2432 VSS \$I2408 \$I3713 VSS nfet_05v0 L=0.6U W=0.36U AS=0.333P AD=0.0936P
+ PS=2.57U PD=0.88U
* device instance $2433 r180 *1 640.645,818.2 nfet_05v0
M$2433 \$I3716 \$I3713 VSS VSS nfet_05v0 L=0.6U W=0.36U AS=0.0936P AD=0.0432P
+ PS=0.88U PD=0.6U
* device instance $2434 r180 *1 639.805,818.2 nfet_05v0
M$2434 \$I3714 \$I3713 \$I3716 VSS nfet_05v0 L=0.6U W=0.36U AS=0.0432P
+ AD=0.369P PS=0.6U PD=2.77U
* device instance $2435 r180 *1 657.735,799.75 pfet_05v0
M$2435 \$I3726 \$I3721 \$I3722 VDD_DEC pfet_05v0 L=0.5U W=0.36U AS=0.3456P
+ AD=0.0612P PS=2.64U PD=0.7U
* device instance $2436 r180 *1 656.895,799.75 pfet_05v0
M$2436 \$I3726 \$I3721 VDD_DEC VDD_DEC pfet_05v0 L=0.5U W=0.36U AS=0.379P
+ AD=0.0612P PS=2.37U PD=0.7U
* device instance $2437 r180 *1 655.245,800.07 pfet_05v0
M$2437 \$7 \$I3722 VDD_DEC VDD_DEC pfet_05v0 L=0.5U W=1.22U AS=0.379P
+ AD=0.5368P PS=2.37U PD=3.32U
* device instance $2438 r180 *1 661.975,799.64 pfet_05v0
M$2438 VDD_DEC \$I2081 \$I3720 VDD_DEC pfet_05v0 L=0.5U W=0.36U AS=0.3852P
+ AD=0.1116P PS=2.86U PD=0.98U
* device instance $2439 r180 *1 660.855,799.64 pfet_05v0
M$2439 \$I3725 \$I3720 VDD_DEC VDD_DEC pfet_05v0 L=0.5U W=0.36U AS=0.1116P
+ AD=0.0612P PS=0.98U PD=0.7U
* device instance $2440 r180 *1 660.015,799.64 pfet_05v0
M$2440 \$I3725 \$I3720 \$I3721 VDD_DEC pfet_05v0 L=0.5U W=0.36U AS=0.3852P
+ AD=0.0612P PS=2.86U PD=0.7U
* device instance $2441 r180 *1 657.685,802.518 nfet_05v0
M$2441 \$I3724 \$I3721 \$I3722 VSS nfet_05v0 L=0.6U W=0.365U AS=0.3705P
+ AD=0.0438P PS=2.77U PD=0.605U
* device instance $2442 r180 *1 656.845,802.518 nfet_05v0
M$2442 VSS \$I3721 \$I3724 VSS nfet_05v0 L=0.6U W=0.365U AS=0.0438P
+ AD=0.282625P PS=0.605U PD=1.87U
* device instance $2443 r180 *1 655.195,802.29 nfet_05v0
M$2443 \$7 \$I3722 VSS VSS nfet_05v0 L=0.6U W=0.82U AS=0.282625P AD=0.3608P
+ PS=1.87U PD=2.52U
* device instance $2444 r180 *1 661.925,802.52 nfet_05v0
M$2444 VSS \$I2081 \$I3720 VSS nfet_05v0 L=0.6U W=0.36U AS=0.333P AD=0.0936P
+ PS=2.57U PD=0.88U
* device instance $2445 r180 *1 660.805,802.52 nfet_05v0
M$2445 \$I3723 \$I3720 VSS VSS nfet_05v0 L=0.6U W=0.36U AS=0.0936P AD=0.0432P
+ PS=0.88U PD=0.6U
* device instance $2446 r180 *1 659.965,802.52 nfet_05v0
M$2446 \$I3721 \$I3720 \$I3723 VSS nfet_05v0 L=0.6U W=0.36U AS=0.0432P
+ AD=0.369P PS=0.6U PD=2.77U
* device instance $2447 r180 *1 666.135,791.91 pfet_05v0
M$2447 \$I3733 \$I3728 \$I3729 VDD_DEC pfet_05v0 L=0.5U W=0.36U AS=0.3456P
+ AD=0.0612P PS=2.64U PD=0.7U
* device instance $2448 r180 *1 665.295,791.91 pfet_05v0
M$2448 \$I3733 \$I3728 VDD_DEC VDD_DEC pfet_05v0 L=0.5U W=0.36U AS=0.379P
+ AD=0.0612P PS=2.37U PD=0.7U
* device instance $2449 r180 *1 663.645,792.23 pfet_05v0
M$2449 \$8 \$I3729 VDD_DEC VDD_DEC pfet_05v0 L=0.5U W=1.22U AS=0.379P
+ AD=0.5368P PS=2.37U PD=3.32U
* device instance $2450 r180 *1 670.375,791.8 pfet_05v0
M$2450 VDD_DEC \$I2216 \$I3727 VDD_DEC pfet_05v0 L=0.5U W=0.36U AS=0.3852P
+ AD=0.1116P PS=2.86U PD=0.98U
* device instance $2451 r180 *1 669.255,791.8 pfet_05v0
M$2451 \$I3732 \$I3727 VDD_DEC VDD_DEC pfet_05v0 L=0.5U W=0.36U AS=0.1116P
+ AD=0.0612P PS=0.98U PD=0.7U
* device instance $2452 r180 *1 668.415,791.8 pfet_05v0
M$2452 \$I3732 \$I3727 \$I3728 VDD_DEC pfet_05v0 L=0.5U W=0.36U AS=0.3852P
+ AD=0.0612P PS=2.86U PD=0.7U
* device instance $2453 r180 *1 666.085,794.678 nfet_05v0
M$2453 \$I3731 \$I3728 \$I3729 VSS nfet_05v0 L=0.6U W=0.365U AS=0.3705P
+ AD=0.0438P PS=2.77U PD=0.605U
* device instance $2454 r180 *1 665.245,794.678 nfet_05v0
M$2454 VSS \$I3728 \$I3731 VSS nfet_05v0 L=0.6U W=0.365U AS=0.0438P
+ AD=0.282625P PS=0.605U PD=1.87U
* device instance $2455 r180 *1 663.595,794.45 nfet_05v0
M$2455 \$8 \$I3729 VSS VSS nfet_05v0 L=0.6U W=0.82U AS=0.282625P AD=0.3608P
+ PS=1.87U PD=2.52U
* device instance $2456 r180 *1 670.325,794.68 nfet_05v0
M$2456 VSS \$I2216 \$I3727 VSS nfet_05v0 L=0.6U W=0.36U AS=0.333P AD=0.0936P
+ PS=2.57U PD=0.88U
* device instance $2457 r180 *1 669.205,794.68 nfet_05v0
M$2457 \$I3730 \$I3727 VSS VSS nfet_05v0 L=0.6U W=0.36U AS=0.0936P AD=0.0432P
+ PS=0.88U PD=0.6U
* device instance $2458 r180 *1 668.365,794.68 nfet_05v0
M$2458 \$I3728 \$I3727 \$I3730 VSS nfet_05v0 L=0.6U W=0.36U AS=0.0432P
+ AD=0.369P PS=0.6U PD=2.77U
* device instance $2459 r180 *1 648.215,815.43 pfet_05v0
M$2459 \$I3740 \$I3735 \$I3736 VDD_DEC pfet_05v0 L=0.5U W=0.36U AS=0.3456P
+ AD=0.0612P PS=2.64U PD=0.7U
* device instance $2460 r180 *1 647.375,815.43 pfet_05v0
M$2460 \$I3740 \$I3735 VDD_DEC VDD_DEC pfet_05v0 L=0.5U W=0.36U AS=0.379P
+ AD=0.0612P PS=2.37U PD=0.7U
* device instance $2461 r180 *1 645.725,815.75 pfet_05v0
M$2461 \$10 \$I3736 VDD_DEC VDD_DEC pfet_05v0 L=0.5U W=1.22U AS=0.379P
+ AD=0.5368P PS=2.37U PD=3.32U
* device instance $2462 r180 *1 652.455,815.32 pfet_05v0
M$2462 VDD_DEC \$I2416 \$I3734 VDD_DEC pfet_05v0 L=0.5U W=0.36U AS=0.3852P
+ AD=0.1116P PS=2.86U PD=0.98U
* device instance $2463 r180 *1 651.335,815.32 pfet_05v0
M$2463 \$I3739 \$I3734 VDD_DEC VDD_DEC pfet_05v0 L=0.5U W=0.36U AS=0.1116P
+ AD=0.0612P PS=0.98U PD=0.7U
* device instance $2464 r180 *1 650.495,815.32 pfet_05v0
M$2464 \$I3739 \$I3734 \$I3735 VDD_DEC pfet_05v0 L=0.5U W=0.36U AS=0.3852P
+ AD=0.0612P PS=2.86U PD=0.7U
* device instance $2465 r180 *1 648.165,818.198 nfet_05v0
M$2465 \$I3738 \$I3735 \$I3736 VSS nfet_05v0 L=0.6U W=0.365U AS=0.3705P
+ AD=0.0438P PS=2.77U PD=0.605U
* device instance $2466 r180 *1 647.325,818.198 nfet_05v0
M$2466 VSS \$I3735 \$I3738 VSS nfet_05v0 L=0.6U W=0.365U AS=0.0438P
+ AD=0.282625P PS=0.605U PD=1.87U
* device instance $2467 r180 *1 645.675,817.97 nfet_05v0
M$2467 \$10 \$I3736 VSS VSS nfet_05v0 L=0.6U W=0.82U AS=0.282625P AD=0.3608P
+ PS=1.87U PD=2.52U
* device instance $2468 r180 *1 652.405,818.2 nfet_05v0
M$2468 VSS \$I2416 \$I3734 VSS nfet_05v0 L=0.6U W=0.36U AS=0.333P AD=0.0936P
+ PS=2.57U PD=0.88U
* device instance $2469 r180 *1 651.285,818.2 nfet_05v0
M$2469 \$I3737 \$I3734 VSS VSS nfet_05v0 L=0.6U W=0.36U AS=0.0936P AD=0.0432P
+ PS=0.88U PD=0.6U
* device instance $2470 r180 *1 650.445,818.2 nfet_05v0
M$2470 \$I3735 \$I3734 \$I3737 VSS nfet_05v0 L=0.6U W=0.36U AS=0.0432P
+ AD=0.369P PS=0.6U PD=2.77U
* device instance $2471 r180 *1 666.695,799.75 pfet_05v0
M$2471 \$I3747 \$I3742 \$I3743 VDD_DEC pfet_05v0 L=0.5U W=0.36U AS=0.3456P
+ AD=0.0612P PS=2.64U PD=0.7U
* device instance $2472 r180 *1 665.855,799.75 pfet_05v0
M$2472 \$I3747 \$I3742 VDD_DEC VDD_DEC pfet_05v0 L=0.5U W=0.36U AS=0.379P
+ AD=0.0612P PS=2.37U PD=0.7U
* device instance $2473 r180 *1 664.205,800.07 pfet_05v0
M$2473 \$11 \$I3743 VDD_DEC VDD_DEC pfet_05v0 L=0.5U W=1.22U AS=0.379P
+ AD=0.5368P PS=2.37U PD=3.32U
* device instance $2474 r180 *1 670.935,799.64 pfet_05v0
M$2474 VDD_DEC \$I2425 \$I3741 VDD_DEC pfet_05v0 L=0.5U W=0.36U AS=0.3852P
+ AD=0.1116P PS=2.86U PD=0.98U
* device instance $2475 r180 *1 669.815,799.64 pfet_05v0
M$2475 \$I3746 \$I3741 VDD_DEC VDD_DEC pfet_05v0 L=0.5U W=0.36U AS=0.1116P
+ AD=0.0612P PS=0.98U PD=0.7U
* device instance $2476 r180 *1 668.975,799.64 pfet_05v0
M$2476 \$I3746 \$I3741 \$I3742 VDD_DEC pfet_05v0 L=0.5U W=0.36U AS=0.3852P
+ AD=0.0612P PS=2.86U PD=0.7U
* device instance $2477 r180 *1 666.645,802.518 nfet_05v0
M$2477 \$I3745 \$I3742 \$I3743 VSS nfet_05v0 L=0.6U W=0.365U AS=0.3705P
+ AD=0.0438P PS=2.77U PD=0.605U
* device instance $2478 r180 *1 665.805,802.518 nfet_05v0
M$2478 VSS \$I3742 \$I3745 VSS nfet_05v0 L=0.6U W=0.365U AS=0.0438P
+ AD=0.282625P PS=0.605U PD=1.87U
* device instance $2479 r180 *1 664.155,802.29 nfet_05v0
M$2479 \$11 \$I3743 VSS VSS nfet_05v0 L=0.6U W=0.82U AS=0.282625P AD=0.3608P
+ PS=1.87U PD=2.52U
* device instance $2480 r180 *1 670.885,802.52 nfet_05v0
M$2480 VSS \$I2425 \$I3741 VSS nfet_05v0 L=0.6U W=0.36U AS=0.333P AD=0.0936P
+ PS=2.57U PD=0.88U
* device instance $2481 r180 *1 669.765,802.52 nfet_05v0
M$2481 \$I3744 \$I3741 VSS VSS nfet_05v0 L=0.6U W=0.36U AS=0.0936P AD=0.0432P
+ PS=0.88U PD=0.6U
* device instance $2482 r180 *1 668.925,802.52 nfet_05v0
M$2482 \$I3742 \$I3741 \$I3744 VSS nfet_05v0 L=0.6U W=0.36U AS=0.0432P
+ AD=0.369P PS=0.6U PD=2.77U
* device instance $2483 r180 *1 662.215,807.59 pfet_05v0
M$2483 \$I3754 \$I3749 \$I3750 VDD_DEC pfet_05v0 L=0.5U W=0.36U AS=0.3456P
+ AD=0.0612P PS=2.64U PD=0.7U
* device instance $2484 r180 *1 661.375,807.59 pfet_05v0
M$2484 \$I3754 \$I3749 VDD_DEC VDD_DEC pfet_05v0 L=0.5U W=0.36U AS=0.379P
+ AD=0.0612P PS=2.37U PD=0.7U
* device instance $2485 r180 *1 659.725,807.91 pfet_05v0
M$2485 \$12 \$I3750 VDD_DEC VDD_DEC pfet_05v0 L=0.5U W=1.22U AS=0.379P
+ AD=0.5368P PS=2.37U PD=3.32U
* device instance $2486 r180 *1 666.455,807.48 pfet_05v0
M$2486 VDD_DEC \$I2328 \$I3748 VDD_DEC pfet_05v0 L=0.5U W=0.36U AS=0.3852P
+ AD=0.1116P PS=2.86U PD=0.98U
* device instance $2487 r180 *1 665.335,807.48 pfet_05v0
M$2487 \$I3753 \$I3748 VDD_DEC VDD_DEC pfet_05v0 L=0.5U W=0.36U AS=0.1116P
+ AD=0.0612P PS=0.98U PD=0.7U
* device instance $2488 r180 *1 664.495,807.48 pfet_05v0
M$2488 \$I3753 \$I3748 \$I3749 VDD_DEC pfet_05v0 L=0.5U W=0.36U AS=0.3852P
+ AD=0.0612P PS=2.86U PD=0.7U
* device instance $2489 r180 *1 662.165,810.358 nfet_05v0
M$2489 \$I3752 \$I3749 \$I3750 VSS nfet_05v0 L=0.6U W=0.365U AS=0.3705P
+ AD=0.0438P PS=2.77U PD=0.605U
* device instance $2490 r180 *1 661.325,810.358 nfet_05v0
M$2490 VSS \$I3749 \$I3752 VSS nfet_05v0 L=0.6U W=0.365U AS=0.0438P
+ AD=0.282625P PS=0.605U PD=1.87U
* device instance $2491 r180 *1 659.675,810.13 nfet_05v0
M$2491 \$12 \$I3750 VSS VSS nfet_05v0 L=0.6U W=0.82U AS=0.282625P AD=0.3608P
+ PS=1.87U PD=2.52U
* device instance $2492 r180 *1 666.405,810.36 nfet_05v0
M$2492 VSS \$I2328 \$I3748 VSS nfet_05v0 L=0.6U W=0.36U AS=0.333P AD=0.0936P
+ PS=2.57U PD=0.88U
* device instance $2493 r180 *1 665.285,810.36 nfet_05v0
M$2493 \$I3751 \$I3748 VSS VSS nfet_05v0 L=0.6U W=0.36U AS=0.0936P AD=0.0432P
+ PS=0.88U PD=0.6U
* device instance $2494 r180 *1 664.445,810.36 nfet_05v0
M$2494 \$I3749 \$I3748 \$I3751 VSS nfet_05v0 L=0.6U W=0.36U AS=0.0432P
+ AD=0.369P PS=0.6U PD=2.77U
* device instance $2495 m90 *1 651.015,822.01 pfet_05v0
M$2495 \$I3761 \$I3756 \$I3757 VDD_DEC pfet_05v0 L=0.5U W=0.36U AS=0.3456P
+ AD=0.0612P PS=2.64U PD=0.7U
* device instance $2496 m90 *1 650.175,822.01 pfet_05v0
M$2496 \$I3761 \$I3756 VDD_DEC VDD_DEC pfet_05v0 L=0.5U W=0.36U AS=0.379P
+ AD=0.0612P PS=2.37U PD=0.7U
* device instance $2497 m90 *1 648.525,821.69 pfet_05v0
M$2497 \$13 \$I3757 VDD_DEC VDD_DEC pfet_05v0 L=0.5U W=1.22U AS=0.379P
+ AD=0.5368P PS=2.37U PD=3.32U
* device instance $2498 m90 *1 655.255,822.12 pfet_05v0
M$2498 VDD_DEC \$I2258 \$I3755 VDD_DEC pfet_05v0 L=0.5U W=0.36U AS=0.3852P
+ AD=0.1116P PS=2.86U PD=0.98U
* device instance $2499 m90 *1 654.135,822.12 pfet_05v0
M$2499 \$I3760 \$I3755 VDD_DEC VDD_DEC pfet_05v0 L=0.5U W=0.36U AS=0.1116P
+ AD=0.0612P PS=0.98U PD=0.7U
* device instance $2500 m90 *1 653.295,822.12 pfet_05v0
M$2500 \$I3760 \$I3755 \$I3756 VDD_DEC pfet_05v0 L=0.5U W=0.36U AS=0.3852P
+ AD=0.0612P PS=2.86U PD=0.7U
* device instance $2501 m90 *1 650.965,819.242 nfet_05v0
M$2501 \$I3759 \$I3756 \$I3757 VSS nfet_05v0 L=0.6U W=0.365U AS=0.3705P
+ AD=0.0438P PS=2.77U PD=0.605U
* device instance $2502 m90 *1 650.125,819.242 nfet_05v0
M$2502 VSS \$I3756 \$I3759 VSS nfet_05v0 L=0.6U W=0.365U AS=0.0438P
+ AD=0.282625P PS=0.605U PD=1.87U
* device instance $2503 m90 *1 648.475,819.47 nfet_05v0
M$2503 \$13 \$I3757 VSS VSS nfet_05v0 L=0.6U W=0.82U AS=0.282625P AD=0.3608P
+ PS=1.87U PD=2.52U
* device instance $2504 m90 *1 655.205,819.24 nfet_05v0
M$2504 VSS \$I2258 \$I3755 VSS nfet_05v0 L=0.6U W=0.36U AS=0.333P AD=0.0936P
+ PS=2.57U PD=0.88U
* device instance $2505 m90 *1 654.085,819.24 nfet_05v0
M$2505 \$I3758 \$I3755 VSS VSS nfet_05v0 L=0.6U W=0.36U AS=0.0936P AD=0.0432P
+ PS=0.88U PD=0.6U
* device instance $2506 m90 *1 653.245,819.24 nfet_05v0
M$2506 \$I3756 \$I3755 \$I3758 VSS nfet_05v0 L=0.6U W=0.36U AS=0.0432P
+ AD=0.369P PS=0.6U PD=2.77U
* device instance $2507 r180 *1 648.215,823.27 pfet_05v0
M$2507 \$I3768 \$I3763 \$I3764 VDD_DEC pfet_05v0 L=0.5U W=0.36U AS=0.3456P
+ AD=0.0612P PS=2.64U PD=0.7U
* device instance $2508 r180 *1 647.375,823.27 pfet_05v0
M$2508 \$I3768 \$I3763 VDD_DEC VDD_DEC pfet_05v0 L=0.5U W=0.36U AS=0.379P
+ AD=0.0612P PS=2.37U PD=0.7U
* device instance $2509 r180 *1 645.725,823.59 pfet_05v0
M$2509 \$14 \$I3764 VDD_DEC VDD_DEC pfet_05v0 L=0.5U W=1.22U AS=0.379P
+ AD=0.5368P PS=2.37U PD=3.32U
* device instance $2510 r180 *1 652.455,823.16 pfet_05v0
M$2510 VDD_DEC \$I2326 \$I3762 VDD_DEC pfet_05v0 L=0.5U W=0.36U AS=0.3852P
+ AD=0.1116P PS=2.86U PD=0.98U
* device instance $2511 r180 *1 651.335,823.16 pfet_05v0
M$2511 \$I3767 \$I3762 VDD_DEC VDD_DEC pfet_05v0 L=0.5U W=0.36U AS=0.1116P
+ AD=0.0612P PS=0.98U PD=0.7U
* device instance $2512 r180 *1 650.495,823.16 pfet_05v0
M$2512 \$I3767 \$I3762 \$I3763 VDD_DEC pfet_05v0 L=0.5U W=0.36U AS=0.3852P
+ AD=0.0612P PS=2.86U PD=0.7U
* device instance $2513 r180 *1 648.165,826.038 nfet_05v0
M$2513 \$I3766 \$I3763 \$I3764 VSS nfet_05v0 L=0.6U W=0.365U AS=0.3705P
+ AD=0.0438P PS=2.77U PD=0.605U
* device instance $2514 r180 *1 647.325,826.038 nfet_05v0
M$2514 VSS \$I3763 \$I3766 VSS nfet_05v0 L=0.6U W=0.365U AS=0.0438P
+ AD=0.282625P PS=0.605U PD=1.87U
* device instance $2515 r180 *1 645.675,825.81 nfet_05v0
M$2515 \$14 \$I3764 VSS VSS nfet_05v0 L=0.6U W=0.82U AS=0.282625P AD=0.3608P
+ PS=1.87U PD=2.52U
* device instance $2516 r180 *1 652.405,826.04 nfet_05v0
M$2516 VSS \$I2326 \$I3762 VSS nfet_05v0 L=0.6U W=0.36U AS=0.333P AD=0.0936P
+ PS=2.57U PD=0.88U
* device instance $2517 r180 *1 651.285,826.04 nfet_05v0
M$2517 \$I3765 \$I3762 VSS VSS nfet_05v0 L=0.6U W=0.36U AS=0.0936P AD=0.0432P
+ PS=0.88U PD=0.6U
* device instance $2518 r180 *1 650.445,826.04 nfet_05v0
M$2518 \$I3763 \$I3762 \$I3765 VSS nfet_05v0 L=0.6U W=0.36U AS=0.0432P
+ AD=0.369P PS=0.6U PD=2.77U
* device instance $2519 r180 *1 657.175,815.43 pfet_05v0
M$2519 \$I3775 \$I3770 \$I3771 VDD_DEC pfet_05v0 L=0.5U W=0.36U AS=0.3456P
+ AD=0.0612P PS=2.64U PD=0.7U
* device instance $2520 r180 *1 656.335,815.43 pfet_05v0
M$2520 \$I3775 \$I3770 VDD_DEC VDD_DEC pfet_05v0 L=0.5U W=0.36U AS=0.379P
+ AD=0.0612P PS=2.37U PD=0.7U
* device instance $2521 r180 *1 654.685,815.75 pfet_05v0
M$2521 \$15 \$I3771 VDD_DEC VDD_DEC pfet_05v0 L=0.5U W=1.22U AS=0.379P
+ AD=0.5368P PS=2.37U PD=3.32U
* device instance $2522 r180 *1 661.415,815.32 pfet_05v0
M$2522 VDD_DEC \$I2386 \$I3769 VDD_DEC pfet_05v0 L=0.5U W=0.36U AS=0.3852P
+ AD=0.1116P PS=2.86U PD=0.98U
* device instance $2523 r180 *1 660.295,815.32 pfet_05v0
M$2523 \$I3774 \$I3769 VDD_DEC VDD_DEC pfet_05v0 L=0.5U W=0.36U AS=0.1116P
+ AD=0.0612P PS=0.98U PD=0.7U
* device instance $2524 r180 *1 659.455,815.32 pfet_05v0
M$2524 \$I3774 \$I3769 \$I3770 VDD_DEC pfet_05v0 L=0.5U W=0.36U AS=0.3852P
+ AD=0.0612P PS=2.86U PD=0.7U
* device instance $2525 r180 *1 657.125,818.198 nfet_05v0
M$2525 \$I3773 \$I3770 \$I3771 VSS nfet_05v0 L=0.6U W=0.365U AS=0.3705P
+ AD=0.0438P PS=2.77U PD=0.605U
* device instance $2526 r180 *1 656.285,818.198 nfet_05v0
M$2526 VSS \$I3770 \$I3773 VSS nfet_05v0 L=0.6U W=0.365U AS=0.0438P
+ AD=0.282625P PS=0.605U PD=1.87U
* device instance $2527 r180 *1 654.635,817.97 nfet_05v0
M$2527 \$15 \$I3771 VSS VSS nfet_05v0 L=0.6U W=0.82U AS=0.282625P AD=0.3608P
+ PS=1.87U PD=2.52U
* device instance $2528 r180 *1 661.365,818.2 nfet_05v0
M$2528 VSS \$I2386 \$I3769 VSS nfet_05v0 L=0.6U W=0.36U AS=0.333P AD=0.0936P
+ PS=2.57U PD=0.88U
* device instance $2529 r180 *1 660.245,818.2 nfet_05v0
M$2529 \$I3772 \$I3769 VSS VSS nfet_05v0 L=0.6U W=0.36U AS=0.0936P AD=0.0432P
+ PS=0.88U PD=0.6U
* device instance $2530 r180 *1 659.405,818.2 nfet_05v0
M$2530 \$I3770 \$I3769 \$I3772 VSS nfet_05v0 L=0.6U W=0.36U AS=0.0432P
+ AD=0.369P PS=0.6U PD=2.77U
* device instance $2531 m90 *1 648.775,829.85 pfet_05v0
M$2531 \$I3782 \$I3777 \$I3778 VDD_DEC pfet_05v0 L=0.5U W=0.36U AS=0.3456P
+ AD=0.0612P PS=2.64U PD=0.7U
* device instance $2532 m90 *1 647.935,829.85 pfet_05v0
M$2532 \$I3782 \$I3777 VDD_DEC VDD_DEC pfet_05v0 L=0.5U W=0.36U AS=0.379P
+ AD=0.0612P PS=2.37U PD=0.7U
* device instance $2533 m90 *1 646.285,829.53 pfet_05v0
M$2533 \$16 \$I3778 VDD_DEC VDD_DEC pfet_05v0 L=0.5U W=1.22U AS=0.379P
+ AD=0.5368P PS=2.37U PD=3.32U
* device instance $2534 m90 *1 653.015,829.96 pfet_05v0
M$2534 VDD_DEC \$I2288 \$I3776 VDD_DEC pfet_05v0 L=0.5U W=0.36U AS=0.3852P
+ AD=0.1116P PS=2.86U PD=0.98U
* device instance $2535 m90 *1 651.895,829.96 pfet_05v0
M$2535 \$I3781 \$I3776 VDD_DEC VDD_DEC pfet_05v0 L=0.5U W=0.36U AS=0.1116P
+ AD=0.0612P PS=0.98U PD=0.7U
* device instance $2536 m90 *1 651.055,829.96 pfet_05v0
M$2536 \$I3781 \$I3776 \$I3777 VDD_DEC pfet_05v0 L=0.5U W=0.36U AS=0.3852P
+ AD=0.0612P PS=2.86U PD=0.7U
* device instance $2537 m90 *1 648.725,827.082 nfet_05v0
M$2537 \$I3780 \$I3777 \$I3778 VSS nfet_05v0 L=0.6U W=0.365U AS=0.3705P
+ AD=0.0438P PS=2.77U PD=0.605U
* device instance $2538 m90 *1 647.885,827.082 nfet_05v0
M$2538 VSS \$I3777 \$I3780 VSS nfet_05v0 L=0.6U W=0.365U AS=0.0438P
+ AD=0.282625P PS=0.605U PD=1.87U
* device instance $2539 m90 *1 646.235,827.31 nfet_05v0
M$2539 \$16 \$I3778 VSS VSS nfet_05v0 L=0.6U W=0.82U AS=0.282625P AD=0.3608P
+ PS=1.87U PD=2.52U
* device instance $2540 m90 *1 652.965,827.08 nfet_05v0
M$2540 VSS \$I2288 \$I3776 VSS nfet_05v0 L=0.6U W=0.36U AS=0.333P AD=0.0936P
+ PS=2.57U PD=0.88U
* device instance $2541 m90 *1 651.845,827.08 nfet_05v0
M$2541 \$I3779 \$I3776 VSS VSS nfet_05v0 L=0.6U W=0.36U AS=0.0936P AD=0.0432P
+ PS=0.88U PD=0.6U
* device instance $2542 m90 *1 651.005,827.08 nfet_05v0
M$2542 \$I3777 \$I3776 \$I3779 VSS nfet_05v0 L=0.6U W=0.36U AS=0.0432P
+ AD=0.369P PS=0.6U PD=2.77U
* device instance $2543 r180 *1 652.135,831.11 pfet_05v0
M$2543 \$I3789 \$I3784 \$I3785 VDD_DEC pfet_05v0 L=0.5U W=0.36U AS=0.3456P
+ AD=0.0612P PS=2.64U PD=0.7U
* device instance $2544 r180 *1 651.295,831.11 pfet_05v0
M$2544 \$I3789 \$I3784 VDD_DEC VDD_DEC pfet_05v0 L=0.5U W=0.36U AS=0.379P
+ AD=0.0612P PS=2.37U PD=0.7U
* device instance $2545 r180 *1 649.645,831.43 pfet_05v0
M$2545 \$19 \$I3785 VDD_DEC VDD_DEC pfet_05v0 L=0.5U W=1.22U AS=0.379P
+ AD=0.5368P PS=2.37U PD=3.32U
* device instance $2546 r180 *1 656.375,831 pfet_05v0
M$2546 VDD_DEC \$I2369 \$I3783 VDD_DEC pfet_05v0 L=0.5U W=0.36U AS=0.3852P
+ AD=0.1116P PS=2.86U PD=0.98U
* device instance $2547 r180 *1 655.255,831 pfet_05v0
M$2547 \$I3788 \$I3783 VDD_DEC VDD_DEC pfet_05v0 L=0.5U W=0.36U AS=0.1116P
+ AD=0.0612P PS=0.98U PD=0.7U
* device instance $2548 r180 *1 654.415,831 pfet_05v0
M$2548 \$I3788 \$I3783 \$I3784 VDD_DEC pfet_05v0 L=0.5U W=0.36U AS=0.3852P
+ AD=0.0612P PS=2.86U PD=0.7U
* device instance $2549 r180 *1 652.085,833.878 nfet_05v0
M$2549 \$I3787 \$I3784 \$I3785 VSS nfet_05v0 L=0.6U W=0.365U AS=0.3705P
+ AD=0.0438P PS=2.77U PD=0.605U
* device instance $2550 r180 *1 651.245,833.878 nfet_05v0
M$2550 VSS \$I3784 \$I3787 VSS nfet_05v0 L=0.6U W=0.365U AS=0.0438P
+ AD=0.282625P PS=0.605U PD=1.87U
* device instance $2551 r180 *1 649.595,833.65 nfet_05v0
M$2551 \$19 \$I3785 VSS VSS nfet_05v0 L=0.6U W=0.82U AS=0.282625P AD=0.3608P
+ PS=1.87U PD=2.52U
* device instance $2552 r180 *1 656.325,833.88 nfet_05v0
M$2552 VSS \$I2369 \$I3783 VSS nfet_05v0 L=0.6U W=0.36U AS=0.333P AD=0.0936P
+ PS=2.57U PD=0.88U
* device instance $2553 r180 *1 655.205,833.88 nfet_05v0
M$2553 \$I3786 \$I3783 VSS VSS nfet_05v0 L=0.6U W=0.36U AS=0.0936P AD=0.0432P
+ PS=0.88U PD=0.6U
* device instance $2554 r180 *1 654.365,833.88 nfet_05v0
M$2554 \$I3784 \$I3783 \$I3786 VSS nfet_05v0 L=0.6U W=0.36U AS=0.0432P
+ AD=0.369P PS=0.6U PD=2.77U
* device instance $2555 m90 *1 657.735,829.85 pfet_05v0
M$2555 \$I3796 \$I3791 \$I3792 VDD_DEC pfet_05v0 L=0.5U W=0.36U AS=0.3456P
+ AD=0.0612P PS=2.64U PD=0.7U
* device instance $2556 m90 *1 656.895,829.85 pfet_05v0
M$2556 \$I3796 \$I3791 VDD_DEC VDD_DEC pfet_05v0 L=0.5U W=0.36U AS=0.379P
+ AD=0.0612P PS=2.37U PD=0.7U
* device instance $2557 m90 *1 655.245,829.53 pfet_05v0
M$2557 \$20 \$I3792 VDD_DEC VDD_DEC pfet_05v0 L=0.5U W=1.22U AS=0.379P
+ AD=0.5368P PS=2.37U PD=3.32U
* device instance $2558 m90 *1 661.975,829.96 pfet_05v0
M$2558 VDD_DEC \$I2259 \$I3790 VDD_DEC pfet_05v0 L=0.5U W=0.36U AS=0.3852P
+ AD=0.1116P PS=2.86U PD=0.98U
* device instance $2559 m90 *1 660.855,829.96 pfet_05v0
M$2559 \$I3795 \$I3790 VDD_DEC VDD_DEC pfet_05v0 L=0.5U W=0.36U AS=0.1116P
+ AD=0.0612P PS=0.98U PD=0.7U
* device instance $2560 m90 *1 660.015,829.96 pfet_05v0
M$2560 \$I3795 \$I3790 \$I3791 VDD_DEC pfet_05v0 L=0.5U W=0.36U AS=0.3852P
+ AD=0.0612P PS=2.86U PD=0.7U
* device instance $2561 m90 *1 657.685,827.082 nfet_05v0
M$2561 \$I3794 \$I3791 \$I3792 VSS nfet_05v0 L=0.6U W=0.365U AS=0.3705P
+ AD=0.0438P PS=2.77U PD=0.605U
* device instance $2562 m90 *1 656.845,827.082 nfet_05v0
M$2562 VSS \$I3791 \$I3794 VSS nfet_05v0 L=0.6U W=0.365U AS=0.0438P
+ AD=0.282625P PS=0.605U PD=1.87U
* device instance $2563 m90 *1 655.195,827.31 nfet_05v0
M$2563 \$20 \$I3792 VSS VSS nfet_05v0 L=0.6U W=0.82U AS=0.282625P AD=0.3608P
+ PS=1.87U PD=2.52U
* device instance $2564 m90 *1 661.925,827.08 nfet_05v0
M$2564 VSS \$I2259 \$I3790 VSS nfet_05v0 L=0.6U W=0.36U AS=0.333P AD=0.0936P
+ PS=2.57U PD=0.88U
* device instance $2565 m90 *1 660.805,827.08 nfet_05v0
M$2565 \$I3793 \$I3790 VSS VSS nfet_05v0 L=0.6U W=0.36U AS=0.0936P AD=0.0432P
+ PS=0.88U PD=0.6U
* device instance $2566 m90 *1 659.965,827.08 nfet_05v0
M$2566 \$I3791 \$I3790 \$I3793 VSS nfet_05v0 L=0.6U W=0.36U AS=0.0432P
+ AD=0.369P PS=0.6U PD=2.77U
* device instance $2567 r180 *1 666.135,823.27 pfet_05v0
M$2567 \$I3803 \$I3798 \$I3799 VDD_DEC pfet_05v0 L=0.5U W=0.36U AS=0.3456P
+ AD=0.0612P PS=2.64U PD=0.7U
* device instance $2568 r180 *1 665.295,823.27 pfet_05v0
M$2568 \$I3803 \$I3798 VDD_DEC VDD_DEC pfet_05v0 L=0.5U W=0.36U AS=0.379P
+ AD=0.0612P PS=2.37U PD=0.7U
* device instance $2569 r180 *1 663.645,823.59 pfet_05v0
M$2569 \$21 \$I3799 VDD_DEC VDD_DEC pfet_05v0 L=0.5U W=1.22U AS=0.379P
+ AD=0.5368P PS=2.37U PD=3.32U
* device instance $2570 r180 *1 670.375,823.16 pfet_05v0
M$2570 VDD_DEC \$I2421 \$I3797 VDD_DEC pfet_05v0 L=0.5U W=0.36U AS=0.3852P
+ AD=0.1116P PS=2.86U PD=0.98U
* device instance $2571 r180 *1 669.255,823.16 pfet_05v0
M$2571 \$I3802 \$I3797 VDD_DEC VDD_DEC pfet_05v0 L=0.5U W=0.36U AS=0.1116P
+ AD=0.0612P PS=0.98U PD=0.7U
* device instance $2572 r180 *1 668.415,823.16 pfet_05v0
M$2572 \$I3802 \$I3797 \$I3798 VDD_DEC pfet_05v0 L=0.5U W=0.36U AS=0.3852P
+ AD=0.0612P PS=2.86U PD=0.7U
* device instance $2573 r180 *1 666.085,826.038 nfet_05v0
M$2573 \$I3801 \$I3798 \$I3799 VSS nfet_05v0 L=0.6U W=0.365U AS=0.3705P
+ AD=0.0438P PS=2.77U PD=0.605U
* device instance $2574 r180 *1 665.245,826.038 nfet_05v0
M$2574 VSS \$I3798 \$I3801 VSS nfet_05v0 L=0.6U W=0.365U AS=0.0438P
+ AD=0.282625P PS=0.605U PD=1.87U
* device instance $2575 r180 *1 663.595,825.81 nfet_05v0
M$2575 \$21 \$I3799 VSS VSS nfet_05v0 L=0.6U W=0.82U AS=0.282625P AD=0.3608P
+ PS=1.87U PD=2.52U
* device instance $2576 r180 *1 670.325,826.04 nfet_05v0
M$2576 VSS \$I2421 \$I3797 VSS nfet_05v0 L=0.6U W=0.36U AS=0.333P AD=0.0936P
+ PS=2.57U PD=0.88U
* device instance $2577 r180 *1 669.205,826.04 nfet_05v0
M$2577 \$I3800 \$I3797 VSS VSS nfet_05v0 L=0.6U W=0.36U AS=0.0936P AD=0.0432P
+ PS=0.88U PD=0.6U
* device instance $2578 r180 *1 668.365,826.04 nfet_05v0
M$2578 \$I3798 \$I3797 \$I3800 VSS nfet_05v0 L=0.6U W=0.36U AS=0.0432P
+ AD=0.369P PS=0.6U PD=2.77U
* device instance $2579 r0 *1 493.225,774.97 pfet_05v0
M$2579 \$I3810 \$I3805 \$I3806 VDD_DEC pfet_05v0 L=0.5U W=0.36U AS=0.3456P
+ AD=0.0612P PS=2.64U PD=0.7U
* device instance $2580 r0 *1 494.065,774.97 pfet_05v0
M$2580 \$I3810 \$I3805 VDD_DEC VDD_DEC pfet_05v0 L=0.5U W=0.36U AS=0.379P
+ AD=0.0612P PS=2.37U PD=0.7U
* device instance $2581 r0 *1 495.715,774.65 pfet_05v0
M$2581 \$276 \$I3806 VDD_DEC VDD_DEC pfet_05v0 L=0.5U W=1.22U AS=0.379P
+ AD=0.5368P PS=2.37U PD=3.32U
* device instance $2582 r0 *1 488.985,775.08 pfet_05v0
M$2582 VDD_DEC \$I2019 \$I3804 VDD_DEC pfet_05v0 L=0.5U W=0.36U AS=0.3852P
+ AD=0.1116P PS=2.86U PD=0.98U
* device instance $2583 r0 *1 490.105,775.08 pfet_05v0
M$2583 \$I3809 \$I3804 VDD_DEC VDD_DEC pfet_05v0 L=0.5U W=0.36U AS=0.1116P
+ AD=0.0612P PS=0.98U PD=0.7U
* device instance $2584 r0 *1 490.945,775.08 pfet_05v0
M$2584 \$I3809 \$I3804 \$I3805 VDD_DEC pfet_05v0 L=0.5U W=0.36U AS=0.3852P
+ AD=0.0612P PS=2.86U PD=0.7U
* device instance $2585 r0 *1 493.275,772.202 nfet_05v0
M$2585 \$I3808 \$I3805 \$I3806 VSS nfet_05v0 L=0.6U W=0.365U AS=0.3705P
+ AD=0.0438P PS=2.77U PD=0.605U
* device instance $2586 r0 *1 494.115,772.202 nfet_05v0
M$2586 VSS \$I3805 \$I3808 VSS nfet_05v0 L=0.6U W=0.365U AS=0.0438P
+ AD=0.282625P PS=0.605U PD=1.87U
* device instance $2587 r0 *1 495.765,772.43 nfet_05v0
M$2587 \$276 \$I3806 VSS VSS nfet_05v0 L=0.6U W=0.82U AS=0.282625P AD=0.3608P
+ PS=1.87U PD=2.52U
* device instance $2588 r0 *1 489.035,772.2 nfet_05v0
M$2588 VSS \$I2019 \$I3804 VSS nfet_05v0 L=0.6U W=0.36U AS=0.333P AD=0.0936P
+ PS=2.57U PD=0.88U
* device instance $2589 r0 *1 490.155,772.2 nfet_05v0
M$2589 \$I3807 \$I3804 VSS VSS nfet_05v0 L=0.6U W=0.36U AS=0.0936P AD=0.0432P
+ PS=0.88U PD=0.6U
* device instance $2590 r0 *1 490.995,772.2 nfet_05v0
M$2590 \$I3805 \$I3804 \$I3807 VSS nfet_05v0 L=0.6U W=0.36U AS=0.0432P
+ AD=0.369P PS=0.6U PD=2.77U
* device instance $2591 r0 *1 493.785,790.65 pfet_05v0
M$2591 \$I3817 \$I3812 \$I3813 VDD_DEC pfet_05v0 L=0.5U W=0.36U AS=0.3456P
+ AD=0.0612P PS=2.64U PD=0.7U
* device instance $2592 r0 *1 494.625,790.65 pfet_05v0
M$2592 \$I3817 \$I3812 VDD_DEC VDD_DEC pfet_05v0 L=0.5U W=0.36U AS=0.379P
+ AD=0.0612P PS=2.37U PD=0.7U
* device instance $2593 r0 *1 496.275,790.33 pfet_05v0
M$2593 \$265 \$I3813 VDD_DEC VDD_DEC pfet_05v0 L=0.5U W=1.22U AS=0.379P
+ AD=0.5368P PS=2.37U PD=3.32U
* device instance $2594 r0 *1 489.545,790.76 pfet_05v0
M$2594 VDD_DEC \$I2159 \$I3811 VDD_DEC pfet_05v0 L=0.5U W=0.36U AS=0.3852P
+ AD=0.1116P PS=2.86U PD=0.98U
* device instance $2595 r0 *1 490.665,790.76 pfet_05v0
M$2595 \$I3816 \$I3811 VDD_DEC VDD_DEC pfet_05v0 L=0.5U W=0.36U AS=0.1116P
+ AD=0.0612P PS=0.98U PD=0.7U
* device instance $2596 r0 *1 491.505,790.76 pfet_05v0
M$2596 \$I3816 \$I3811 \$I3812 VDD_DEC pfet_05v0 L=0.5U W=0.36U AS=0.3852P
+ AD=0.0612P PS=2.86U PD=0.7U
* device instance $2597 r0 *1 493.835,787.882 nfet_05v0
M$2597 \$I3815 \$I3812 \$I3813 VSS nfet_05v0 L=0.6U W=0.365U AS=0.3705P
+ AD=0.0438P PS=2.77U PD=0.605U
* device instance $2598 r0 *1 494.675,787.882 nfet_05v0
M$2598 VSS \$I3812 \$I3815 VSS nfet_05v0 L=0.6U W=0.365U AS=0.0438P
+ AD=0.282625P PS=0.605U PD=1.87U
* device instance $2599 r0 *1 496.325,788.11 nfet_05v0
M$2599 \$265 \$I3813 VSS VSS nfet_05v0 L=0.6U W=0.82U AS=0.282625P AD=0.3608P
+ PS=1.87U PD=2.52U
* device instance $2600 r0 *1 489.595,787.88 nfet_05v0
M$2600 VSS \$I2159 \$I3811 VSS nfet_05v0 L=0.6U W=0.36U AS=0.333P AD=0.0936P
+ PS=2.57U PD=0.88U
* device instance $2601 r0 *1 490.715,787.88 nfet_05v0
M$2601 \$I3814 \$I3811 VSS VSS nfet_05v0 L=0.6U W=0.36U AS=0.0936P AD=0.0432P
+ PS=0.88U PD=0.6U
* device instance $2602 r0 *1 491.555,787.88 nfet_05v0
M$2602 \$I3812 \$I3811 \$I3814 VSS nfet_05v0 L=0.6U W=0.36U AS=0.0432P
+ AD=0.369P PS=0.6U PD=2.77U
* device instance $2603 m0 *1 495.465,784.07 pfet_05v0
M$2603 \$I3824 \$I3819 \$I3820 VDD_DEC pfet_05v0 L=0.5U W=0.36U AS=0.3456P
+ AD=0.0612P PS=2.64U PD=0.7U
* device instance $2604 m0 *1 496.305,784.07 pfet_05v0
M$2604 \$I3824 \$I3819 VDD_DEC VDD_DEC pfet_05v0 L=0.5U W=0.36U AS=0.379P
+ AD=0.0612P PS=2.37U PD=0.7U
* device instance $2605 m0 *1 497.955,784.39 pfet_05v0
M$2605 \$268 \$I3820 VDD_DEC VDD_DEC pfet_05v0 L=0.5U W=1.22U AS=0.379P
+ AD=0.5368P PS=2.37U PD=3.32U
* device instance $2606 m0 *1 491.225,783.96 pfet_05v0
M$2606 VDD_DEC \$I2123 \$I3818 VDD_DEC pfet_05v0 L=0.5U W=0.36U AS=0.3852P
+ AD=0.1116P PS=2.86U PD=0.98U
* device instance $2607 m0 *1 492.345,783.96 pfet_05v0
M$2607 \$I3823 \$I3818 VDD_DEC VDD_DEC pfet_05v0 L=0.5U W=0.36U AS=0.1116P
+ AD=0.0612P PS=0.98U PD=0.7U
* device instance $2608 m0 *1 493.185,783.96 pfet_05v0
M$2608 \$I3823 \$I3818 \$I3819 VDD_DEC pfet_05v0 L=0.5U W=0.36U AS=0.3852P
+ AD=0.0612P PS=2.86U PD=0.7U
* device instance $2609 m0 *1 495.515,786.838 nfet_05v0
M$2609 \$I3822 \$I3819 \$I3820 VSS nfet_05v0 L=0.6U W=0.365U AS=0.3705P
+ AD=0.0438P PS=2.77U PD=0.605U
* device instance $2610 m0 *1 496.355,786.838 nfet_05v0
M$2610 VSS \$I3819 \$I3822 VSS nfet_05v0 L=0.6U W=0.365U AS=0.0438P
+ AD=0.282625P PS=0.605U PD=1.87U
* device instance $2611 m0 *1 498.005,786.61 nfet_05v0
M$2611 \$268 \$I3820 VSS VSS nfet_05v0 L=0.6U W=0.82U AS=0.282625P AD=0.3608P
+ PS=1.87U PD=2.52U
* device instance $2612 m0 *1 491.275,786.84 nfet_05v0
M$2612 VSS \$I2123 \$I3818 VSS nfet_05v0 L=0.6U W=0.36U AS=0.333P AD=0.0936P
+ PS=2.57U PD=0.88U
* device instance $2613 m0 *1 492.395,786.84 nfet_05v0
M$2613 \$I3821 \$I3818 VSS VSS nfet_05v0 L=0.6U W=0.36U AS=0.0936P AD=0.0432P
+ PS=0.88U PD=0.6U
* device instance $2614 m0 *1 493.235,786.84 nfet_05v0
M$2614 \$I3819 \$I3818 \$I3821 VSS nfet_05v0 L=0.6U W=0.36U AS=0.0432P
+ AD=0.369P PS=0.6U PD=2.77U
* device instance $2615 r0 *1 493.785,782.81 pfet_05v0
M$2615 \$I3831 \$I3826 \$I3827 VDD_DEC pfet_05v0 L=0.5U W=0.36U AS=0.3456P
+ AD=0.0612P PS=2.64U PD=0.7U
* device instance $2616 r0 *1 494.625,782.81 pfet_05v0
M$2616 \$I3831 \$I3826 VDD_DEC VDD_DEC pfet_05v0 L=0.5U W=0.36U AS=0.379P
+ AD=0.0612P PS=2.37U PD=0.7U
* device instance $2617 r0 *1 496.275,782.49 pfet_05v0
M$2617 \$270 \$I3827 VDD_DEC VDD_DEC pfet_05v0 L=0.5U W=1.22U AS=0.379P
+ AD=0.5368P PS=2.37U PD=3.32U
* device instance $2618 r0 *1 489.545,782.92 pfet_05v0
M$2618 VDD_DEC \$I2052 \$I3825 VDD_DEC pfet_05v0 L=0.5U W=0.36U AS=0.3852P
+ AD=0.1116P PS=2.86U PD=0.98U
* device instance $2619 r0 *1 490.665,782.92 pfet_05v0
M$2619 \$I3830 \$I3825 VDD_DEC VDD_DEC pfet_05v0 L=0.5U W=0.36U AS=0.1116P
+ AD=0.0612P PS=0.98U PD=0.7U
* device instance $2620 r0 *1 491.505,782.92 pfet_05v0
M$2620 \$I3830 \$I3825 \$I3826 VDD_DEC pfet_05v0 L=0.5U W=0.36U AS=0.3852P
+ AD=0.0612P PS=2.86U PD=0.7U
* device instance $2621 r0 *1 493.835,780.042 nfet_05v0
M$2621 \$I3829 \$I3826 \$I3827 VSS nfet_05v0 L=0.6U W=0.365U AS=0.3705P
+ AD=0.0438P PS=2.77U PD=0.605U
* device instance $2622 r0 *1 494.675,780.042 nfet_05v0
M$2622 VSS \$I3826 \$I3829 VSS nfet_05v0 L=0.6U W=0.365U AS=0.0438P
+ AD=0.282625P PS=0.605U PD=1.87U
* device instance $2623 r0 *1 496.325,780.27 nfet_05v0
M$2623 \$270 \$I3827 VSS VSS nfet_05v0 L=0.6U W=0.82U AS=0.282625P AD=0.3608P
+ PS=1.87U PD=2.52U
* device instance $2624 r0 *1 489.595,780.04 nfet_05v0
M$2624 VSS \$I2052 \$I3825 VSS nfet_05v0 L=0.6U W=0.36U AS=0.333P AD=0.0936P
+ PS=2.57U PD=0.88U
* device instance $2625 r0 *1 490.715,780.04 nfet_05v0
M$2625 \$I3828 \$I3825 VSS VSS nfet_05v0 L=0.6U W=0.36U AS=0.0936P AD=0.0432P
+ PS=0.88U PD=0.6U
* device instance $2626 r0 *1 491.555,780.04 nfet_05v0
M$2626 \$I3826 \$I3825 \$I3828 VSS nfet_05v0 L=0.6U W=0.36U AS=0.0432P
+ AD=0.369P PS=0.6U PD=2.77U
* device instance $2627 m90 *1 579.335,806.33 pfet_05v0
M$2627 \$I3838 \$I3833 \$I3834 VDD_DEC pfet_05v0 L=0.5U W=0.36U AS=0.3456P
+ AD=0.0612P PS=2.64U PD=0.7U
* device instance $2628 m90 *1 578.495,806.33 pfet_05v0
M$2628 \$I3838 \$I3833 VDD_DEC VDD_DEC pfet_05v0 L=0.5U W=0.36U AS=0.379P
+ AD=0.0612P PS=2.37U PD=0.7U
* device instance $2629 m90 *1 576.845,806.01 pfet_05v0
M$2629 \$I2207 \$I3834 VDD_DEC VDD_DEC pfet_05v0 L=0.5U W=1.22U AS=0.379P
+ AD=0.5368P PS=2.37U PD=3.32U
* device instance $2630 m90 *1 583.575,806.44 pfet_05v0
M$2630 VDD_DEC \$I2310 \$I3832 VDD_DEC pfet_05v0 L=0.5U W=0.36U AS=0.3852P
+ AD=0.1116P PS=2.86U PD=0.98U
* device instance $2631 m90 *1 582.455,806.44 pfet_05v0
M$2631 \$I3837 \$I3832 VDD_DEC VDD_DEC pfet_05v0 L=0.5U W=0.36U AS=0.1116P
+ AD=0.0612P PS=0.98U PD=0.7U
* device instance $2632 m90 *1 581.615,806.44 pfet_05v0
M$2632 \$I3837 \$I3832 \$I3833 VDD_DEC pfet_05v0 L=0.5U W=0.36U AS=0.3852P
+ AD=0.0612P PS=2.86U PD=0.7U
* device instance $2633 m90 *1 579.285,803.562 nfet_05v0
M$2633 \$I3836 \$I3833 \$I3834 VSS nfet_05v0 L=0.6U W=0.365U AS=0.3705P
+ AD=0.0438P PS=2.77U PD=0.605U
* device instance $2634 m90 *1 578.445,803.562 nfet_05v0
M$2634 VSS \$I3833 \$I3836 VSS nfet_05v0 L=0.6U W=0.365U AS=0.0438P
+ AD=0.282625P PS=0.605U PD=1.87U
* device instance $2635 m90 *1 576.795,803.79 nfet_05v0
M$2635 \$I2207 \$I3834 VSS VSS nfet_05v0 L=0.6U W=0.82U AS=0.282625P AD=0.3608P
+ PS=1.87U PD=2.52U
* device instance $2636 m90 *1 583.525,803.56 nfet_05v0
M$2636 VSS \$I2310 \$I3832 VSS nfet_05v0 L=0.6U W=0.36U AS=0.333P AD=0.0936P
+ PS=2.57U PD=0.88U
* device instance $2637 m90 *1 582.405,803.56 nfet_05v0
M$2637 \$I3835 \$I3832 VSS VSS nfet_05v0 L=0.6U W=0.36U AS=0.0936P AD=0.0432P
+ PS=0.88U PD=0.6U
* device instance $2638 m90 *1 581.565,803.56 nfet_05v0
M$2638 \$I3833 \$I3832 \$I3835 VSS nfet_05v0 L=0.6U W=0.36U AS=0.0432P
+ AD=0.369P PS=0.6U PD=2.77U
* device instance $2639 m90 *1 512.135,798.49 pfet_05v0
M$2639 \$I3845 \$I3840 \$I3841 VDD_DEC pfet_05v0 L=0.5U W=0.36U AS=0.3456P
+ AD=0.0612P PS=2.64U PD=0.7U
* device instance $2640 m90 *1 511.295,798.49 pfet_05v0
M$2640 \$I3845 \$I3840 VDD_DEC VDD_DEC pfet_05v0 L=0.5U W=0.36U AS=0.379P
+ AD=0.0612P PS=2.37U PD=0.7U
* device instance $2641 m90 *1 509.645,798.17 pfet_05v0
M$2641 \$I2196 \$I3841 VDD_DEC VDD_DEC pfet_05v0 L=0.5U W=1.22U AS=0.379P
+ AD=0.5368P PS=2.37U PD=3.32U
* device instance $2642 m90 *1 516.375,798.6 pfet_05v0
M$2642 VDD_DEC \$I2201 \$I3839 VDD_DEC pfet_05v0 L=0.5U W=0.36U AS=0.3852P
+ AD=0.1116P PS=2.86U PD=0.98U
* device instance $2643 m90 *1 515.255,798.6 pfet_05v0
M$2643 \$I3844 \$I3839 VDD_DEC VDD_DEC pfet_05v0 L=0.5U W=0.36U AS=0.1116P
+ AD=0.0612P PS=0.98U PD=0.7U
* device instance $2644 m90 *1 514.415,798.6 pfet_05v0
M$2644 \$I3844 \$I3839 \$I3840 VDD_DEC pfet_05v0 L=0.5U W=0.36U AS=0.3852P
+ AD=0.0612P PS=2.86U PD=0.7U
* device instance $2645 m90 *1 512.085,795.722 nfet_05v0
M$2645 \$I3843 \$I3840 \$I3841 VSS nfet_05v0 L=0.6U W=0.365U AS=0.3705P
+ AD=0.0438P PS=2.77U PD=0.605U
* device instance $2646 m90 *1 511.245,795.722 nfet_05v0
M$2646 VSS \$I3840 \$I3843 VSS nfet_05v0 L=0.6U W=0.365U AS=0.0438P
+ AD=0.282625P PS=0.605U PD=1.87U
* device instance $2647 m90 *1 509.595,795.95 nfet_05v0
M$2647 \$I2196 \$I3841 VSS VSS nfet_05v0 L=0.6U W=0.82U AS=0.282625P AD=0.3608P
+ PS=1.87U PD=2.52U
* device instance $2648 m90 *1 516.325,795.72 nfet_05v0
M$2648 VSS \$I2201 \$I3839 VSS nfet_05v0 L=0.6U W=0.36U AS=0.333P AD=0.0936P
+ PS=2.57U PD=0.88U
* device instance $2649 m90 *1 515.205,795.72 nfet_05v0
M$2649 \$I3842 \$I3839 VSS VSS nfet_05v0 L=0.6U W=0.36U AS=0.0936P AD=0.0432P
+ PS=0.88U PD=0.6U
* device instance $2650 m90 *1 514.365,795.72 nfet_05v0
M$2650 \$I3840 \$I3839 \$I3842 VSS nfet_05v0 L=0.6U W=0.36U AS=0.0432P
+ AD=0.369P PS=0.6U PD=2.77U
* device instance $2651 m90 *1 666.695,837.69 pfet_05v0
M$2651 \$I3852 \$I3847 \$I3848 VDD_DEC pfet_05v0 L=0.5U W=0.36U AS=0.3456P
+ AD=0.0612P PS=2.64U PD=0.7U
* device instance $2652 m90 *1 665.855,837.69 pfet_05v0
M$2652 \$I3852 \$I3847 VDD_DEC VDD_DEC pfet_05v0 L=0.5U W=0.36U AS=0.379P
+ AD=0.0612P PS=2.37U PD=0.7U
* device instance $2653 m90 *1 664.205,837.37 pfet_05v0
M$2653 \$I2344 \$I3848 VDD_DEC VDD_DEC pfet_05v0 L=0.5U W=1.22U AS=0.379P
+ AD=0.5368P PS=2.37U PD=3.32U
* device instance $2654 m90 *1 670.935,837.8 pfet_05v0
M$2654 VDD_DEC D[6] \$I3846 VDD_DEC pfet_05v0 L=0.5U W=0.36U AS=0.3852P
+ AD=0.1116P PS=2.86U PD=0.98U
* device instance $2655 m90 *1 669.815,837.8 pfet_05v0
M$2655 \$I3851 \$I3846 VDD_DEC VDD_DEC pfet_05v0 L=0.5U W=0.36U AS=0.1116P
+ AD=0.0612P PS=0.98U PD=0.7U
* device instance $2656 m90 *1 668.975,837.8 pfet_05v0
M$2656 \$I3851 \$I3846 \$I3847 VDD_DEC pfet_05v0 L=0.5U W=0.36U AS=0.3852P
+ AD=0.0612P PS=2.86U PD=0.7U
* device instance $2657 m90 *1 666.645,834.922 nfet_05v0
M$2657 \$I3850 \$I3847 \$I3848 VSS nfet_05v0 L=0.6U W=0.365U AS=0.3705P
+ AD=0.0438P PS=2.77U PD=0.605U
* device instance $2658 m90 *1 665.805,834.922 nfet_05v0
M$2658 VSS \$I3847 \$I3850 VSS nfet_05v0 L=0.6U W=0.365U AS=0.0438P
+ AD=0.282625P PS=0.605U PD=1.87U
* device instance $2659 m90 *1 664.155,835.15 nfet_05v0
M$2659 \$I2344 \$I3848 VSS VSS nfet_05v0 L=0.6U W=0.82U AS=0.282625P AD=0.3608P
+ PS=1.87U PD=2.52U
* device instance $2660 m90 *1 670.885,834.92 nfet_05v0
M$2660 VSS D[6] \$I3846 VSS nfet_05v0 L=0.6U W=0.36U AS=0.333P AD=0.0936P
+ PS=2.57U PD=0.88U
* device instance $2661 m90 *1 669.765,834.92 nfet_05v0
M$2661 \$I3849 \$I3846 VSS VSS nfet_05v0 L=0.6U W=0.36U AS=0.0936P AD=0.0432P
+ PS=0.88U PD=0.6U
* device instance $2662 m90 *1 668.925,834.92 nfet_05v0
M$2662 \$I3847 \$I3846 \$I3849 VSS nfet_05v0 L=0.6U W=0.36U AS=0.0432P
+ AD=0.369P PS=0.6U PD=2.77U
* device instance $2663 m90 *1 555.815,837.69 pfet_05v0
M$2663 \$I3859 \$I3854 \$I3855 VDD_DEC pfet_05v0 L=0.5U W=0.36U AS=0.3456P
+ AD=0.0612P PS=2.64U PD=0.7U
* device instance $2664 m90 *1 554.975,837.69 pfet_05v0
M$2664 \$I3859 \$I3854 VDD_DEC VDD_DEC pfet_05v0 L=0.5U W=0.36U AS=0.379P
+ AD=0.0612P PS=2.37U PD=0.7U
* device instance $2665 m90 *1 553.325,837.37 pfet_05v0
M$2665 \$I2417 \$I3855 VDD_DEC VDD_DEC pfet_05v0 L=0.5U W=1.22U AS=0.379P
+ AD=0.5368P PS=2.37U PD=3.32U
* device instance $2666 m90 *1 560.055,837.8 pfet_05v0
M$2666 VDD_DEC D[2] \$I3853 VDD_DEC pfet_05v0 L=0.5U W=0.36U AS=0.3852P
+ AD=0.1116P PS=2.86U PD=0.98U
* device instance $2667 m90 *1 558.935,837.8 pfet_05v0
M$2667 \$I3858 \$I3853 VDD_DEC VDD_DEC pfet_05v0 L=0.5U W=0.36U AS=0.1116P
+ AD=0.0612P PS=0.98U PD=0.7U
* device instance $2668 m90 *1 558.095,837.8 pfet_05v0
M$2668 \$I3858 \$I3853 \$I3854 VDD_DEC pfet_05v0 L=0.5U W=0.36U AS=0.3852P
+ AD=0.0612P PS=2.86U PD=0.7U
* device instance $2669 m90 *1 555.765,834.922 nfet_05v0
M$2669 \$I3857 \$I3854 \$I3855 VSS nfet_05v0 L=0.6U W=0.365U AS=0.3705P
+ AD=0.0438P PS=2.77U PD=0.605U
* device instance $2670 m90 *1 554.925,834.922 nfet_05v0
M$2670 VSS \$I3854 \$I3857 VSS nfet_05v0 L=0.6U W=0.365U AS=0.0438P
+ AD=0.282625P PS=0.605U PD=1.87U
* device instance $2671 m90 *1 553.275,835.15 nfet_05v0
M$2671 \$I2417 \$I3855 VSS VSS nfet_05v0 L=0.6U W=0.82U AS=0.282625P AD=0.3608P
+ PS=1.87U PD=2.52U
* device instance $2672 m90 *1 560.005,834.92 nfet_05v0
M$2672 VSS D[2] \$I3853 VSS nfet_05v0 L=0.6U W=0.36U AS=0.333P AD=0.0936P
+ PS=2.57U PD=0.88U
* device instance $2673 m90 *1 558.885,834.92 nfet_05v0
M$2673 \$I3856 \$I3853 VSS VSS nfet_05v0 L=0.6U W=0.36U AS=0.0936P AD=0.0432P
+ PS=0.88U PD=0.6U
* device instance $2674 m90 *1 558.045,834.92 nfet_05v0
M$2674 \$I3854 \$I3853 \$I3856 VSS nfet_05v0 L=0.6U W=0.36U AS=0.0432P
+ AD=0.369P PS=0.6U PD=2.77U
* device instance $2675 m90 *1 648.775,790.65 pfet_05v0
M$2675 \$I3866 \$I3861 \$I3862 VDD_DEC pfet_05v0 L=0.5U W=0.36U AS=0.3456P
+ AD=0.0612P PS=2.64U PD=0.7U
* device instance $2676 m90 *1 647.935,790.65 pfet_05v0
M$2676 \$I3866 \$I3861 VDD_DEC VDD_DEC pfet_05v0 L=0.5U W=0.36U AS=0.379P
+ AD=0.0612P PS=2.37U PD=0.7U
* device instance $2677 m90 *1 646.285,790.33 pfet_05v0
M$2677 \$I2177 \$I3862 VDD_DEC VDD_DEC pfet_05v0 L=0.5U W=1.22U AS=0.379P
+ AD=0.5368P PS=2.37U PD=3.32U
* device instance $2678 m90 *1 653.015,790.76 pfet_05v0
M$2678 VDD_DEC \$I2215 \$I3860 VDD_DEC pfet_05v0 L=0.5U W=0.36U AS=0.3852P
+ AD=0.1116P PS=2.86U PD=0.98U
* device instance $2679 m90 *1 651.895,790.76 pfet_05v0
M$2679 \$I3865 \$I3860 VDD_DEC VDD_DEC pfet_05v0 L=0.5U W=0.36U AS=0.1116P
+ AD=0.0612P PS=0.98U PD=0.7U
* device instance $2680 m90 *1 651.055,790.76 pfet_05v0
M$2680 \$I3865 \$I3860 \$I3861 VDD_DEC pfet_05v0 L=0.5U W=0.36U AS=0.3852P
+ AD=0.0612P PS=2.86U PD=0.7U
* device instance $2681 m90 *1 648.725,787.882 nfet_05v0
M$2681 \$I3864 \$I3861 \$I3862 VSS nfet_05v0 L=0.6U W=0.365U AS=0.3705P
+ AD=0.0438P PS=2.77U PD=0.605U
* device instance $2682 m90 *1 647.885,787.882 nfet_05v0
M$2682 VSS \$I3861 \$I3864 VSS nfet_05v0 L=0.6U W=0.365U AS=0.0438P
+ AD=0.282625P PS=0.605U PD=1.87U
* device instance $2683 m90 *1 646.235,788.11 nfet_05v0
M$2683 \$I2177 \$I3862 VSS VSS nfet_05v0 L=0.6U W=0.82U AS=0.282625P AD=0.3608P
+ PS=1.87U PD=2.52U
* device instance $2684 m90 *1 652.965,787.88 nfet_05v0
M$2684 VSS \$I2215 \$I3860 VSS nfet_05v0 L=0.6U W=0.36U AS=0.333P AD=0.0936P
+ PS=2.57U PD=0.88U
* device instance $2685 m90 *1 651.845,787.88 nfet_05v0
M$2685 \$I3863 \$I3860 VSS VSS nfet_05v0 L=0.6U W=0.36U AS=0.0936P AD=0.0432P
+ PS=0.88U PD=0.6U
* device instance $2686 m90 *1 651.005,787.88 nfet_05v0
M$2686 \$I3861 \$I3860 \$I3863 VSS nfet_05v0 L=0.6U W=0.36U AS=0.0432P
+ AD=0.369P PS=0.6U PD=2.77U
* device instance $2687 m90 *1 642.055,822.01 pfet_05v0
M$2687 \$I3873 \$I3868 \$I3869 VDD_DEC pfet_05v0 L=0.5U W=0.36U AS=0.3456P
+ AD=0.0612P PS=2.64U PD=0.7U
* device instance $2688 m90 *1 641.215,822.01 pfet_05v0
M$2688 \$I3873 \$I3868 VDD_DEC VDD_DEC pfet_05v0 L=0.5U W=0.36U AS=0.379P
+ AD=0.0612P PS=2.37U PD=0.7U
* device instance $2689 m90 *1 639.565,821.69 pfet_05v0
M$2689 \$I2337 \$I3869 VDD_DEC VDD_DEC pfet_05v0 L=0.5U W=1.22U AS=0.379P
+ AD=0.5368P PS=2.37U PD=3.32U
* device instance $2690 m90 *1 646.295,822.12 pfet_05v0
M$2690 VDD_DEC \$I2404 \$I3867 VDD_DEC pfet_05v0 L=0.5U W=0.36U AS=0.3852P
+ AD=0.1116P PS=2.86U PD=0.98U
* device instance $2691 m90 *1 645.175,822.12 pfet_05v0
M$2691 \$I3872 \$I3867 VDD_DEC VDD_DEC pfet_05v0 L=0.5U W=0.36U AS=0.1116P
+ AD=0.0612P PS=0.98U PD=0.7U
* device instance $2692 m90 *1 644.335,822.12 pfet_05v0
M$2692 \$I3872 \$I3867 \$I3868 VDD_DEC pfet_05v0 L=0.5U W=0.36U AS=0.3852P
+ AD=0.0612P PS=2.86U PD=0.7U
* device instance $2693 m90 *1 642.005,819.242 nfet_05v0
M$2693 \$I3871 \$I3868 \$I3869 VSS nfet_05v0 L=0.6U W=0.365U AS=0.3705P
+ AD=0.0438P PS=2.77U PD=0.605U
* device instance $2694 m90 *1 641.165,819.242 nfet_05v0
M$2694 VSS \$I3868 \$I3871 VSS nfet_05v0 L=0.6U W=0.365U AS=0.0438P
+ AD=0.282625P PS=0.605U PD=1.87U
* device instance $2695 m90 *1 639.515,819.47 nfet_05v0
M$2695 \$I2337 \$I3869 VSS VSS nfet_05v0 L=0.6U W=0.82U AS=0.282625P AD=0.3608P
+ PS=1.87U PD=2.52U
* device instance $2696 m90 *1 646.245,819.24 nfet_05v0
M$2696 VSS \$I2404 \$I3867 VSS nfet_05v0 L=0.6U W=0.36U AS=0.333P AD=0.0936P
+ PS=2.57U PD=0.88U
* device instance $2697 m90 *1 645.125,819.24 nfet_05v0
M$2697 \$I3870 \$I3867 VSS VSS nfet_05v0 L=0.6U W=0.36U AS=0.0936P AD=0.0432P
+ PS=0.88U PD=0.6U
* device instance $2698 m90 *1 644.285,819.24 nfet_05v0
M$2698 \$I3868 \$I3867 \$I3870 VSS nfet_05v0 L=0.6U W=0.36U AS=0.0432P
+ AD=0.369P PS=0.6U PD=2.77U
* device instance $2699 m90 *1 578.215,814.17 pfet_05v0
M$2699 \$I3880 \$I3875 \$I3876 VDD_DEC pfet_05v0 L=0.5U W=0.36U AS=0.3456P
+ AD=0.0612P PS=2.64U PD=0.7U
* device instance $2700 m90 *1 577.375,814.17 pfet_05v0
M$2700 \$I3880 \$I3875 VDD_DEC VDD_DEC pfet_05v0 L=0.5U W=0.36U AS=0.379P
+ AD=0.0612P PS=2.37U PD=0.7U
* device instance $2701 m90 *1 575.725,813.85 pfet_05v0
M$2701 \$I2170 \$I3876 VDD_DEC VDD_DEC pfet_05v0 L=0.5U W=1.22U AS=0.379P
+ AD=0.5368P PS=2.37U PD=3.32U
* device instance $2702 m90 *1 582.455,814.28 pfet_05v0
M$2702 VDD_DEC \$I2208 \$I3874 VDD_DEC pfet_05v0 L=0.5U W=0.36U AS=0.3852P
+ AD=0.1116P PS=2.86U PD=0.98U
* device instance $2703 m90 *1 581.335,814.28 pfet_05v0
M$2703 \$I3879 \$I3874 VDD_DEC VDD_DEC pfet_05v0 L=0.5U W=0.36U AS=0.1116P
+ AD=0.0612P PS=0.98U PD=0.7U
* device instance $2704 m90 *1 580.495,814.28 pfet_05v0
M$2704 \$I3879 \$I3874 \$I3875 VDD_DEC pfet_05v0 L=0.5U W=0.36U AS=0.3852P
+ AD=0.0612P PS=2.86U PD=0.7U
* device instance $2705 m90 *1 578.165,811.402 nfet_05v0
M$2705 \$I3878 \$I3875 \$I3876 VSS nfet_05v0 L=0.6U W=0.365U AS=0.3705P
+ AD=0.0438P PS=2.77U PD=0.605U
* device instance $2706 m90 *1 577.325,811.402 nfet_05v0
M$2706 VSS \$I3875 \$I3878 VSS nfet_05v0 L=0.6U W=0.365U AS=0.0438P
+ AD=0.282625P PS=0.605U PD=1.87U
* device instance $2707 m90 *1 575.675,811.63 nfet_05v0
M$2707 \$I2170 \$I3876 VSS VSS nfet_05v0 L=0.6U W=0.82U AS=0.282625P AD=0.3608P
+ PS=1.87U PD=2.52U
* device instance $2708 m90 *1 582.405,811.4 nfet_05v0
M$2708 VSS \$I2208 \$I3874 VSS nfet_05v0 L=0.6U W=0.36U AS=0.333P AD=0.0936P
+ PS=2.57U PD=0.88U
* device instance $2709 m90 *1 581.285,811.4 nfet_05v0
M$2709 \$I3877 \$I3874 VSS VSS nfet_05v0 L=0.6U W=0.36U AS=0.0936P AD=0.0432P
+ PS=0.88U PD=0.6U
* device instance $2710 m90 *1 580.445,811.4 nfet_05v0
M$2710 \$I3875 \$I3874 \$I3877 VSS nfet_05v0 L=0.6U W=0.36U AS=0.0432P
+ AD=0.369P PS=0.6U PD=2.77U
* device instance $2711 m90 *1 564.775,822.01 pfet_05v0
M$2711 \$I3887 \$I3882 \$I3883 VDD_DEC pfet_05v0 L=0.5U W=0.36U AS=0.3456P
+ AD=0.0612P PS=2.64U PD=0.7U
* device instance $2712 m90 *1 563.935,822.01 pfet_05v0
M$2712 \$I3887 \$I3882 VDD_DEC VDD_DEC pfet_05v0 L=0.5U W=0.36U AS=0.379P
+ AD=0.0612P PS=2.37U PD=0.7U
* device instance $2713 m90 *1 562.285,821.69 pfet_05v0
M$2713 \$I2358 \$I3883 VDD_DEC VDD_DEC pfet_05v0 L=0.5U W=1.22U AS=0.379P
+ AD=0.5368P PS=2.37U PD=3.32U
* device instance $2714 m90 *1 569.015,822.12 pfet_05v0
M$2714 VDD_DEC \$I2401 \$I3881 VDD_DEC pfet_05v0 L=0.5U W=0.36U AS=0.3852P
+ AD=0.1116P PS=2.86U PD=0.98U
* device instance $2715 m90 *1 567.895,822.12 pfet_05v0
M$2715 \$I3886 \$I3881 VDD_DEC VDD_DEC pfet_05v0 L=0.5U W=0.36U AS=0.1116P
+ AD=0.0612P PS=0.98U PD=0.7U
* device instance $2716 m90 *1 567.055,822.12 pfet_05v0
M$2716 \$I3886 \$I3881 \$I3882 VDD_DEC pfet_05v0 L=0.5U W=0.36U AS=0.3852P
+ AD=0.0612P PS=2.86U PD=0.7U
* device instance $2717 m90 *1 564.725,819.242 nfet_05v0
M$2717 \$I3885 \$I3882 \$I3883 VSS nfet_05v0 L=0.6U W=0.365U AS=0.3705P
+ AD=0.0438P PS=2.77U PD=0.605U
* device instance $2718 m90 *1 563.885,819.242 nfet_05v0
M$2718 VSS \$I3882 \$I3885 VSS nfet_05v0 L=0.6U W=0.365U AS=0.0438P
+ AD=0.282625P PS=0.605U PD=1.87U
* device instance $2719 m90 *1 562.235,819.47 nfet_05v0
M$2719 \$I2358 \$I3883 VSS VSS nfet_05v0 L=0.6U W=0.82U AS=0.282625P AD=0.3608P
+ PS=1.87U PD=2.52U
* device instance $2720 m90 *1 568.965,819.24 nfet_05v0
M$2720 VSS \$I2401 \$I3881 VSS nfet_05v0 L=0.6U W=0.36U AS=0.333P AD=0.0936P
+ PS=2.57U PD=0.88U
* device instance $2721 m90 *1 567.845,819.24 nfet_05v0
M$2721 \$I3884 \$I3881 VSS VSS nfet_05v0 L=0.6U W=0.36U AS=0.0936P AD=0.0432P
+ PS=0.88U PD=0.6U
* device instance $2722 m90 *1 567.005,819.24 nfet_05v0
M$2722 \$I3882 \$I3881 \$I3884 VSS nfet_05v0 L=0.6U W=0.36U AS=0.0432P
+ AD=0.369P PS=0.6U PD=2.77U
* device instance $2723 m90 *1 579.335,782.81 pfet_05v0
M$2723 \$I3894 \$I3889 \$I3890 VDD_DEC pfet_05v0 L=0.5U W=0.36U AS=0.3456P
+ AD=0.0612P PS=2.64U PD=0.7U
* device instance $2724 m90 *1 578.495,782.81 pfet_05v0
M$2724 \$I3894 \$I3889 VDD_DEC VDD_DEC pfet_05v0 L=0.5U W=0.36U AS=0.379P
+ AD=0.0612P PS=2.37U PD=0.7U
* device instance $2725 m90 *1 576.845,782.49 pfet_05v0
M$2725 \$84 \$I3890 VDD_DEC VDD_DEC pfet_05v0 L=0.5U W=1.22U AS=0.379P
+ AD=0.5368P PS=2.37U PD=3.32U
* device instance $2726 m90 *1 583.575,782.92 pfet_05v0
M$2726 VDD_DEC \$I2067 \$I3888 VDD_DEC pfet_05v0 L=0.5U W=0.36U AS=0.3852P
+ AD=0.1116P PS=2.86U PD=0.98U
* device instance $2727 m90 *1 582.455,782.92 pfet_05v0
M$2727 \$I3893 \$I3888 VDD_DEC VDD_DEC pfet_05v0 L=0.5U W=0.36U AS=0.1116P
+ AD=0.0612P PS=0.98U PD=0.7U
* device instance $2728 m90 *1 581.615,782.92 pfet_05v0
M$2728 \$I3893 \$I3888 \$I3889 VDD_DEC pfet_05v0 L=0.5U W=0.36U AS=0.3852P
+ AD=0.0612P PS=2.86U PD=0.7U
* device instance $2729 m90 *1 579.285,780.042 nfet_05v0
M$2729 \$I3892 \$I3889 \$I3890 VSS nfet_05v0 L=0.6U W=0.365U AS=0.3705P
+ AD=0.0438P PS=2.77U PD=0.605U
* device instance $2730 m90 *1 578.445,780.042 nfet_05v0
M$2730 VSS \$I3889 \$I3892 VSS nfet_05v0 L=0.6U W=0.365U AS=0.0438P
+ AD=0.282625P PS=0.605U PD=1.87U
* device instance $2731 m90 *1 576.795,780.27 nfet_05v0
M$2731 \$84 \$I3890 VSS VSS nfet_05v0 L=0.6U W=0.82U AS=0.282625P AD=0.3608P
+ PS=1.87U PD=2.52U
* device instance $2732 m90 *1 583.525,780.04 nfet_05v0
M$2732 VSS \$I2067 \$I3888 VSS nfet_05v0 L=0.6U W=0.36U AS=0.333P AD=0.0936P
+ PS=2.57U PD=0.88U
* device instance $2733 m90 *1 582.405,780.04 nfet_05v0
M$2733 \$I3891 \$I3888 VSS VSS nfet_05v0 L=0.6U W=0.36U AS=0.0936P AD=0.0432P
+ PS=0.88U PD=0.6U
* device instance $2734 m90 *1 581.565,780.04 nfet_05v0
M$2734 \$I3889 \$I3888 \$I3891 VSS nfet_05v0 L=0.6U W=0.36U AS=0.0432P
+ AD=0.369P PS=0.6U PD=2.77U
* device instance $2735 m90 *1 527.815,814.17 pfet_05v0
M$2735 \$I3901 \$I3896 \$I3897 VDD_DEC pfet_05v0 L=0.5U W=0.36U AS=0.3456P
+ AD=0.0612P PS=2.64U PD=0.7U
* device instance $2736 m90 *1 526.975,814.17 pfet_05v0
M$2736 \$I3901 \$I3896 VDD_DEC VDD_DEC pfet_05v0 L=0.5U W=0.36U AS=0.379P
+ AD=0.0612P PS=2.37U PD=0.7U
* device instance $2737 m90 *1 525.325,813.85 pfet_05v0
M$2737 \$I2249 \$I3897 VDD_DEC VDD_DEC pfet_05v0 L=0.5U W=1.22U AS=0.379P
+ AD=0.5368P PS=2.37U PD=3.32U
* device instance $2738 m90 *1 532.055,814.28 pfet_05v0
M$2738 VDD_DEC \$I2358 \$I3895 VDD_DEC pfet_05v0 L=0.5U W=0.36U AS=0.3852P
+ AD=0.1116P PS=2.86U PD=0.98U
* device instance $2739 m90 *1 530.935,814.28 pfet_05v0
M$2739 \$I3900 \$I3895 VDD_DEC VDD_DEC pfet_05v0 L=0.5U W=0.36U AS=0.1116P
+ AD=0.0612P PS=0.98U PD=0.7U
* device instance $2740 m90 *1 530.095,814.28 pfet_05v0
M$2740 \$I3900 \$I3895 \$I3896 VDD_DEC pfet_05v0 L=0.5U W=0.36U AS=0.3852P
+ AD=0.0612P PS=2.86U PD=0.7U
* device instance $2741 m90 *1 527.765,811.402 nfet_05v0
M$2741 \$I3899 \$I3896 \$I3897 VSS nfet_05v0 L=0.6U W=0.365U AS=0.3705P
+ AD=0.0438P PS=2.77U PD=0.605U
* device instance $2742 m90 *1 526.925,811.402 nfet_05v0
M$2742 VSS \$I3896 \$I3899 VSS nfet_05v0 L=0.6U W=0.365U AS=0.0438P
+ AD=0.282625P PS=0.605U PD=1.87U
* device instance $2743 m90 *1 525.275,811.63 nfet_05v0
M$2743 \$I2249 \$I3897 VSS VSS nfet_05v0 L=0.6U W=0.82U AS=0.282625P AD=0.3608P
+ PS=1.87U PD=2.52U
* device instance $2744 m90 *1 532.005,811.4 nfet_05v0
M$2744 VSS \$I2358 \$I3895 VSS nfet_05v0 L=0.6U W=0.36U AS=0.333P AD=0.0936P
+ PS=2.57U PD=0.88U
* device instance $2745 m90 *1 530.885,811.4 nfet_05v0
M$2745 \$I3898 \$I3895 VSS VSS nfet_05v0 L=0.6U W=0.36U AS=0.0936P AD=0.0432P
+ PS=0.88U PD=0.6U
* device instance $2746 m90 *1 530.045,811.4 nfet_05v0
M$2746 \$I3896 \$I3895 \$I3898 VSS nfet_05v0 L=0.6U W=0.36U AS=0.0432P
+ AD=0.369P PS=0.6U PD=2.77U
* device instance $2747 m90 *1 651.015,814.17 pfet_05v0
M$2747 \$I3908 \$I3903 \$I3904 VDD_DEC pfet_05v0 L=0.5U W=0.36U AS=0.3456P
+ AD=0.0612P PS=2.64U PD=0.7U
* device instance $2748 m90 *1 650.175,814.17 pfet_05v0
M$2748 \$I3908 \$I3903 VDD_DEC VDD_DEC pfet_05v0 L=0.5U W=0.36U AS=0.379P
+ AD=0.0612P PS=2.37U PD=0.7U
* device instance $2749 m90 *1 648.525,813.85 pfet_05v0
M$2749 \$I2237 \$I3904 VDD_DEC VDD_DEC pfet_05v0 L=0.5U W=1.22U AS=0.379P
+ AD=0.5368P PS=2.37U PD=3.32U
* device instance $2750 m90 *1 655.255,814.28 pfet_05v0
M$2750 VDD_DEC \$I2342 \$I3902 VDD_DEC pfet_05v0 L=0.5U W=0.36U AS=0.3852P
+ AD=0.1116P PS=2.86U PD=0.98U
* device instance $2751 m90 *1 654.135,814.28 pfet_05v0
M$2751 \$I3907 \$I3902 VDD_DEC VDD_DEC pfet_05v0 L=0.5U W=0.36U AS=0.1116P
+ AD=0.0612P PS=0.98U PD=0.7U
* device instance $2752 m90 *1 653.295,814.28 pfet_05v0
M$2752 \$I3907 \$I3902 \$I3903 VDD_DEC pfet_05v0 L=0.5U W=0.36U AS=0.3852P
+ AD=0.0612P PS=2.86U PD=0.7U
* device instance $2753 m90 *1 650.965,811.402 nfet_05v0
M$2753 \$I3906 \$I3903 \$I3904 VSS nfet_05v0 L=0.6U W=0.365U AS=0.3705P
+ AD=0.0438P PS=2.77U PD=0.605U
* device instance $2754 m90 *1 650.125,811.402 nfet_05v0
M$2754 VSS \$I3903 \$I3906 VSS nfet_05v0 L=0.6U W=0.365U AS=0.0438P
+ AD=0.282625P PS=0.605U PD=1.87U
* device instance $2755 m90 *1 648.475,811.63 nfet_05v0
M$2755 \$I2237 \$I3904 VSS VSS nfet_05v0 L=0.6U W=0.82U AS=0.282625P AD=0.3608P
+ PS=1.87U PD=2.52U
* device instance $2756 m90 *1 655.205,811.4 nfet_05v0
M$2756 VSS \$I2342 \$I3902 VSS nfet_05v0 L=0.6U W=0.36U AS=0.333P AD=0.0936P
+ PS=2.57U PD=0.88U
* device instance $2757 m90 *1 654.085,811.4 nfet_05v0
M$2757 \$I3905 \$I3902 VSS VSS nfet_05v0 L=0.6U W=0.36U AS=0.0936P AD=0.0432P
+ PS=0.88U PD=0.6U
* device instance $2758 m90 *1 653.245,811.4 nfet_05v0
M$2758 \$I3903 \$I3902 \$I3905 VSS nfet_05v0 L=0.6U W=0.36U AS=0.0432P
+ AD=0.369P PS=0.6U PD=2.77U
* device instance $2759 m90 *1 555.815,822.01 pfet_05v0
M$2759 \$I3915 \$I3910 \$I3911 VDD_DEC pfet_05v0 L=0.5U W=0.36U AS=0.3456P
+ AD=0.0612P PS=2.64U PD=0.7U
* device instance $2760 m90 *1 554.975,822.01 pfet_05v0
M$2760 \$I3915 \$I3910 VDD_DEC VDD_DEC pfet_05v0 L=0.5U W=0.36U AS=0.379P
+ AD=0.0612P PS=2.37U PD=0.7U
* device instance $2761 m90 *1 553.325,821.69 pfet_05v0
M$2761 \$I2333 \$I3911 VDD_DEC VDD_DEC pfet_05v0 L=0.5U W=1.22U AS=0.379P
+ AD=0.5368P PS=2.37U PD=3.32U
* device instance $2762 m90 *1 560.055,822.12 pfet_05v0
M$2762 VDD_DEC \$I2358 \$I3909 VDD_DEC pfet_05v0 L=0.5U W=0.36U AS=0.3852P
+ AD=0.1116P PS=2.86U PD=0.98U
* device instance $2763 m90 *1 558.935,822.12 pfet_05v0
M$2763 \$I3914 \$I3909 VDD_DEC VDD_DEC pfet_05v0 L=0.5U W=0.36U AS=0.1116P
+ AD=0.0612P PS=0.98U PD=0.7U
* device instance $2764 m90 *1 558.095,822.12 pfet_05v0
M$2764 \$I3914 \$I3909 \$I3910 VDD_DEC pfet_05v0 L=0.5U W=0.36U AS=0.3852P
+ AD=0.0612P PS=2.86U PD=0.7U
* device instance $2765 m90 *1 555.765,819.242 nfet_05v0
M$2765 \$I3913 \$I3910 \$I3911 VSS nfet_05v0 L=0.6U W=0.365U AS=0.3705P
+ AD=0.0438P PS=2.77U PD=0.605U
* device instance $2766 m90 *1 554.925,819.242 nfet_05v0
M$2766 VSS \$I3910 \$I3913 VSS nfet_05v0 L=0.6U W=0.365U AS=0.0438P
+ AD=0.282625P PS=0.605U PD=1.87U
* device instance $2767 m90 *1 553.275,819.47 nfet_05v0
M$2767 \$I2333 \$I3911 VSS VSS nfet_05v0 L=0.6U W=0.82U AS=0.282625P AD=0.3608P
+ PS=1.87U PD=2.52U
* device instance $2768 m90 *1 560.005,819.24 nfet_05v0
M$2768 VSS \$I2358 \$I3909 VSS nfet_05v0 L=0.6U W=0.36U AS=0.333P AD=0.0936P
+ PS=2.57U PD=0.88U
* device instance $2769 m90 *1 558.885,819.24 nfet_05v0
M$2769 \$I3912 \$I3909 VSS VSS nfet_05v0 L=0.6U W=0.36U AS=0.0936P AD=0.0432P
+ PS=0.88U PD=0.6U
* device instance $2770 m90 *1 558.045,819.24 nfet_05v0
M$2770 \$I3910 \$I3909 \$I3912 VSS nfet_05v0 L=0.6U W=0.36U AS=0.0432P
+ AD=0.369P PS=0.6U PD=2.77U
* device instance $2771 m90 *1 602.295,814.17 pfet_05v0
M$2771 \$I3922 \$I3917 \$I3918 VDD_DEC pfet_05v0 L=0.5U W=0.36U AS=0.3456P
+ AD=0.0612P PS=2.64U PD=0.7U
* device instance $2772 m90 *1 601.455,814.17 pfet_05v0
M$2772 \$I3922 \$I3917 VDD_DEC VDD_DEC pfet_05v0 L=0.5U W=0.36U AS=0.379P
+ AD=0.0612P PS=2.37U PD=0.7U
* device instance $2773 m90 *1 599.805,813.85 pfet_05v0
M$2773 \$I2252 \$I3918 VDD_DEC VDD_DEC pfet_05v0 L=0.5U W=1.22U AS=0.379P
+ AD=0.5368P PS=2.37U PD=3.32U
* device instance $2774 m90 *1 606.535,814.28 pfet_05v0
M$2774 VDD_DEC \$I2338 \$I3916 VDD_DEC pfet_05v0 L=0.5U W=0.36U AS=0.3852P
+ AD=0.1116P PS=2.86U PD=0.98U
* device instance $2775 m90 *1 605.415,814.28 pfet_05v0
M$2775 \$I3921 \$I3916 VDD_DEC VDD_DEC pfet_05v0 L=0.5U W=0.36U AS=0.1116P
+ AD=0.0612P PS=0.98U PD=0.7U
* device instance $2776 m90 *1 604.575,814.28 pfet_05v0
M$2776 \$I3921 \$I3916 \$I3917 VDD_DEC pfet_05v0 L=0.5U W=0.36U AS=0.3852P
+ AD=0.0612P PS=2.86U PD=0.7U
* device instance $2777 m90 *1 602.245,811.402 nfet_05v0
M$2777 \$I3920 \$I3917 \$I3918 VSS nfet_05v0 L=0.6U W=0.365U AS=0.3705P
+ AD=0.0438P PS=2.77U PD=0.605U
* device instance $2778 m90 *1 601.405,811.402 nfet_05v0
M$2778 VSS \$I3917 \$I3920 VSS nfet_05v0 L=0.6U W=0.365U AS=0.0438P
+ AD=0.282625P PS=0.605U PD=1.87U
* device instance $2779 m90 *1 599.755,811.63 nfet_05v0
M$2779 \$I2252 \$I3918 VSS VSS nfet_05v0 L=0.6U W=0.82U AS=0.282625P AD=0.3608P
+ PS=1.87U PD=2.52U
* device instance $2780 m90 *1 606.485,811.4 nfet_05v0
M$2780 VSS \$I2338 \$I3916 VSS nfet_05v0 L=0.6U W=0.36U AS=0.333P AD=0.0936P
+ PS=2.57U PD=0.88U
* device instance $2781 m90 *1 605.365,811.4 nfet_05v0
M$2781 \$I3919 \$I3916 VSS VSS nfet_05v0 L=0.6U W=0.36U AS=0.0936P AD=0.0432P
+ PS=0.88U PD=0.6U
* device instance $2782 m90 *1 604.525,811.4 nfet_05v0
M$2782 \$I3917 \$I3916 \$I3919 VSS nfet_05v0 L=0.6U W=0.36U AS=0.0432P
+ AD=0.369P PS=0.6U PD=2.77U
* device instance $2783 m90 *1 532.855,790.65 pfet_05v0
M$2783 \$I3929 \$I3924 \$I3925 VDD_DEC pfet_05v0 L=0.5U W=0.36U AS=0.3456P
+ AD=0.0612P PS=2.64U PD=0.7U
* device instance $2784 m90 *1 532.015,790.65 pfet_05v0
M$2784 \$I3929 \$I3924 VDD_DEC VDD_DEC pfet_05v0 L=0.5U W=0.36U AS=0.379P
+ AD=0.0612P PS=2.37U PD=0.7U
* device instance $2785 m90 *1 530.365,790.33 pfet_05v0
M$2785 \$I2200 \$I3925 VDD_DEC VDD_DEC pfet_05v0 L=0.5U W=1.22U AS=0.379P
+ AD=0.5368P PS=2.37U PD=3.32U
* device instance $2786 m90 *1 537.095,790.76 pfet_05v0
M$2786 VDD_DEC \$I2332 \$I3923 VDD_DEC pfet_05v0 L=0.5U W=0.36U AS=0.3852P
+ AD=0.1116P PS=2.86U PD=0.98U
* device instance $2787 m90 *1 535.975,790.76 pfet_05v0
M$2787 \$I3928 \$I3923 VDD_DEC VDD_DEC pfet_05v0 L=0.5U W=0.36U AS=0.1116P
+ AD=0.0612P PS=0.98U PD=0.7U
* device instance $2788 m90 *1 535.135,790.76 pfet_05v0
M$2788 \$I3928 \$I3923 \$I3924 VDD_DEC pfet_05v0 L=0.5U W=0.36U AS=0.3852P
+ AD=0.0612P PS=2.86U PD=0.7U
* device instance $2789 m90 *1 532.805,787.882 nfet_05v0
M$2789 \$I3927 \$I3924 \$I3925 VSS nfet_05v0 L=0.6U W=0.365U AS=0.3705P
+ AD=0.0438P PS=2.77U PD=0.605U
* device instance $2790 m90 *1 531.965,787.882 nfet_05v0
M$2790 VSS \$I3924 \$I3927 VSS nfet_05v0 L=0.6U W=0.365U AS=0.0438P
+ AD=0.282625P PS=0.605U PD=1.87U
* device instance $2791 m90 *1 530.315,788.11 nfet_05v0
M$2791 \$I2200 \$I3925 VSS VSS nfet_05v0 L=0.6U W=0.82U AS=0.282625P AD=0.3608P
+ PS=1.87U PD=2.52U
* device instance $2792 m90 *1 537.045,787.88 nfet_05v0
M$2792 VSS \$I2332 \$I3923 VSS nfet_05v0 L=0.6U W=0.36U AS=0.333P AD=0.0936P
+ PS=2.57U PD=0.88U
* device instance $2793 m90 *1 535.925,787.88 nfet_05v0
M$2793 \$I3926 \$I3923 VSS VSS nfet_05v0 L=0.6U W=0.36U AS=0.0936P AD=0.0432P
+ PS=0.88U PD=0.6U
* device instance $2794 m90 *1 535.085,787.88 nfet_05v0
M$2794 \$I3924 \$I3923 \$I3926 VSS nfet_05v0 L=0.6U W=0.36U AS=0.0432P
+ AD=0.369P PS=0.6U PD=2.77U
* device instance $2795 m90 *1 642.055,814.17 pfet_05v0
M$2795 \$I3936 \$I3931 \$I3932 VDD_DEC pfet_05v0 L=0.5U W=0.36U AS=0.3456P
+ AD=0.0612P PS=2.64U PD=0.7U
* device instance $2796 m90 *1 641.215,814.17 pfet_05v0
M$2796 \$I3936 \$I3931 VDD_DEC VDD_DEC pfet_05v0 L=0.5U W=0.36U AS=0.379P
+ AD=0.0612P PS=2.37U PD=0.7U
* device instance $2797 m90 *1 639.565,813.85 pfet_05v0
M$2797 \$I2311 \$I3932 VDD_DEC VDD_DEC pfet_05v0 L=0.5U W=1.22U AS=0.379P
+ AD=0.5368P PS=2.37U PD=3.32U
* device instance $2798 m90 *1 646.295,814.28 pfet_05v0
M$2798 VDD_DEC \$I2337 \$I3930 VDD_DEC pfet_05v0 L=0.5U W=0.36U AS=0.3852P
+ AD=0.1116P PS=2.86U PD=0.98U
* device instance $2799 m90 *1 645.175,814.28 pfet_05v0
M$2799 \$I3935 \$I3930 VDD_DEC VDD_DEC pfet_05v0 L=0.5U W=0.36U AS=0.1116P
+ AD=0.0612P PS=0.98U PD=0.7U
* device instance $2800 m90 *1 644.335,814.28 pfet_05v0
M$2800 \$I3935 \$I3930 \$I3931 VDD_DEC pfet_05v0 L=0.5U W=0.36U AS=0.3852P
+ AD=0.0612P PS=2.86U PD=0.7U
* device instance $2801 m90 *1 642.005,811.402 nfet_05v0
M$2801 \$I3934 \$I3931 \$I3932 VSS nfet_05v0 L=0.6U W=0.365U AS=0.3705P
+ AD=0.0438P PS=2.77U PD=0.605U
* device instance $2802 m90 *1 641.165,811.402 nfet_05v0
M$2802 VSS \$I3931 \$I3934 VSS nfet_05v0 L=0.6U W=0.365U AS=0.0438P
+ AD=0.282625P PS=0.605U PD=1.87U
* device instance $2803 m90 *1 639.515,811.63 nfet_05v0
M$2803 \$I2311 \$I3932 VSS VSS nfet_05v0 L=0.6U W=0.82U AS=0.282625P AD=0.3608P
+ PS=1.87U PD=2.52U
* device instance $2804 m90 *1 646.245,811.4 nfet_05v0
M$2804 VSS \$I2337 \$I3930 VSS nfet_05v0 L=0.6U W=0.36U AS=0.333P AD=0.0936P
+ PS=2.57U PD=0.88U
* device instance $2805 m90 *1 645.125,811.4 nfet_05v0
M$2805 \$I3933 \$I3930 VSS VSS nfet_05v0 L=0.6U W=0.36U AS=0.0936P AD=0.0432P
+ PS=0.88U PD=0.6U
* device instance $2806 m90 *1 644.285,811.4 nfet_05v0
M$2806 \$I3931 \$I3930 \$I3933 VSS nfet_05v0 L=0.6U W=0.36U AS=0.0432P
+ AD=0.369P PS=0.6U PD=2.77U
* device instance $2807 m90 *1 604.535,822.01 pfet_05v0
M$2807 \$I3943 \$I3938 \$I3939 VDD_DEC pfet_05v0 L=0.5U W=0.36U AS=0.3456P
+ AD=0.0612P PS=2.64U PD=0.7U
* device instance $2808 m90 *1 603.695,822.01 pfet_05v0
M$2808 \$I3943 \$I3938 VDD_DEC VDD_DEC pfet_05v0 L=0.5U W=0.36U AS=0.379P
+ AD=0.0612P PS=2.37U PD=0.7U
* device instance $2809 m90 *1 602.045,821.69 pfet_05v0
M$2809 \$I2338 \$I3939 VDD_DEC VDD_DEC pfet_05v0 L=0.5U W=1.22U AS=0.379P
+ AD=0.5368P PS=2.37U PD=3.32U
* device instance $2810 m90 *1 608.775,822.12 pfet_05v0
M$2810 VDD_DEC \$I2176 \$I3937 VDD_DEC pfet_05v0 L=0.5U W=0.36U AS=0.3852P
+ AD=0.1116P PS=2.86U PD=0.98U
* device instance $2811 m90 *1 607.655,822.12 pfet_05v0
M$2811 \$I3942 \$I3937 VDD_DEC VDD_DEC pfet_05v0 L=0.5U W=0.36U AS=0.1116P
+ AD=0.0612P PS=0.98U PD=0.7U
* device instance $2812 m90 *1 606.815,822.12 pfet_05v0
M$2812 \$I3942 \$I3937 \$I3938 VDD_DEC pfet_05v0 L=0.5U W=0.36U AS=0.3852P
+ AD=0.0612P PS=2.86U PD=0.7U
* device instance $2813 m90 *1 604.485,819.242 nfet_05v0
M$2813 \$I3941 \$I3938 \$I3939 VSS nfet_05v0 L=0.6U W=0.365U AS=0.3705P
+ AD=0.0438P PS=2.77U PD=0.605U
* device instance $2814 m90 *1 603.645,819.242 nfet_05v0
M$2814 VSS \$I3938 \$I3941 VSS nfet_05v0 L=0.6U W=0.365U AS=0.0438P
+ AD=0.282625P PS=0.605U PD=1.87U
* device instance $2815 m90 *1 601.995,819.47 nfet_05v0
M$2815 \$I2338 \$I3939 VSS VSS nfet_05v0 L=0.6U W=0.82U AS=0.282625P AD=0.3608P
+ PS=1.87U PD=2.52U
* device instance $2816 m90 *1 608.725,819.24 nfet_05v0
M$2816 VSS \$I2176 \$I3937 VSS nfet_05v0 L=0.6U W=0.36U AS=0.333P AD=0.0936P
+ PS=2.57U PD=0.88U
* device instance $2817 m90 *1 607.605,819.24 nfet_05v0
M$2817 \$I3940 \$I3937 VSS VSS nfet_05v0 L=0.6U W=0.36U AS=0.0936P AD=0.0432P
+ PS=0.88U PD=0.6U
* device instance $2818 m90 *1 606.765,819.24 nfet_05v0
M$2818 \$I3938 \$I3937 \$I3940 VSS nfet_05v0 L=0.6U W=0.36U AS=0.0432P
+ AD=0.369P PS=0.6U PD=2.77U
* device instance $2819 m90 *1 563.655,814.17 pfet_05v0
M$2819 \$I3950 \$I3945 \$I3946 VDD_DEC pfet_05v0 L=0.5U W=0.36U AS=0.3456P
+ AD=0.0612P PS=2.64U PD=0.7U
* device instance $2820 m90 *1 562.815,814.17 pfet_05v0
M$2820 \$I3950 \$I3945 VDD_DEC VDD_DEC pfet_05v0 L=0.5U W=0.36U AS=0.379P
+ AD=0.0612P PS=2.37U PD=0.7U
* device instance $2821 m90 *1 561.165,813.85 pfet_05v0
M$2821 \$I2203 \$I3946 VDD_DEC VDD_DEC pfet_05v0 L=0.5U W=1.22U AS=0.379P
+ AD=0.5368P PS=2.37U PD=3.32U
* device instance $2822 m90 *1 567.895,814.28 pfet_05v0
M$2822 VDD_DEC \$I2207 \$I3944 VDD_DEC pfet_05v0 L=0.5U W=0.36U AS=0.3852P
+ AD=0.1116P PS=2.86U PD=0.98U
* device instance $2823 m90 *1 566.775,814.28 pfet_05v0
M$2823 \$I3949 \$I3944 VDD_DEC VDD_DEC pfet_05v0 L=0.5U W=0.36U AS=0.1116P
+ AD=0.0612P PS=0.98U PD=0.7U
* device instance $2824 m90 *1 565.935,814.28 pfet_05v0
M$2824 \$I3949 \$I3944 \$I3945 VDD_DEC pfet_05v0 L=0.5U W=0.36U AS=0.3852P
+ AD=0.0612P PS=2.86U PD=0.7U
* device instance $2825 m90 *1 563.605,811.402 nfet_05v0
M$2825 \$I3948 \$I3945 \$I3946 VSS nfet_05v0 L=0.6U W=0.365U AS=0.3705P
+ AD=0.0438P PS=2.77U PD=0.605U
* device instance $2826 m90 *1 562.765,811.402 nfet_05v0
M$2826 VSS \$I3945 \$I3948 VSS nfet_05v0 L=0.6U W=0.365U AS=0.0438P
+ AD=0.282625P PS=0.605U PD=1.87U
* device instance $2827 m90 *1 561.115,811.63 nfet_05v0
M$2827 \$I2203 \$I3946 VSS VSS nfet_05v0 L=0.6U W=0.82U AS=0.282625P AD=0.3608P
+ PS=1.87U PD=2.52U
* device instance $2828 m90 *1 567.845,811.4 nfet_05v0
M$2828 VSS \$I2207 \$I3944 VSS nfet_05v0 L=0.6U W=0.36U AS=0.333P AD=0.0936P
+ PS=2.57U PD=0.88U
* device instance $2829 m90 *1 566.725,811.4 nfet_05v0
M$2829 \$I3947 \$I3944 VSS VSS nfet_05v0 L=0.6U W=0.36U AS=0.0936P AD=0.0432P
+ PS=0.88U PD=0.6U
* device instance $2830 m90 *1 565.885,811.4 nfet_05v0
M$2830 \$I3945 \$I3944 \$I3947 VSS nfet_05v0 L=0.6U W=0.36U AS=0.0432P
+ AD=0.369P PS=0.6U PD=2.77U
* device instance $2831 m90 *1 555.255,798.49 pfet_05v0
M$2831 \$I3957 \$I3952 \$I3953 VDD_DEC pfet_05v0 L=0.5U W=0.36U AS=0.3456P
+ AD=0.0612P PS=2.64U PD=0.7U
* device instance $2832 m90 *1 554.415,798.49 pfet_05v0
M$2832 \$I3957 \$I3952 VDD_DEC VDD_DEC pfet_05v0 L=0.5U W=0.36U AS=0.379P
+ AD=0.0612P PS=2.37U PD=0.7U
* device instance $2833 m90 *1 552.765,798.17 pfet_05v0
M$2833 \$I2359 \$I3953 VDD_DEC VDD_DEC pfet_05v0 L=0.5U W=1.22U AS=0.379P
+ AD=0.5368P PS=2.37U PD=3.32U
* device instance $2834 m90 *1 559.495,798.6 pfet_05v0
M$2834 VDD_DEC \$I2204 \$I3951 VDD_DEC pfet_05v0 L=0.5U W=0.36U AS=0.3852P
+ AD=0.1116P PS=2.86U PD=0.98U
* device instance $2835 m90 *1 558.375,798.6 pfet_05v0
M$2835 \$I3956 \$I3951 VDD_DEC VDD_DEC pfet_05v0 L=0.5U W=0.36U AS=0.1116P
+ AD=0.0612P PS=0.98U PD=0.7U
* device instance $2836 m90 *1 557.535,798.6 pfet_05v0
M$2836 \$I3956 \$I3951 \$I3952 VDD_DEC pfet_05v0 L=0.5U W=0.36U AS=0.3852P
+ AD=0.0612P PS=2.86U PD=0.7U
* device instance $2837 m90 *1 555.205,795.722 nfet_05v0
M$2837 \$I3955 \$I3952 \$I3953 VSS nfet_05v0 L=0.6U W=0.365U AS=0.3705P
+ AD=0.0438P PS=2.77U PD=0.605U
* device instance $2838 m90 *1 554.365,795.722 nfet_05v0
M$2838 VSS \$I3952 \$I3955 VSS nfet_05v0 L=0.6U W=0.365U AS=0.0438P
+ AD=0.282625P PS=0.605U PD=1.87U
* device instance $2839 m90 *1 552.715,795.95 nfet_05v0
M$2839 \$I2359 \$I3953 VSS VSS nfet_05v0 L=0.6U W=0.82U AS=0.282625P AD=0.3608P
+ PS=1.87U PD=2.52U
* device instance $2840 m90 *1 559.445,795.72 nfet_05v0
M$2840 VSS \$I2204 \$I3951 VSS nfet_05v0 L=0.6U W=0.36U AS=0.333P AD=0.0936P
+ PS=2.57U PD=0.88U
* device instance $2841 m90 *1 558.325,795.72 nfet_05v0
M$2841 \$I3954 \$I3951 VSS VSS nfet_05v0 L=0.6U W=0.36U AS=0.0936P AD=0.0432P
+ PS=0.88U PD=0.6U
* device instance $2842 m90 *1 557.485,795.72 nfet_05v0
M$2842 \$I3952 \$I3951 \$I3954 VSS nfet_05v0 L=0.6U W=0.36U AS=0.0432P
+ AD=0.369P PS=0.6U PD=2.77U
* device instance $2843 m90 *1 561.415,790.65 pfet_05v0
M$2843 \$I3964 \$I3959 \$I3960 VDD_DEC pfet_05v0 L=0.5U W=0.36U AS=0.3456P
+ AD=0.0612P PS=2.64U PD=0.7U
* device instance $2844 m90 *1 560.575,790.65 pfet_05v0
M$2844 \$I3964 \$I3959 VDD_DEC VDD_DEC pfet_05v0 L=0.5U W=0.36U AS=0.379P
+ AD=0.0612P PS=2.37U PD=0.7U
* device instance $2845 m90 *1 558.925,790.33 pfet_05v0
M$2845 \$153 \$I3960 VDD_DEC VDD_DEC pfet_05v0 L=0.5U W=1.22U AS=0.379P
+ AD=0.5368P PS=2.37U PD=3.32U
* device instance $2846 m90 *1 565.655,790.76 pfet_05v0
M$2846 VDD_DEC \$I2164 \$I3958 VDD_DEC pfet_05v0 L=0.5U W=0.36U AS=0.3852P
+ AD=0.1116P PS=2.86U PD=0.98U
* device instance $2847 m90 *1 564.535,790.76 pfet_05v0
M$2847 \$I3963 \$I3958 VDD_DEC VDD_DEC pfet_05v0 L=0.5U W=0.36U AS=0.1116P
+ AD=0.0612P PS=0.98U PD=0.7U
* device instance $2848 m90 *1 563.695,790.76 pfet_05v0
M$2848 \$I3963 \$I3958 \$I3959 VDD_DEC pfet_05v0 L=0.5U W=0.36U AS=0.3852P
+ AD=0.0612P PS=2.86U PD=0.7U
* device instance $2849 m90 *1 561.365,787.882 nfet_05v0
M$2849 \$I3962 \$I3959 \$I3960 VSS nfet_05v0 L=0.6U W=0.365U AS=0.3705P
+ AD=0.0438P PS=2.77U PD=0.605U
* device instance $2850 m90 *1 560.525,787.882 nfet_05v0
M$2850 VSS \$I3959 \$I3962 VSS nfet_05v0 L=0.6U W=0.365U AS=0.0438P
+ AD=0.282625P PS=0.605U PD=1.87U
* device instance $2851 m90 *1 558.875,788.11 nfet_05v0
M$2851 \$153 \$I3960 VSS VSS nfet_05v0 L=0.6U W=0.82U AS=0.282625P AD=0.3608P
+ PS=1.87U PD=2.52U
* device instance $2852 m90 *1 565.605,787.88 nfet_05v0
M$2852 VSS \$I2164 \$I3958 VSS nfet_05v0 L=0.6U W=0.36U AS=0.333P AD=0.0936P
+ PS=2.57U PD=0.88U
* device instance $2853 m90 *1 564.485,787.88 nfet_05v0
M$2853 \$I3961 \$I3958 VSS VSS nfet_05v0 L=0.6U W=0.36U AS=0.0936P AD=0.0432P
+ PS=0.88U PD=0.6U
* device instance $2854 m90 *1 563.645,787.88 nfet_05v0
M$2854 \$I3959 \$I3958 \$I3961 VSS nfet_05v0 L=0.6U W=0.36U AS=0.0432P
+ AD=0.369P PS=0.6U PD=2.77U
* device instance $2855 m90 *1 637.575,806.33 pfet_05v0
M$2855 \$I3971 \$I3966 \$I3967 VDD_DEC pfet_05v0 L=0.5U W=0.36U AS=0.3456P
+ AD=0.0612P PS=2.64U PD=0.7U
* device instance $2856 m90 *1 636.735,806.33 pfet_05v0
M$2856 \$I3971 \$I3966 VDD_DEC VDD_DEC pfet_05v0 L=0.5U W=0.36U AS=0.379P
+ AD=0.0612P PS=2.37U PD=0.7U
* device instance $2857 m90 *1 635.085,806.01 pfet_05v0
M$2857 \$I2241 \$I3967 VDD_DEC VDD_DEC pfet_05v0 L=0.5U W=1.22U AS=0.379P
+ AD=0.5368P PS=2.37U PD=3.32U
* device instance $2858 m90 *1 641.815,806.44 pfet_05v0
M$2858 VDD_DEC \$I2311 \$I3965 VDD_DEC pfet_05v0 L=0.5U W=0.36U AS=0.3852P
+ AD=0.1116P PS=2.86U PD=0.98U
* device instance $2859 m90 *1 640.695,806.44 pfet_05v0
M$2859 \$I3970 \$I3965 VDD_DEC VDD_DEC pfet_05v0 L=0.5U W=0.36U AS=0.1116P
+ AD=0.0612P PS=0.98U PD=0.7U
* device instance $2860 m90 *1 639.855,806.44 pfet_05v0
M$2860 \$I3970 \$I3965 \$I3966 VDD_DEC pfet_05v0 L=0.5U W=0.36U AS=0.3852P
+ AD=0.0612P PS=2.86U PD=0.7U
* device instance $2861 m90 *1 637.525,803.562 nfet_05v0
M$2861 \$I3969 \$I3966 \$I3967 VSS nfet_05v0 L=0.6U W=0.365U AS=0.3705P
+ AD=0.0438P PS=2.77U PD=0.605U
* device instance $2862 m90 *1 636.685,803.562 nfet_05v0
M$2862 VSS \$I3966 \$I3969 VSS nfet_05v0 L=0.6U W=0.365U AS=0.0438P
+ AD=0.282625P PS=0.605U PD=1.87U
* device instance $2863 m90 *1 635.035,803.79 nfet_05v0
M$2863 \$I2241 \$I3967 VSS VSS nfet_05v0 L=0.6U W=0.82U AS=0.282625P AD=0.3608P
+ PS=1.87U PD=2.52U
* device instance $2864 m90 *1 641.765,803.56 nfet_05v0
M$2864 VSS \$I2311 \$I3965 VSS nfet_05v0 L=0.6U W=0.36U AS=0.333P AD=0.0936P
+ PS=2.57U PD=0.88U
* device instance $2865 m90 *1 640.645,803.56 nfet_05v0
M$2865 \$I3968 \$I3965 VSS VSS nfet_05v0 L=0.6U W=0.36U AS=0.0936P AD=0.0432P
+ PS=0.88U PD=0.6U
* device instance $2866 m90 *1 639.805,803.56 nfet_05v0
M$2866 \$I3966 \$I3965 \$I3968 VSS nfet_05v0 L=0.6U W=0.36U AS=0.0432P
+ AD=0.369P PS=0.6U PD=2.77U
* device instance $2867 m90 *1 586.615,837.69 pfet_05v0
M$2867 \$I3978 \$I3973 \$I3974 VDD_DEC pfet_05v0 L=0.5U W=0.36U AS=0.3456P
+ AD=0.0612P PS=2.64U PD=0.7U
* device instance $2868 m90 *1 585.775,837.69 pfet_05v0
M$2868 \$I3978 \$I3973 VDD_DEC VDD_DEC pfet_05v0 L=0.5U W=0.36U AS=0.379P
+ AD=0.0612P PS=2.37U PD=0.7U
* device instance $2869 m90 *1 584.125,837.37 pfet_05v0
M$2869 \$I2334 \$I3974 VDD_DEC VDD_DEC pfet_05v0 L=0.5U W=1.22U AS=0.379P
+ AD=0.5368P PS=2.37U PD=3.32U
* device instance $2870 m90 *1 590.855,837.8 pfet_05v0
M$2870 VDD_DEC D[3] \$I3972 VDD_DEC pfet_05v0 L=0.5U W=0.36U AS=0.3852P
+ AD=0.1116P PS=2.86U PD=0.98U
* device instance $2871 m90 *1 589.735,837.8 pfet_05v0
M$2871 \$I3977 \$I3972 VDD_DEC VDD_DEC pfet_05v0 L=0.5U W=0.36U AS=0.1116P
+ AD=0.0612P PS=0.98U PD=0.7U
* device instance $2872 m90 *1 588.895,837.8 pfet_05v0
M$2872 \$I3977 \$I3972 \$I3973 VDD_DEC pfet_05v0 L=0.5U W=0.36U AS=0.3852P
+ AD=0.0612P PS=2.86U PD=0.7U
* device instance $2873 m90 *1 586.565,834.922 nfet_05v0
M$2873 \$I3976 \$I3973 \$I3974 VSS nfet_05v0 L=0.6U W=0.365U AS=0.3705P
+ AD=0.0438P PS=2.77U PD=0.605U
* device instance $2874 m90 *1 585.725,834.922 nfet_05v0
M$2874 VSS \$I3973 \$I3976 VSS nfet_05v0 L=0.6U W=0.365U AS=0.0438P
+ AD=0.282625P PS=0.605U PD=1.87U
* device instance $2875 m90 *1 584.075,835.15 nfet_05v0
M$2875 \$I2334 \$I3974 VSS VSS nfet_05v0 L=0.6U W=0.82U AS=0.282625P AD=0.3608P
+ PS=1.87U PD=2.52U
* device instance $2876 m90 *1 590.805,834.92 nfet_05v0
M$2876 VSS D[3] \$I3972 VSS nfet_05v0 L=0.6U W=0.36U AS=0.333P AD=0.0936P
+ PS=2.57U PD=0.88U
* device instance $2877 m90 *1 589.685,834.92 nfet_05v0
M$2877 \$I3975 \$I3972 VSS VSS nfet_05v0 L=0.6U W=0.36U AS=0.0936P AD=0.0432P
+ PS=0.88U PD=0.6U
* device instance $2878 m90 *1 588.845,834.92 nfet_05v0
M$2878 \$I3973 \$I3972 \$I3975 VSS nfet_05v0 L=0.6U W=0.36U AS=0.0432P
+ AD=0.369P PS=0.6U PD=2.77U
* device instance $2879 m0 *1 650.025,791.91 pfet_05v0
M$2879 \$I3985 \$I3980 \$I3981 VDD_DEC pfet_05v0 L=0.5U W=0.36U AS=0.3456P
+ AD=0.0612P PS=2.64U PD=0.7U
* device instance $2880 m0 *1 650.865,791.91 pfet_05v0
M$2880 \$I3985 \$I3980 VDD_DEC VDD_DEC pfet_05v0 L=0.5U W=0.36U AS=0.379P
+ AD=0.0612P PS=2.37U PD=0.7U
* device instance $2881 m0 *1 652.515,792.23 pfet_05v0
M$2881 \$I2243 \$I3981 VDD_DEC VDD_DEC pfet_05v0 L=0.5U W=1.22U AS=0.379P
+ AD=0.5368P PS=2.37U PD=3.32U
* device instance $2882 m0 *1 645.785,791.8 pfet_05v0
M$2882 VDD_DEC \$I2208 \$I3979 VDD_DEC pfet_05v0 L=0.5U W=0.36U AS=0.3852P
+ AD=0.1116P PS=2.86U PD=0.98U
* device instance $2883 m0 *1 646.905,791.8 pfet_05v0
M$2883 \$I3984 \$I3979 VDD_DEC VDD_DEC pfet_05v0 L=0.5U W=0.36U AS=0.1116P
+ AD=0.0612P PS=0.98U PD=0.7U
* device instance $2884 m0 *1 647.745,791.8 pfet_05v0
M$2884 \$I3984 \$I3979 \$I3980 VDD_DEC pfet_05v0 L=0.5U W=0.36U AS=0.3852P
+ AD=0.0612P PS=2.86U PD=0.7U
* device instance $2885 m0 *1 650.075,794.678 nfet_05v0
M$2885 \$I3983 \$I3980 \$I3981 VSS nfet_05v0 L=0.6U W=0.365U AS=0.3705P
+ AD=0.0438P PS=2.77U PD=0.605U
* device instance $2886 m0 *1 650.915,794.678 nfet_05v0
M$2886 VSS \$I3980 \$I3983 VSS nfet_05v0 L=0.6U W=0.365U AS=0.0438P
+ AD=0.282625P PS=0.605U PD=1.87U
* device instance $2887 m0 *1 652.565,794.45 nfet_05v0
M$2887 \$I2243 \$I3981 VSS VSS nfet_05v0 L=0.6U W=0.82U AS=0.282625P AD=0.3608P
+ PS=1.87U PD=2.52U
* device instance $2888 m0 *1 645.835,794.68 nfet_05v0
M$2888 VSS \$I2208 \$I3979 VSS nfet_05v0 L=0.6U W=0.36U AS=0.333P AD=0.0936P
+ PS=2.57U PD=0.88U
* device instance $2889 m0 *1 646.955,794.68 nfet_05v0
M$2889 \$I3982 \$I3979 VSS VSS nfet_05v0 L=0.6U W=0.36U AS=0.0936P AD=0.0432P
+ PS=0.88U PD=0.6U
* device instance $2890 m0 *1 647.795,794.68 nfet_05v0
M$2890 \$I3980 \$I3979 \$I3982 VSS nfet_05v0 L=0.6U W=0.36U AS=0.0432P
+ AD=0.369P PS=0.6U PD=2.77U
* device instance $2891 m0 *1 639.945,791.91 pfet_05v0
M$2891 \$I3992 \$I3987 \$I3988 VDD_DEC pfet_05v0 L=0.5U W=0.36U AS=0.3456P
+ AD=0.0612P PS=2.64U PD=0.7U
* device instance $2892 m0 *1 640.785,791.91 pfet_05v0
M$2892 \$I3992 \$I3987 VDD_DEC VDD_DEC pfet_05v0 L=0.5U W=0.36U AS=0.379P
+ AD=0.0612P PS=2.37U PD=0.7U
* device instance $2893 m0 *1 642.435,792.23 pfet_05v0
M$2893 \$I2140 \$I3988 VDD_DEC VDD_DEC pfet_05v0 L=0.5U W=1.22U AS=0.379P
+ AD=0.5368P PS=2.37U PD=3.32U
* device instance $2894 m0 *1 635.705,791.8 pfet_05v0
M$2894 VDD_DEC \$I2215 \$I3986 VDD_DEC pfet_05v0 L=0.5U W=0.36U AS=0.3852P
+ AD=0.1116P PS=2.86U PD=0.98U
* device instance $2895 m0 *1 636.825,791.8 pfet_05v0
M$2895 \$I3991 \$I3986 VDD_DEC VDD_DEC pfet_05v0 L=0.5U W=0.36U AS=0.1116P
+ AD=0.0612P PS=0.98U PD=0.7U
* device instance $2896 m0 *1 637.665,791.8 pfet_05v0
M$2896 \$I3991 \$I3986 \$I3987 VDD_DEC pfet_05v0 L=0.5U W=0.36U AS=0.3852P
+ AD=0.0612P PS=2.86U PD=0.7U
* device instance $2897 m0 *1 639.995,794.678 nfet_05v0
M$2897 \$I3990 \$I3987 \$I3988 VSS nfet_05v0 L=0.6U W=0.365U AS=0.3705P
+ AD=0.0438P PS=2.77U PD=0.605U
* device instance $2898 m0 *1 640.835,794.678 nfet_05v0
M$2898 VSS \$I3987 \$I3990 VSS nfet_05v0 L=0.6U W=0.365U AS=0.0438P
+ AD=0.282625P PS=0.605U PD=1.87U
* device instance $2899 m0 *1 642.485,794.45 nfet_05v0
M$2899 \$I2140 \$I3988 VSS VSS nfet_05v0 L=0.6U W=0.82U AS=0.282625P AD=0.3608P
+ PS=1.87U PD=2.52U
* device instance $2900 m0 *1 635.755,794.68 nfet_05v0
M$2900 VSS \$I2215 \$I3986 VSS nfet_05v0 L=0.6U W=0.36U AS=0.333P AD=0.0936P
+ PS=2.57U PD=0.88U
* device instance $2901 m0 *1 636.875,794.68 nfet_05v0
M$2901 \$I3989 \$I3986 VSS VSS nfet_05v0 L=0.6U W=0.36U AS=0.0936P AD=0.0432P
+ PS=0.88U PD=0.6U
* device instance $2902 m0 *1 637.715,794.68 nfet_05v0
M$2902 \$I3987 \$I3986 \$I3989 VSS nfet_05v0 L=0.6U W=0.36U AS=0.0432P
+ AD=0.369P PS=0.6U PD=2.77U
* device instance $2903 m0 *1 561.545,776.23 pfet_05v0
M$2903 \$I3999 \$I3994 \$I3995 VDD_DEC pfet_05v0 L=0.5U W=0.36U AS=0.3456P
+ AD=0.0612P PS=2.64U PD=0.7U
* device instance $2904 m0 *1 562.385,776.23 pfet_05v0
M$2904 \$I3999 \$I3994 VDD_DEC VDD_DEC pfet_05v0 L=0.5U W=0.36U AS=0.379P
+ AD=0.0612P PS=2.37U PD=0.7U
* device instance $2905 m0 *1 564.035,776.55 pfet_05v0
M$2905 \$171 \$I3995 VDD_DEC VDD_DEC pfet_05v0 L=0.5U W=1.22U AS=0.379P
+ AD=0.5368P PS=2.37U PD=3.32U
* device instance $2906 m0 *1 557.305,776.12 pfet_05v0
M$2906 VDD_DEC \$I2064 \$I3993 VDD_DEC pfet_05v0 L=0.5U W=0.36U AS=0.3852P
+ AD=0.1116P PS=2.86U PD=0.98U
* device instance $2907 m0 *1 558.425,776.12 pfet_05v0
M$2907 \$I3998 \$I3993 VDD_DEC VDD_DEC pfet_05v0 L=0.5U W=0.36U AS=0.1116P
+ AD=0.0612P PS=0.98U PD=0.7U
* device instance $2908 m0 *1 559.265,776.12 pfet_05v0
M$2908 \$I3998 \$I3993 \$I3994 VDD_DEC pfet_05v0 L=0.5U W=0.36U AS=0.3852P
+ AD=0.0612P PS=2.86U PD=0.7U
* device instance $2909 m0 *1 561.595,778.998 nfet_05v0
M$2909 \$I3997 \$I3994 \$I3995 VSS nfet_05v0 L=0.6U W=0.365U AS=0.3705P
+ AD=0.0438P PS=2.77U PD=0.605U
* device instance $2910 m0 *1 562.435,778.998 nfet_05v0
M$2910 VSS \$I3994 \$I3997 VSS nfet_05v0 L=0.6U W=0.365U AS=0.0438P
+ AD=0.282625P PS=0.605U PD=1.87U
* device instance $2911 m0 *1 564.085,778.77 nfet_05v0
M$2911 \$171 \$I3995 VSS VSS nfet_05v0 L=0.6U W=0.82U AS=0.282625P AD=0.3608P
+ PS=1.87U PD=2.52U
* device instance $2912 m0 *1 557.355,779 nfet_05v0
M$2912 VSS \$I2064 \$I3993 VSS nfet_05v0 L=0.6U W=0.36U AS=0.333P AD=0.0936P
+ PS=2.57U PD=0.88U
* device instance $2913 m0 *1 558.475,779 nfet_05v0
M$2913 \$I3996 \$I3993 VSS VSS nfet_05v0 L=0.6U W=0.36U AS=0.0936P AD=0.0432P
+ PS=0.88U PD=0.6U
* device instance $2914 m0 *1 559.315,779 nfet_05v0
M$2914 \$I3994 \$I3993 \$I3996 VSS nfet_05v0 L=0.6U W=0.36U AS=0.0432P
+ AD=0.369P PS=0.6U PD=2.77U
* device instance $2915 m0 *1 573.305,776.23 pfet_05v0
M$2915 \$I4006 \$I4001 \$I4002 VDD_DEC pfet_05v0 L=0.5U W=0.36U AS=0.3456P
+ AD=0.0612P PS=2.64U PD=0.7U
* device instance $2916 m0 *1 574.145,776.23 pfet_05v0
M$2916 \$I4006 \$I4001 VDD_DEC VDD_DEC pfet_05v0 L=0.5U W=0.36U AS=0.379P
+ AD=0.0612P PS=2.37U PD=0.7U
* device instance $2917 m0 *1 575.795,776.55 pfet_05v0
M$2917 \$192 \$I4002 VDD_DEC VDD_DEC pfet_05v0 L=0.5U W=1.22U AS=0.379P
+ AD=0.5368P PS=2.37U PD=3.32U
* device instance $2918 m0 *1 569.065,776.12 pfet_05v0
M$2918 VDD_DEC \$I2066 \$I4000 VDD_DEC pfet_05v0 L=0.5U W=0.36U AS=0.3852P
+ AD=0.1116P PS=2.86U PD=0.98U
* device instance $2919 m0 *1 570.185,776.12 pfet_05v0
M$2919 \$I4005 \$I4000 VDD_DEC VDD_DEC pfet_05v0 L=0.5U W=0.36U AS=0.1116P
+ AD=0.0612P PS=0.98U PD=0.7U
* device instance $2920 m0 *1 571.025,776.12 pfet_05v0
M$2920 \$I4005 \$I4000 \$I4001 VDD_DEC pfet_05v0 L=0.5U W=0.36U AS=0.3852P
+ AD=0.0612P PS=2.86U PD=0.7U
* device instance $2921 m0 *1 573.355,778.998 nfet_05v0
M$2921 \$I4004 \$I4001 \$I4002 VSS nfet_05v0 L=0.6U W=0.365U AS=0.3705P
+ AD=0.0438P PS=2.77U PD=0.605U
* device instance $2922 m0 *1 574.195,778.998 nfet_05v0
M$2922 VSS \$I4001 \$I4004 VSS nfet_05v0 L=0.6U W=0.365U AS=0.0438P
+ AD=0.282625P PS=0.605U PD=1.87U
* device instance $2923 m0 *1 575.845,778.77 nfet_05v0
M$2923 \$192 \$I4002 VSS VSS nfet_05v0 L=0.6U W=0.82U AS=0.282625P AD=0.3608P
+ PS=1.87U PD=2.52U
* device instance $2924 m0 *1 569.115,779 nfet_05v0
M$2924 VSS \$I2066 \$I4000 VSS nfet_05v0 L=0.6U W=0.36U AS=0.333P AD=0.0936P
+ PS=2.57U PD=0.88U
* device instance $2925 m0 *1 570.235,779 nfet_05v0
M$2925 \$I4003 \$I4000 VSS VSS nfet_05v0 L=0.6U W=0.36U AS=0.0936P AD=0.0432P
+ PS=0.88U PD=0.6U
* device instance $2926 m0 *1 571.075,779 nfet_05v0
M$2926 \$I4001 \$I4000 \$I4003 VSS nfet_05v0 L=0.6U W=0.36U AS=0.0432P
+ AD=0.369P PS=0.6U PD=2.77U
* device instance $2927 m0 *1 552.585,784.07 pfet_05v0
M$2927 \$I4013 \$I4008 \$I4009 VDD_DEC pfet_05v0 L=0.5U W=0.36U AS=0.3456P
+ AD=0.0612P PS=2.64U PD=0.7U
* device instance $2928 m0 *1 553.425,784.07 pfet_05v0
M$2928 \$I4013 \$I4008 VDD_DEC VDD_DEC pfet_05v0 L=0.5U W=0.36U AS=0.379P
+ AD=0.0612P PS=2.37U PD=0.7U
* device instance $2929 m0 *1 555.075,784.39 pfet_05v0
M$2929 \$191 \$I4009 VDD_DEC VDD_DEC pfet_05v0 L=0.5U W=1.22U AS=0.379P
+ AD=0.5368P PS=2.37U PD=3.32U
* device instance $2930 m0 *1 548.345,783.96 pfet_05v0
M$2930 VDD_DEC \$I2130 \$I4007 VDD_DEC pfet_05v0 L=0.5U W=0.36U AS=0.3852P
+ AD=0.1116P PS=2.86U PD=0.98U
* device instance $2931 m0 *1 549.465,783.96 pfet_05v0
M$2931 \$I4012 \$I4007 VDD_DEC VDD_DEC pfet_05v0 L=0.5U W=0.36U AS=0.1116P
+ AD=0.0612P PS=0.98U PD=0.7U
* device instance $2932 m0 *1 550.305,783.96 pfet_05v0
M$2932 \$I4012 \$I4007 \$I4008 VDD_DEC pfet_05v0 L=0.5U W=0.36U AS=0.3852P
+ AD=0.0612P PS=2.86U PD=0.7U
* device instance $2933 m0 *1 552.635,786.838 nfet_05v0
M$2933 \$I4011 \$I4008 \$I4009 VSS nfet_05v0 L=0.6U W=0.365U AS=0.3705P
+ AD=0.0438P PS=2.77U PD=0.605U
* device instance $2934 m0 *1 553.475,786.838 nfet_05v0
M$2934 VSS \$I4008 \$I4011 VSS nfet_05v0 L=0.6U W=0.365U AS=0.0438P
+ AD=0.282625P PS=0.605U PD=1.87U
* device instance $2935 m0 *1 555.125,786.61 nfet_05v0
M$2935 \$191 \$I4009 VSS VSS nfet_05v0 L=0.6U W=0.82U AS=0.282625P AD=0.3608P
+ PS=1.87U PD=2.52U
* device instance $2936 m0 *1 548.395,786.84 nfet_05v0
M$2936 VSS \$I2130 \$I4007 VSS nfet_05v0 L=0.6U W=0.36U AS=0.333P AD=0.0936P
+ PS=2.57U PD=0.88U
* device instance $2937 m0 *1 549.515,786.84 nfet_05v0
M$2937 \$I4010 \$I4007 VSS VSS nfet_05v0 L=0.6U W=0.36U AS=0.0936P AD=0.0432P
+ PS=0.88U PD=0.6U
* device instance $2938 m0 *1 550.355,786.84 nfet_05v0
M$2938 \$I4008 \$I4007 \$I4010 VSS nfet_05v0 L=0.6U W=0.36U AS=0.0432P
+ AD=0.369P PS=0.6U PD=2.77U
* device instance $2939 m0 *1 628.185,807.59 pfet_05v0
M$2939 \$I4020 \$I4015 \$I4016 VDD_DEC pfet_05v0 L=0.5U W=0.36U AS=0.3456P
+ AD=0.0612P PS=2.64U PD=0.7U
* device instance $2940 m0 *1 629.025,807.59 pfet_05v0
M$2940 \$I4020 \$I4015 VDD_DEC VDD_DEC pfet_05v0 L=0.5U W=0.36U AS=0.379P
+ AD=0.0612P PS=2.37U PD=0.7U
* device instance $2941 m0 *1 630.675,807.91 pfet_05v0
M$2941 \$9 \$I4016 VDD_DEC VDD_DEC pfet_05v0 L=0.5U W=1.22U AS=0.379P
+ AD=0.5368P PS=2.37U PD=3.32U
* device instance $2942 m0 *1 623.945,807.48 pfet_05v0
M$2942 VDD_DEC \$I2245 \$I4014 VDD_DEC pfet_05v0 L=0.5U W=0.36U AS=0.3852P
+ AD=0.1116P PS=2.86U PD=0.98U
* device instance $2943 m0 *1 625.065,807.48 pfet_05v0
M$2943 \$I4019 \$I4014 VDD_DEC VDD_DEC pfet_05v0 L=0.5U W=0.36U AS=0.1116P
+ AD=0.0612P PS=0.98U PD=0.7U
* device instance $2944 m0 *1 625.905,807.48 pfet_05v0
M$2944 \$I4019 \$I4014 \$I4015 VDD_DEC pfet_05v0 L=0.5U W=0.36U AS=0.3852P
+ AD=0.0612P PS=2.86U PD=0.7U
* device instance $2945 m0 *1 628.235,810.358 nfet_05v0
M$2945 \$I4018 \$I4015 \$I4016 VSS nfet_05v0 L=0.6U W=0.365U AS=0.3705P
+ AD=0.0438P PS=2.77U PD=0.605U
* device instance $2946 m0 *1 629.075,810.358 nfet_05v0
M$2946 VSS \$I4015 \$I4018 VSS nfet_05v0 L=0.6U W=0.365U AS=0.0438P
+ AD=0.282625P PS=0.605U PD=1.87U
* device instance $2947 m0 *1 630.725,810.13 nfet_05v0
M$2947 \$9 \$I4016 VSS VSS nfet_05v0 L=0.6U W=0.82U AS=0.282625P AD=0.3608P
+ PS=1.87U PD=2.52U
* device instance $2948 m0 *1 623.995,810.36 nfet_05v0
M$2948 VSS \$I2245 \$I4014 VSS nfet_05v0 L=0.6U W=0.36U AS=0.333P AD=0.0936P
+ PS=2.57U PD=0.88U
* device instance $2949 m0 *1 625.115,810.36 nfet_05v0
M$2949 \$I4017 \$I4014 VSS VSS nfet_05v0 L=0.6U W=0.36U AS=0.0936P AD=0.0432P
+ PS=0.88U PD=0.6U
* device instance $2950 m0 *1 625.955,810.36 nfet_05v0
M$2950 \$I4015 \$I4014 \$I4017 VSS nfet_05v0 L=0.6U W=0.36U AS=0.0432P
+ AD=0.369P PS=0.6U PD=2.77U
* device instance $2951 m0 *1 561.545,784.07 pfet_05v0
M$2951 \$I4027 \$I4022 \$I4023 VDD_DEC pfet_05v0 L=0.5U W=0.36U AS=0.3456P
+ AD=0.0612P PS=2.64U PD=0.7U
* device instance $2952 m0 *1 562.385,784.07 pfet_05v0
M$2952 \$I4027 \$I4022 VDD_DEC VDD_DEC pfet_05v0 L=0.5U W=0.36U AS=0.379P
+ AD=0.0612P PS=2.37U PD=0.7U
* device instance $2953 m0 *1 564.035,784.39 pfet_05v0
M$2953 \$159 \$I4023 VDD_DEC VDD_DEC pfet_05v0 L=0.5U W=1.22U AS=0.379P
+ AD=0.5368P PS=2.37U PD=3.32U
* device instance $2954 m0 *1 557.305,783.96 pfet_05v0
M$2954 VDD_DEC \$I2131 \$I4021 VDD_DEC pfet_05v0 L=0.5U W=0.36U AS=0.3852P
+ AD=0.1116P PS=2.86U PD=0.98U
* device instance $2955 m0 *1 558.425,783.96 pfet_05v0
M$2955 \$I4026 \$I4021 VDD_DEC VDD_DEC pfet_05v0 L=0.5U W=0.36U AS=0.1116P
+ AD=0.0612P PS=0.98U PD=0.7U
* device instance $2956 m0 *1 559.265,783.96 pfet_05v0
M$2956 \$I4026 \$I4021 \$I4022 VDD_DEC pfet_05v0 L=0.5U W=0.36U AS=0.3852P
+ AD=0.0612P PS=2.86U PD=0.7U
* device instance $2957 m0 *1 561.595,786.838 nfet_05v0
M$2957 \$I4025 \$I4022 \$I4023 VSS nfet_05v0 L=0.6U W=0.365U AS=0.3705P
+ AD=0.0438P PS=2.77U PD=0.605U
* device instance $2958 m0 *1 562.435,786.838 nfet_05v0
M$2958 VSS \$I4022 \$I4025 VSS nfet_05v0 L=0.6U W=0.365U AS=0.0438P
+ AD=0.282625P PS=0.605U PD=1.87U
* device instance $2959 m0 *1 564.085,786.61 nfet_05v0
M$2959 \$159 \$I4023 VSS VSS nfet_05v0 L=0.6U W=0.82U AS=0.282625P AD=0.3608P
+ PS=1.87U PD=2.52U
* device instance $2960 m0 *1 557.355,786.84 nfet_05v0
M$2960 VSS \$I2131 \$I4021 VSS nfet_05v0 L=0.6U W=0.36U AS=0.333P AD=0.0936P
+ PS=2.57U PD=0.88U
* device instance $2961 m0 *1 558.475,786.84 nfet_05v0
M$2961 \$I4024 \$I4021 VSS VSS nfet_05v0 L=0.6U W=0.36U AS=0.0936P AD=0.0432P
+ PS=0.88U PD=0.6U
* device instance $2962 m0 *1 559.315,786.84 nfet_05v0
M$2962 \$I4022 \$I4021 \$I4024 VSS nfet_05v0 L=0.6U W=0.36U AS=0.0432P
+ AD=0.369P PS=0.6U PD=2.77U
* device instance $2963 m0 *1 543.625,776.23 pfet_05v0
M$2963 \$I4034 \$I4029 \$I4030 VDD_DEC pfet_05v0 L=0.5U W=0.36U AS=0.3456P
+ AD=0.0612P PS=2.64U PD=0.7U
* device instance $2964 m0 *1 544.465,776.23 pfet_05v0
M$2964 \$I4034 \$I4029 VDD_DEC VDD_DEC pfet_05v0 L=0.5U W=0.36U AS=0.379P
+ AD=0.0612P PS=2.37U PD=0.7U
* device instance $2965 m0 *1 546.115,776.55 pfet_05v0
M$2965 \$185 \$I4030 VDD_DEC VDD_DEC pfet_05v0 L=0.5U W=1.22U AS=0.379P
+ AD=0.5368P PS=2.37U PD=3.32U
* device instance $2966 m0 *1 539.385,776.12 pfet_05v0
M$2966 VDD_DEC \$I2061 \$I4028 VDD_DEC pfet_05v0 L=0.5U W=0.36U AS=0.3852P
+ AD=0.1116P PS=2.86U PD=0.98U
* device instance $2967 m0 *1 540.505,776.12 pfet_05v0
M$2967 \$I4033 \$I4028 VDD_DEC VDD_DEC pfet_05v0 L=0.5U W=0.36U AS=0.1116P
+ AD=0.0612P PS=0.98U PD=0.7U
* device instance $2968 m0 *1 541.345,776.12 pfet_05v0
M$2968 \$I4033 \$I4028 \$I4029 VDD_DEC pfet_05v0 L=0.5U W=0.36U AS=0.3852P
+ AD=0.0612P PS=2.86U PD=0.7U
* device instance $2969 m0 *1 543.675,778.998 nfet_05v0
M$2969 \$I4032 \$I4029 \$I4030 VSS nfet_05v0 L=0.6U W=0.365U AS=0.3705P
+ AD=0.0438P PS=2.77U PD=0.605U
* device instance $2970 m0 *1 544.515,778.998 nfet_05v0
M$2970 VSS \$I4029 \$I4032 VSS nfet_05v0 L=0.6U W=0.365U AS=0.0438P
+ AD=0.282625P PS=0.605U PD=1.87U
* device instance $2971 m0 *1 546.165,778.77 nfet_05v0
M$2971 \$185 \$I4030 VSS VSS nfet_05v0 L=0.6U W=0.82U AS=0.282625P AD=0.3608P
+ PS=1.87U PD=2.52U
* device instance $2972 m0 *1 539.435,779 nfet_05v0
M$2972 VSS \$I2061 \$I4028 VSS nfet_05v0 L=0.6U W=0.36U AS=0.333P AD=0.0936P
+ PS=2.57U PD=0.88U
* device instance $2973 m0 *1 540.555,779 nfet_05v0
M$2973 \$I4031 \$I4028 VSS VSS nfet_05v0 L=0.6U W=0.36U AS=0.0936P AD=0.0432P
+ PS=0.88U PD=0.6U
* device instance $2974 m0 *1 541.395,779 nfet_05v0
M$2974 \$I4029 \$I4028 \$I4031 VSS nfet_05v0 L=0.6U W=0.36U AS=0.0432P
+ AD=0.369P PS=0.6U PD=2.77U
* device instance $2975 m0 *1 504.425,776.23 pfet_05v0
M$2975 \$I4041 \$I4036 \$I4037 VDD_DEC pfet_05v0 L=0.5U W=0.36U AS=0.3456P
+ AD=0.0612P PS=2.64U PD=0.7U
* device instance $2976 m0 *1 505.265,776.23 pfet_05v0
M$2976 \$I4041 \$I4036 VDD_DEC VDD_DEC pfet_05v0 L=0.5U W=0.36U AS=0.379P
+ AD=0.0612P PS=2.37U PD=0.7U
* device instance $2977 m0 *1 506.915,776.55 pfet_05v0
M$2977 \$279 \$I4037 VDD_DEC VDD_DEC pfet_05v0 L=0.5U W=1.22U AS=0.379P
+ AD=0.5368P PS=2.37U PD=3.32U
* device instance $2978 m0 *1 500.185,776.12 pfet_05v0
M$2978 VDD_DEC \$I2054 \$I4035 VDD_DEC pfet_05v0 L=0.5U W=0.36U AS=0.3852P
+ AD=0.1116P PS=2.86U PD=0.98U
* device instance $2979 m0 *1 501.305,776.12 pfet_05v0
M$2979 \$I4040 \$I4035 VDD_DEC VDD_DEC pfet_05v0 L=0.5U W=0.36U AS=0.1116P
+ AD=0.0612P PS=0.98U PD=0.7U
* device instance $2980 m0 *1 502.145,776.12 pfet_05v0
M$2980 \$I4040 \$I4035 \$I4036 VDD_DEC pfet_05v0 L=0.5U W=0.36U AS=0.3852P
+ AD=0.0612P PS=2.86U PD=0.7U
* device instance $2981 m0 *1 504.475,778.998 nfet_05v0
M$2981 \$I4039 \$I4036 \$I4037 VSS nfet_05v0 L=0.6U W=0.365U AS=0.3705P
+ AD=0.0438P PS=2.77U PD=0.605U
* device instance $2982 m0 *1 505.315,778.998 nfet_05v0
M$2982 VSS \$I4036 \$I4039 VSS nfet_05v0 L=0.6U W=0.365U AS=0.0438P
+ AD=0.282625P PS=0.605U PD=1.87U
* device instance $2983 m0 *1 506.965,778.77 nfet_05v0
M$2983 \$279 \$I4037 VSS VSS nfet_05v0 L=0.6U W=0.82U AS=0.282625P AD=0.3608P
+ PS=1.87U PD=2.52U
* device instance $2984 m0 *1 500.235,779 nfet_05v0
M$2984 VSS \$I2054 \$I4035 VSS nfet_05v0 L=0.6U W=0.36U AS=0.333P AD=0.0936P
+ PS=2.57U PD=0.88U
* device instance $2985 m0 *1 501.355,779 nfet_05v0
M$2985 \$I4038 \$I4035 VSS VSS nfet_05v0 L=0.6U W=0.36U AS=0.0936P AD=0.0432P
+ PS=0.88U PD=0.6U
* device instance $2986 m0 *1 502.195,779 nfet_05v0
M$2986 \$I4036 \$I4035 \$I4038 VSS nfet_05v0 L=0.6U W=0.36U AS=0.0432P
+ AD=0.369P PS=0.6U PD=2.77U
* device instance $2987 m0 *1 561.545,815.43 pfet_05v0
M$2987 \$I4048 \$I4043 \$I4044 VDD_DEC pfet_05v0 L=0.5U W=0.36U AS=0.3456P
+ AD=0.0612P PS=2.64U PD=0.7U
* device instance $2988 m0 *1 562.385,815.43 pfet_05v0
M$2988 \$I4048 \$I4043 VDD_DEC VDD_DEC pfet_05v0 L=0.5U W=0.36U AS=0.379P
+ AD=0.0612P PS=2.37U PD=0.7U
* device instance $2989 m0 *1 564.035,815.75 pfet_05v0
M$2989 \$I2383 \$I4044 VDD_DEC VDD_DEC pfet_05v0 L=0.5U W=1.22U AS=0.379P
+ AD=0.5368P PS=2.37U PD=3.32U
* device instance $2990 m0 *1 557.305,815.32 pfet_05v0
M$2990 VDD_DEC \$I2358 \$I4042 VDD_DEC pfet_05v0 L=0.5U W=0.36U AS=0.3852P
+ AD=0.1116P PS=2.86U PD=0.98U
* device instance $2991 m0 *1 558.425,815.32 pfet_05v0
M$2991 \$I4047 \$I4042 VDD_DEC VDD_DEC pfet_05v0 L=0.5U W=0.36U AS=0.1116P
+ AD=0.0612P PS=0.98U PD=0.7U
* device instance $2992 m0 *1 559.265,815.32 pfet_05v0
M$2992 \$I4047 \$I4042 \$I4043 VDD_DEC pfet_05v0 L=0.5U W=0.36U AS=0.3852P
+ AD=0.0612P PS=2.86U PD=0.7U
* device instance $2993 m0 *1 561.595,818.198 nfet_05v0
M$2993 \$I4046 \$I4043 \$I4044 VSS nfet_05v0 L=0.6U W=0.365U AS=0.3705P
+ AD=0.0438P PS=2.77U PD=0.605U
* device instance $2994 m0 *1 562.435,818.198 nfet_05v0
M$2994 VSS \$I4043 \$I4046 VSS nfet_05v0 L=0.6U W=0.365U AS=0.0438P
+ AD=0.282625P PS=0.605U PD=1.87U
* device instance $2995 m0 *1 564.085,817.97 nfet_05v0
M$2995 \$I2383 \$I4044 VSS VSS nfet_05v0 L=0.6U W=0.82U AS=0.282625P AD=0.3608P
+ PS=1.87U PD=2.52U
* device instance $2996 m0 *1 557.355,818.2 nfet_05v0
M$2996 VSS \$I2358 \$I4042 VSS nfet_05v0 L=0.6U W=0.36U AS=0.333P AD=0.0936P
+ PS=2.57U PD=0.88U
* device instance $2997 m0 *1 558.475,818.2 nfet_05v0
M$2997 \$I4045 \$I4042 VSS VSS nfet_05v0 L=0.6U W=0.36U AS=0.0936P AD=0.0432P
+ PS=0.88U PD=0.6U
* device instance $2998 m0 *1 559.315,818.2 nfet_05v0
M$2998 \$I4043 \$I4042 \$I4045 VSS nfet_05v0 L=0.6U W=0.36U AS=0.0432P
+ AD=0.369P PS=0.6U PD=2.77U
* device instance $2999 m0 *1 522.345,784.07 pfet_05v0
M$2999 \$I4055 \$I4050 \$I4051 VDD_DEC pfet_05v0 L=0.5U W=0.36U AS=0.3456P
+ AD=0.0612P PS=2.64U PD=0.7U
* device instance $3000 m0 *1 523.185,784.07 pfet_05v0
M$3000 \$I4055 \$I4050 VDD_DEC VDD_DEC pfet_05v0 L=0.5U W=0.36U AS=0.379P
+ AD=0.0612P PS=2.37U PD=0.7U
* device instance $3001 m0 *1 524.835,784.39 pfet_05v0
M$3001 \$175 \$I4051 VDD_DEC VDD_DEC pfet_05v0 L=0.5U W=1.22U AS=0.379P
+ AD=0.5368P PS=2.37U PD=3.32U
* device instance $3002 m0 *1 518.105,783.96 pfet_05v0
M$3002 VDD_DEC \$I2126 \$I4049 VDD_DEC pfet_05v0 L=0.5U W=0.36U AS=0.3852P
+ AD=0.1116P PS=2.86U PD=0.98U
* device instance $3003 m0 *1 519.225,783.96 pfet_05v0
M$3003 \$I4054 \$I4049 VDD_DEC VDD_DEC pfet_05v0 L=0.5U W=0.36U AS=0.1116P
+ AD=0.0612P PS=0.98U PD=0.7U
* device instance $3004 m0 *1 520.065,783.96 pfet_05v0
M$3004 \$I4054 \$I4049 \$I4050 VDD_DEC pfet_05v0 L=0.5U W=0.36U AS=0.3852P
+ AD=0.0612P PS=2.86U PD=0.7U
* device instance $3005 m0 *1 522.395,786.838 nfet_05v0
M$3005 \$I4053 \$I4050 \$I4051 VSS nfet_05v0 L=0.6U W=0.365U AS=0.3705P
+ AD=0.0438P PS=2.77U PD=0.605U
* device instance $3006 m0 *1 523.235,786.838 nfet_05v0
M$3006 VSS \$I4050 \$I4053 VSS nfet_05v0 L=0.6U W=0.365U AS=0.0438P
+ AD=0.282625P PS=0.605U PD=1.87U
* device instance $3007 m0 *1 524.885,786.61 nfet_05v0
M$3007 \$175 \$I4051 VSS VSS nfet_05v0 L=0.6U W=0.82U AS=0.282625P AD=0.3608P
+ PS=1.87U PD=2.52U
* device instance $3008 m0 *1 518.155,786.84 nfet_05v0
M$3008 VSS \$I2126 \$I4049 VSS nfet_05v0 L=0.6U W=0.36U AS=0.333P AD=0.0936P
+ PS=2.57U PD=0.88U
* device instance $3009 m0 *1 519.275,786.84 nfet_05v0
M$3009 \$I4052 \$I4049 VSS VSS nfet_05v0 L=0.6U W=0.36U AS=0.0936P AD=0.0432P
+ PS=0.88U PD=0.6U
* device instance $3010 m0 *1 520.115,786.84 nfet_05v0
M$3010 \$I4050 \$I4049 \$I4052 VSS nfet_05v0 L=0.6U W=0.36U AS=0.0432P
+ AD=0.369P PS=0.6U PD=2.77U
* device instance $3011 m0 *1 513.385,784.07 pfet_05v0
M$3011 \$I4062 \$I4057 \$I4058 VDD_DEC pfet_05v0 L=0.5U W=0.36U AS=0.3456P
+ AD=0.0612P PS=2.64U PD=0.7U
* device instance $3012 m0 *1 514.225,784.07 pfet_05v0
M$3012 \$I4062 \$I4057 VDD_DEC VDD_DEC pfet_05v0 L=0.5U W=0.36U AS=0.379P
+ AD=0.0612P PS=2.37U PD=0.7U
* device instance $3013 m0 *1 515.875,784.39 pfet_05v0
M$3013 \$148 \$I4058 VDD_DEC VDD_DEC pfet_05v0 L=0.5U W=1.22U AS=0.379P
+ AD=0.5368P PS=2.37U PD=3.32U
* device instance $3014 m0 *1 509.145,783.96 pfet_05v0
M$3014 VDD_DEC \$I2125 \$I4056 VDD_DEC pfet_05v0 L=0.5U W=0.36U AS=0.3852P
+ AD=0.1116P PS=2.86U PD=0.98U
* device instance $3015 m0 *1 510.265,783.96 pfet_05v0
M$3015 \$I4061 \$I4056 VDD_DEC VDD_DEC pfet_05v0 L=0.5U W=0.36U AS=0.1116P
+ AD=0.0612P PS=0.98U PD=0.7U
* device instance $3016 m0 *1 511.105,783.96 pfet_05v0
M$3016 \$I4061 \$I4056 \$I4057 VDD_DEC pfet_05v0 L=0.5U W=0.36U AS=0.3852P
+ AD=0.0612P PS=2.86U PD=0.7U
* device instance $3017 m0 *1 513.435,786.838 nfet_05v0
M$3017 \$I4060 \$I4057 \$I4058 VSS nfet_05v0 L=0.6U W=0.365U AS=0.3705P
+ AD=0.0438P PS=2.77U PD=0.605U
* device instance $3018 m0 *1 514.275,786.838 nfet_05v0
M$3018 VSS \$I4057 \$I4060 VSS nfet_05v0 L=0.6U W=0.365U AS=0.0438P
+ AD=0.282625P PS=0.605U PD=1.87U
* device instance $3019 m0 *1 515.925,786.61 nfet_05v0
M$3019 \$148 \$I4058 VSS VSS nfet_05v0 L=0.6U W=0.82U AS=0.282625P AD=0.3608P
+ PS=1.87U PD=2.52U
* device instance $3020 m0 *1 509.195,786.84 nfet_05v0
M$3020 VSS \$I2125 \$I4056 VSS nfet_05v0 L=0.6U W=0.36U AS=0.333P AD=0.0936P
+ PS=2.57U PD=0.88U
* device instance $3021 m0 *1 510.315,786.84 nfet_05v0
M$3021 \$I4059 \$I4056 VSS VSS nfet_05v0 L=0.6U W=0.36U AS=0.0936P AD=0.0432P
+ PS=0.88U PD=0.6U
* device instance $3022 m0 *1 511.155,786.84 nfet_05v0
M$3022 \$I4057 \$I4056 \$I4059 VSS nfet_05v0 L=0.6U W=0.36U AS=0.0432P
+ AD=0.369P PS=0.6U PD=2.77U
* device instance $3023 m0 *1 504.425,784.07 pfet_05v0
M$3023 \$I4069 \$I4064 \$I4065 VDD_DEC pfet_05v0 L=0.5U W=0.36U AS=0.3456P
+ AD=0.0612P PS=2.64U PD=0.7U
* device instance $3024 m0 *1 505.265,784.07 pfet_05v0
M$3024 \$I4069 \$I4064 VDD_DEC VDD_DEC pfet_05v0 L=0.5U W=0.36U AS=0.379P
+ AD=0.0612P PS=2.37U PD=0.7U
* device instance $3025 m0 *1 506.915,784.39 pfet_05v0
M$3025 \$274 \$I4065 VDD_DEC VDD_DEC pfet_05v0 L=0.5U W=1.22U AS=0.379P
+ AD=0.5368P PS=2.37U PD=3.32U
* device instance $3026 m0 *1 500.185,783.96 pfet_05v0
M$3026 VDD_DEC \$I2124 \$I4063 VDD_DEC pfet_05v0 L=0.5U W=0.36U AS=0.3852P
+ AD=0.1116P PS=2.86U PD=0.98U
* device instance $3027 m0 *1 501.305,783.96 pfet_05v0
M$3027 \$I4068 \$I4063 VDD_DEC VDD_DEC pfet_05v0 L=0.5U W=0.36U AS=0.1116P
+ AD=0.0612P PS=0.98U PD=0.7U
* device instance $3028 m0 *1 502.145,783.96 pfet_05v0
M$3028 \$I4068 \$I4063 \$I4064 VDD_DEC pfet_05v0 L=0.5U W=0.36U AS=0.3852P
+ AD=0.0612P PS=2.86U PD=0.7U
* device instance $3029 m0 *1 504.475,786.838 nfet_05v0
M$3029 \$I4067 \$I4064 \$I4065 VSS nfet_05v0 L=0.6U W=0.365U AS=0.3705P
+ AD=0.0438P PS=2.77U PD=0.605U
* device instance $3030 m0 *1 505.315,786.838 nfet_05v0
M$3030 VSS \$I4064 \$I4067 VSS nfet_05v0 L=0.6U W=0.365U AS=0.0438P
+ AD=0.282625P PS=0.605U PD=1.87U
* device instance $3031 m0 *1 506.965,786.61 nfet_05v0
M$3031 \$274 \$I4065 VSS VSS nfet_05v0 L=0.6U W=0.82U AS=0.282625P AD=0.3608P
+ PS=1.87U PD=2.52U
* device instance $3032 m0 *1 500.235,786.84 nfet_05v0
M$3032 VSS \$I2124 \$I4063 VSS nfet_05v0 L=0.6U W=0.36U AS=0.333P AD=0.0936P
+ PS=2.57U PD=0.88U
* device instance $3033 m0 *1 501.355,786.84 nfet_05v0
M$3033 \$I4066 \$I4063 VSS VSS nfet_05v0 L=0.6U W=0.36U AS=0.0936P AD=0.0432P
+ PS=0.88U PD=0.6U
* device instance $3034 m0 *1 502.195,786.84 nfet_05v0
M$3034 \$I4064 \$I4063 \$I4066 VSS nfet_05v0 L=0.6U W=0.36U AS=0.0432P
+ AD=0.369P PS=0.6U PD=2.77U
* device instance $3035 m0 *1 522.345,791.91 pfet_05v0
M$3035 \$I4076 \$I4071 \$I4072 VDD_DEC pfet_05v0 L=0.5U W=0.36U AS=0.3456P
+ AD=0.0612P PS=2.64U PD=0.7U
* device instance $3036 m0 *1 523.185,791.91 pfet_05v0
M$3036 \$I4076 \$I4071 VDD_DEC VDD_DEC pfet_05v0 L=0.5U W=0.36U AS=0.379P
+ AD=0.0612P PS=2.37U PD=0.7U
* device instance $3037 m0 *1 524.835,792.23 pfet_05v0
M$3037 \$157 \$I4072 VDD_DEC VDD_DEC pfet_05v0 L=0.5U W=1.22U AS=0.379P
+ AD=0.5368P PS=2.37U PD=3.32U
* device instance $3038 m0 *1 518.105,791.8 pfet_05v0
M$3038 VDD_DEC \$I2202 \$I4070 VDD_DEC pfet_05v0 L=0.5U W=0.36U AS=0.3852P
+ AD=0.1116P PS=2.86U PD=0.98U
* device instance $3039 m0 *1 519.225,791.8 pfet_05v0
M$3039 \$I4075 \$I4070 VDD_DEC VDD_DEC pfet_05v0 L=0.5U W=0.36U AS=0.1116P
+ AD=0.0612P PS=0.98U PD=0.7U
* device instance $3040 m0 *1 520.065,791.8 pfet_05v0
M$3040 \$I4075 \$I4070 \$I4071 VDD_DEC pfet_05v0 L=0.5U W=0.36U AS=0.3852P
+ AD=0.0612P PS=2.86U PD=0.7U
* device instance $3041 m0 *1 522.395,794.678 nfet_05v0
M$3041 \$I4074 \$I4071 \$I4072 VSS nfet_05v0 L=0.6U W=0.365U AS=0.3705P
+ AD=0.0438P PS=2.77U PD=0.605U
* device instance $3042 m0 *1 523.235,794.678 nfet_05v0
M$3042 VSS \$I4071 \$I4074 VSS nfet_05v0 L=0.6U W=0.365U AS=0.0438P
+ AD=0.282625P PS=0.605U PD=1.87U
* device instance $3043 m0 *1 524.885,794.45 nfet_05v0
M$3043 \$157 \$I4072 VSS VSS nfet_05v0 L=0.6U W=0.82U AS=0.282625P AD=0.3608P
+ PS=1.87U PD=2.52U
* device instance $3044 m0 *1 518.155,794.68 nfet_05v0
M$3044 VSS \$I2202 \$I4070 VSS nfet_05v0 L=0.6U W=0.36U AS=0.333P AD=0.0936P
+ PS=2.57U PD=0.88U
* device instance $3045 m0 *1 519.275,794.68 nfet_05v0
M$3045 \$I4073 \$I4070 VSS VSS nfet_05v0 L=0.6U W=0.36U AS=0.0936P AD=0.0432P
+ PS=0.88U PD=0.6U
* device instance $3046 m0 *1 520.115,794.68 nfet_05v0
M$3046 \$I4071 \$I4070 \$I4073 VSS nfet_05v0 L=0.6U W=0.36U AS=0.0432P
+ AD=0.369P PS=0.6U PD=2.77U
* device instance $3047 m0 *1 495.465,776.23 pfet_05v0
M$3047 \$I4083 \$I4078 \$I4079 VDD_DEC pfet_05v0 L=0.5U W=0.36U AS=0.3456P
+ AD=0.0612P PS=2.64U PD=0.7U
* device instance $3048 m0 *1 496.305,776.23 pfet_05v0
M$3048 \$I4083 \$I4078 VDD_DEC VDD_DEC pfet_05v0 L=0.5U W=0.36U AS=0.379P
+ AD=0.0612P PS=2.37U PD=0.7U
* device instance $3049 m0 *1 497.955,776.55 pfet_05v0
M$3049 \$273 \$I4079 VDD_DEC VDD_DEC pfet_05v0 L=0.5U W=1.22U AS=0.379P
+ AD=0.5368P PS=2.37U PD=3.32U
* device instance $3050 m0 *1 491.225,776.12 pfet_05v0
M$3050 VDD_DEC \$I2102 \$I4077 VDD_DEC pfet_05v0 L=0.5U W=0.36U AS=0.3852P
+ AD=0.1116P PS=2.86U PD=0.98U
* device instance $3051 m0 *1 492.345,776.12 pfet_05v0
M$3051 \$I4082 \$I4077 VDD_DEC VDD_DEC pfet_05v0 L=0.5U W=0.36U AS=0.1116P
+ AD=0.0612P PS=0.98U PD=0.7U
* device instance $3052 m0 *1 493.185,776.12 pfet_05v0
M$3052 \$I4082 \$I4077 \$I4078 VDD_DEC pfet_05v0 L=0.5U W=0.36U AS=0.3852P
+ AD=0.0612P PS=2.86U PD=0.7U
* device instance $3053 m0 *1 495.515,778.998 nfet_05v0
M$3053 \$I4081 \$I4078 \$I4079 VSS nfet_05v0 L=0.6U W=0.365U AS=0.3705P
+ AD=0.0438P PS=2.77U PD=0.605U
* device instance $3054 m0 *1 496.355,778.998 nfet_05v0
M$3054 VSS \$I4078 \$I4081 VSS nfet_05v0 L=0.6U W=0.365U AS=0.0438P
+ AD=0.282625P PS=0.605U PD=1.87U
* device instance $3055 m0 *1 498.005,778.77 nfet_05v0
M$3055 \$273 \$I4079 VSS VSS nfet_05v0 L=0.6U W=0.82U AS=0.282625P AD=0.3608P
+ PS=1.87U PD=2.52U
* device instance $3056 m0 *1 491.275,779 nfet_05v0
M$3056 VSS \$I2102 \$I4077 VSS nfet_05v0 L=0.6U W=0.36U AS=0.333P AD=0.0936P
+ PS=2.57U PD=0.88U
* device instance $3057 m0 *1 492.395,779 nfet_05v0
M$3057 \$I4080 \$I4077 VSS VSS nfet_05v0 L=0.6U W=0.36U AS=0.0936P AD=0.0432P
+ PS=0.88U PD=0.6U
* device instance $3058 m0 *1 493.235,779 nfet_05v0
M$3058 \$I4078 \$I4077 \$I4080 VSS nfet_05v0 L=0.6U W=0.36U AS=0.0432P
+ AD=0.369P PS=0.6U PD=2.77U
* device instance $3059 m0 *1 534.665,776.23 pfet_05v0
M$3059 \$I4090 \$I4085 \$I4086 VDD_DEC pfet_05v0 L=0.5U W=0.36U AS=0.3456P
+ AD=0.0612P PS=2.64U PD=0.7U
* device instance $3060 m0 *1 535.505,776.23 pfet_05v0
M$3060 \$I4090 \$I4085 VDD_DEC VDD_DEC pfet_05v0 L=0.5U W=0.36U AS=0.379P
+ AD=0.0612P PS=2.37U PD=0.7U
* device instance $3061 m0 *1 537.155,776.55 pfet_05v0
M$3061 \$164 \$I4086 VDD_DEC VDD_DEC pfet_05v0 L=0.5U W=1.22U AS=0.379P
+ AD=0.5368P PS=2.37U PD=3.32U
* device instance $3062 m0 *1 530.425,776.12 pfet_05v0
M$3062 VDD_DEC \$I2059 \$I4084 VDD_DEC pfet_05v0 L=0.5U W=0.36U AS=0.3852P
+ AD=0.1116P PS=2.86U PD=0.98U
* device instance $3063 m0 *1 531.545,776.12 pfet_05v0
M$3063 \$I4089 \$I4084 VDD_DEC VDD_DEC pfet_05v0 L=0.5U W=0.36U AS=0.1116P
+ AD=0.0612P PS=0.98U PD=0.7U
* device instance $3064 m0 *1 532.385,776.12 pfet_05v0
M$3064 \$I4089 \$I4084 \$I4085 VDD_DEC pfet_05v0 L=0.5U W=0.36U AS=0.3852P
+ AD=0.0612P PS=2.86U PD=0.7U
* device instance $3065 m0 *1 534.715,778.998 nfet_05v0
M$3065 \$I4088 \$I4085 \$I4086 VSS nfet_05v0 L=0.6U W=0.365U AS=0.3705P
+ AD=0.0438P PS=2.77U PD=0.605U
* device instance $3066 m0 *1 535.555,778.998 nfet_05v0
M$3066 VSS \$I4085 \$I4088 VSS nfet_05v0 L=0.6U W=0.365U AS=0.0438P
+ AD=0.282625P PS=0.605U PD=1.87U
* device instance $3067 m0 *1 537.205,778.77 nfet_05v0
M$3067 \$164 \$I4086 VSS VSS nfet_05v0 L=0.6U W=0.82U AS=0.282625P AD=0.3608P
+ PS=1.87U PD=2.52U
* device instance $3068 m0 *1 530.475,779 nfet_05v0
M$3068 VSS \$I2059 \$I4084 VSS nfet_05v0 L=0.6U W=0.36U AS=0.333P AD=0.0936P
+ PS=2.57U PD=0.88U
* device instance $3069 m0 *1 531.595,779 nfet_05v0
M$3069 \$I4087 \$I4084 VSS VSS nfet_05v0 L=0.6U W=0.36U AS=0.0936P AD=0.0432P
+ PS=0.88U PD=0.6U
* device instance $3070 m0 *1 532.435,779 nfet_05v0
M$3070 \$I4085 \$I4084 \$I4087 VSS nfet_05v0 L=0.6U W=0.36U AS=0.0432P
+ AD=0.369P PS=0.6U PD=2.77U
* device instance $3071 m0 *1 534.665,784.07 pfet_05v0
M$3071 \$I4097 \$I4092 \$I4093 VDD_DEC pfet_05v0 L=0.5U W=0.36U AS=0.3456P
+ AD=0.0612P PS=2.64U PD=0.7U
* device instance $3072 m0 *1 535.505,784.07 pfet_05v0
M$3072 \$I4097 \$I4092 VDD_DEC VDD_DEC pfet_05v0 L=0.5U W=0.36U AS=0.379P
+ AD=0.0612P PS=2.37U PD=0.7U
* device instance $3073 m0 *1 537.155,784.39 pfet_05v0
M$3073 \$155 \$I4093 VDD_DEC VDD_DEC pfet_05v0 L=0.5U W=1.22U AS=0.379P
+ AD=0.5368P PS=2.37U PD=3.32U
* device instance $3074 m0 *1 530.425,783.96 pfet_05v0
M$3074 VDD_DEC \$I2128 \$I4091 VDD_DEC pfet_05v0 L=0.5U W=0.36U AS=0.3852P
+ AD=0.1116P PS=2.86U PD=0.98U
* device instance $3075 m0 *1 531.545,783.96 pfet_05v0
M$3075 \$I4096 \$I4091 VDD_DEC VDD_DEC pfet_05v0 L=0.5U W=0.36U AS=0.1116P
+ AD=0.0612P PS=0.98U PD=0.7U
* device instance $3076 m0 *1 532.385,783.96 pfet_05v0
M$3076 \$I4096 \$I4091 \$I4092 VDD_DEC pfet_05v0 L=0.5U W=0.36U AS=0.3852P
+ AD=0.0612P PS=2.86U PD=0.7U
* device instance $3077 m0 *1 534.715,786.838 nfet_05v0
M$3077 \$I4095 \$I4092 \$I4093 VSS nfet_05v0 L=0.6U W=0.365U AS=0.3705P
+ AD=0.0438P PS=2.77U PD=0.605U
* device instance $3078 m0 *1 535.555,786.838 nfet_05v0
M$3078 VSS \$I4092 \$I4095 VSS nfet_05v0 L=0.6U W=0.365U AS=0.0438P
+ AD=0.282625P PS=0.605U PD=1.87U
* device instance $3079 m0 *1 537.205,786.61 nfet_05v0
M$3079 \$155 \$I4093 VSS VSS nfet_05v0 L=0.6U W=0.82U AS=0.282625P AD=0.3608P
+ PS=1.87U PD=2.52U
* device instance $3080 m0 *1 530.475,786.84 nfet_05v0
M$3080 VSS \$I2128 \$I4091 VSS nfet_05v0 L=0.6U W=0.36U AS=0.333P AD=0.0936P
+ PS=2.57U PD=0.88U
* device instance $3081 m0 *1 531.595,786.84 nfet_05v0
M$3081 \$I4094 \$I4091 VSS VSS nfet_05v0 L=0.6U W=0.36U AS=0.0936P AD=0.0432P
+ PS=0.88U PD=0.6U
* device instance $3082 m0 *1 532.435,786.84 nfet_05v0
M$3082 \$I4092 \$I4091 \$I4094 VSS nfet_05v0 L=0.6U W=0.36U AS=0.0432P
+ AD=0.369P PS=0.6U PD=2.77U
* device instance $3083 m0 *1 621.465,815.43 pfet_05v0
M$3083 \$I4104 \$I4099 \$I4100 VDD_DEC pfet_05v0 L=0.5U W=0.36U AS=0.3456P
+ AD=0.0612P PS=2.64U PD=0.7U
* device instance $3084 m0 *1 622.305,815.43 pfet_05v0
M$3084 \$I4104 \$I4099 VDD_DEC VDD_DEC pfet_05v0 L=0.5U W=0.36U AS=0.379P
+ AD=0.0612P PS=2.37U PD=0.7U
* device instance $3085 m0 *1 623.955,815.75 pfet_05v0
M$3085 \$I2341 \$I4100 VDD_DEC VDD_DEC pfet_05v0 L=0.5U W=1.22U AS=0.379P
+ AD=0.5368P PS=2.37U PD=3.32U
* device instance $3086 m0 *1 617.225,815.32 pfet_05v0
M$3086 VDD_DEC \$I2401 \$I4098 VDD_DEC pfet_05v0 L=0.5U W=0.36U AS=0.3852P
+ AD=0.1116P PS=2.86U PD=0.98U
* device instance $3087 m0 *1 618.345,815.32 pfet_05v0
M$3087 \$I4103 \$I4098 VDD_DEC VDD_DEC pfet_05v0 L=0.5U W=0.36U AS=0.1116P
+ AD=0.0612P PS=0.98U PD=0.7U
* device instance $3088 m0 *1 619.185,815.32 pfet_05v0
M$3088 \$I4103 \$I4098 \$I4099 VDD_DEC pfet_05v0 L=0.5U W=0.36U AS=0.3852P
+ AD=0.0612P PS=2.86U PD=0.7U
* device instance $3089 m0 *1 621.515,818.198 nfet_05v0
M$3089 \$I4102 \$I4099 \$I4100 VSS nfet_05v0 L=0.6U W=0.365U AS=0.3705P
+ AD=0.0438P PS=2.77U PD=0.605U
* device instance $3090 m0 *1 622.355,818.198 nfet_05v0
M$3090 VSS \$I4099 \$I4102 VSS nfet_05v0 L=0.6U W=0.365U AS=0.0438P
+ AD=0.282625P PS=0.605U PD=1.87U
* device instance $3091 m0 *1 624.005,817.97 nfet_05v0
M$3091 \$I2341 \$I4100 VSS VSS nfet_05v0 L=0.6U W=0.82U AS=0.282625P AD=0.3608P
+ PS=1.87U PD=2.52U
* device instance $3092 m0 *1 617.275,818.2 nfet_05v0
M$3092 VSS \$I2401 \$I4098 VSS nfet_05v0 L=0.6U W=0.36U AS=0.333P AD=0.0936P
+ PS=2.57U PD=0.88U
* device instance $3093 m0 *1 618.395,818.2 nfet_05v0
M$3093 \$I4101 \$I4098 VSS VSS nfet_05v0 L=0.6U W=0.36U AS=0.0936P AD=0.0432P
+ PS=0.88U PD=0.6U
* device instance $3094 m0 *1 619.235,818.2 nfet_05v0
M$3094 \$I4099 \$I4098 \$I4101 VSS nfet_05v0 L=0.6U W=0.36U AS=0.0432P
+ AD=0.369P PS=0.6U PD=2.77U
* device instance $3095 m0 *1 502.745,791.91 pfet_05v0
M$3095 \$I4111 \$I4106 \$I4107 VDD_DEC pfet_05v0 L=0.5U W=0.36U AS=0.3456P
+ AD=0.0612P PS=2.64U PD=0.7U
* device instance $3096 m0 *1 503.585,791.91 pfet_05v0
M$3096 \$I4111 \$I4106 VDD_DEC VDD_DEC pfet_05v0 L=0.5U W=0.36U AS=0.379P
+ AD=0.0612P PS=2.37U PD=0.7U
* device instance $3097 m0 *1 505.235,792.23 pfet_05v0
M$3097 \$267 \$I4107 VDD_DEC VDD_DEC pfet_05v0 L=0.5U W=1.22U AS=0.379P
+ AD=0.5368P PS=2.37U PD=3.32U
* device instance $3098 m0 *1 498.505,791.8 pfet_05v0
M$3098 VDD_DEC \$I2198 \$I4105 VDD_DEC pfet_05v0 L=0.5U W=0.36U AS=0.3852P
+ AD=0.1116P PS=2.86U PD=0.98U
* device instance $3099 m0 *1 499.625,791.8 pfet_05v0
M$3099 \$I4110 \$I4105 VDD_DEC VDD_DEC pfet_05v0 L=0.5U W=0.36U AS=0.1116P
+ AD=0.0612P PS=0.98U PD=0.7U
* device instance $3100 m0 *1 500.465,791.8 pfet_05v0
M$3100 \$I4110 \$I4105 \$I4106 VDD_DEC pfet_05v0 L=0.5U W=0.36U AS=0.3852P
+ AD=0.0612P PS=2.86U PD=0.7U
* device instance $3101 m0 *1 502.795,794.678 nfet_05v0
M$3101 \$I4109 \$I4106 \$I4107 VSS nfet_05v0 L=0.6U W=0.365U AS=0.3705P
+ AD=0.0438P PS=2.77U PD=0.605U
* device instance $3102 m0 *1 503.635,794.678 nfet_05v0
M$3102 VSS \$I4106 \$I4109 VSS nfet_05v0 L=0.6U W=0.365U AS=0.0438P
+ AD=0.282625P PS=0.605U PD=1.87U
* device instance $3103 m0 *1 505.285,794.45 nfet_05v0
M$3103 \$267 \$I4107 VSS VSS nfet_05v0 L=0.6U W=0.82U AS=0.282625P AD=0.3608P
+ PS=1.87U PD=2.52U
* device instance $3104 m0 *1 498.555,794.68 nfet_05v0
M$3104 VSS \$I2198 \$I4105 VSS nfet_05v0 L=0.6U W=0.36U AS=0.333P AD=0.0936P
+ PS=2.57U PD=0.88U
* device instance $3105 m0 *1 499.675,794.68 nfet_05v0
M$3105 \$I4108 \$I4105 VSS VSS nfet_05v0 L=0.6U W=0.36U AS=0.0936P AD=0.0432P
+ PS=0.88U PD=0.6U
* device instance $3106 m0 *1 500.515,794.68 nfet_05v0
M$3106 \$I4106 \$I4105 \$I4108 VSS nfet_05v0 L=0.6U W=0.36U AS=0.0432P
+ AD=0.369P PS=0.6U PD=2.77U
* device instance $3107 m0 *1 552.585,776.23 pfet_05v0
M$3107 \$I4118 \$I4113 \$I4114 VDD_DEC pfet_05v0 L=0.5U W=0.36U AS=0.3456P
+ AD=0.0612P PS=2.64U PD=0.7U
* device instance $3108 m0 *1 553.425,776.23 pfet_05v0
M$3108 \$I4118 \$I4113 VDD_DEC VDD_DEC pfet_05v0 L=0.5U W=0.36U AS=0.379P
+ AD=0.0612P PS=2.37U PD=0.7U
* device instance $3109 m0 *1 555.075,776.55 pfet_05v0
M$3109 \$156 \$I4114 VDD_DEC VDD_DEC pfet_05v0 L=0.5U W=1.22U AS=0.379P
+ AD=0.5368P PS=2.37U PD=3.32U
* device instance $3110 m0 *1 548.345,776.12 pfet_05v0
M$3110 VDD_DEC \$I2127 \$I4112 VDD_DEC pfet_05v0 L=0.5U W=0.36U AS=0.3852P
+ AD=0.1116P PS=2.86U PD=0.98U
* device instance $3111 m0 *1 549.465,776.12 pfet_05v0
M$3111 \$I4117 \$I4112 VDD_DEC VDD_DEC pfet_05v0 L=0.5U W=0.36U AS=0.1116P
+ AD=0.0612P PS=0.98U PD=0.7U
* device instance $3112 m0 *1 550.305,776.12 pfet_05v0
M$3112 \$I4117 \$I4112 \$I4113 VDD_DEC pfet_05v0 L=0.5U W=0.36U AS=0.3852P
+ AD=0.0612P PS=2.86U PD=0.7U
* device instance $3113 m0 *1 552.635,778.998 nfet_05v0
M$3113 \$I4116 \$I4113 \$I4114 VSS nfet_05v0 L=0.6U W=0.365U AS=0.3705P
+ AD=0.0438P PS=2.77U PD=0.605U
* device instance $3114 m0 *1 553.475,778.998 nfet_05v0
M$3114 VSS \$I4113 \$I4116 VSS nfet_05v0 L=0.6U W=0.365U AS=0.0438P
+ AD=0.282625P PS=0.605U PD=1.87U
* device instance $3115 m0 *1 555.125,778.77 nfet_05v0
M$3115 \$156 \$I4114 VSS VSS nfet_05v0 L=0.6U W=0.82U AS=0.282625P AD=0.3608P
+ PS=1.87U PD=2.52U
* device instance $3116 m0 *1 548.395,779 nfet_05v0
M$3116 VSS \$I2127 \$I4112 VSS nfet_05v0 L=0.6U W=0.36U AS=0.333P AD=0.0936P
+ PS=2.57U PD=0.88U
* device instance $3117 m0 *1 549.515,779 nfet_05v0
M$3117 \$I4115 \$I4112 VSS VSS nfet_05v0 L=0.6U W=0.36U AS=0.0936P AD=0.0432P
+ PS=0.88U PD=0.6U
* device instance $3118 m0 *1 550.355,779 nfet_05v0
M$3118 \$I4113 \$I4112 \$I4115 VSS nfet_05v0 L=0.6U W=0.36U AS=0.0432P
+ AD=0.369P PS=0.6U PD=2.77U
* device instance $3119 m0 *1 543.625,784.07 pfet_05v0
M$3119 \$I4125 \$I4120 \$I4121 VDD_DEC pfet_05v0 L=0.5U W=0.36U AS=0.3456P
+ AD=0.0612P PS=2.64U PD=0.7U
* device instance $3120 m0 *1 544.465,784.07 pfet_05v0
M$3120 \$I4125 \$I4120 VDD_DEC VDD_DEC pfet_05v0 L=0.5U W=0.36U AS=0.379P
+ AD=0.0612P PS=2.37U PD=0.7U
* device instance $3121 m0 *1 546.115,784.39 pfet_05v0
M$3121 \$170 \$I4121 VDD_DEC VDD_DEC pfet_05v0 L=0.5U W=1.22U AS=0.379P
+ AD=0.5368P PS=2.37U PD=3.32U
* device instance $3122 m0 *1 539.385,783.96 pfet_05v0
M$3122 VDD_DEC \$I2129 \$I4119 VDD_DEC pfet_05v0 L=0.5U W=0.36U AS=0.3852P
+ AD=0.1116P PS=2.86U PD=0.98U
* device instance $3123 m0 *1 540.505,783.96 pfet_05v0
M$3123 \$I4124 \$I4119 VDD_DEC VDD_DEC pfet_05v0 L=0.5U W=0.36U AS=0.1116P
+ AD=0.0612P PS=0.98U PD=0.7U
* device instance $3124 m0 *1 541.345,783.96 pfet_05v0
M$3124 \$I4124 \$I4119 \$I4120 VDD_DEC pfet_05v0 L=0.5U W=0.36U AS=0.3852P
+ AD=0.0612P PS=2.86U PD=0.7U
* device instance $3125 m0 *1 543.675,786.838 nfet_05v0
M$3125 \$I4123 \$I4120 \$I4121 VSS nfet_05v0 L=0.6U W=0.365U AS=0.3705P
+ AD=0.0438P PS=2.77U PD=0.605U
* device instance $3126 m0 *1 544.515,786.838 nfet_05v0
M$3126 VSS \$I4120 \$I4123 VSS nfet_05v0 L=0.6U W=0.365U AS=0.0438P
+ AD=0.282625P PS=0.605U PD=1.87U
* device instance $3127 m0 *1 546.165,786.61 nfet_05v0
M$3127 \$170 \$I4121 VSS VSS nfet_05v0 L=0.6U W=0.82U AS=0.282625P AD=0.3608P
+ PS=1.87U PD=2.52U
* device instance $3128 m0 *1 539.435,786.84 nfet_05v0
M$3128 VSS \$I2129 \$I4119 VSS nfet_05v0 L=0.6U W=0.36U AS=0.333P AD=0.0936P
+ PS=2.57U PD=0.88U
* device instance $3129 m0 *1 540.555,786.84 nfet_05v0
M$3129 \$I4122 \$I4119 VSS VSS nfet_05v0 L=0.6U W=0.36U AS=0.0936P AD=0.0432P
+ PS=0.88U PD=0.6U
* device instance $3130 m0 *1 541.395,786.84 nfet_05v0
M$3130 \$I4120 \$I4119 \$I4122 VSS nfet_05v0 L=0.6U W=0.36U AS=0.0432P
+ AD=0.369P PS=0.6U PD=2.77U
* device instance $3131 m0 *1 513.385,776.23 pfet_05v0
M$3131 \$I4132 \$I4127 \$I4128 VDD_DEC pfet_05v0 L=0.5U W=0.36U AS=0.3456P
+ AD=0.0612P PS=2.64U PD=0.7U
* device instance $3132 m0 *1 514.225,776.23 pfet_05v0
M$3132 \$I4132 \$I4127 VDD_DEC VDD_DEC pfet_05v0 L=0.5U W=0.36U AS=0.379P
+ AD=0.0612P PS=2.37U PD=0.7U
* device instance $3133 m0 *1 515.875,776.55 pfet_05v0
M$3133 \$166 \$I4128 VDD_DEC VDD_DEC pfet_05v0 L=0.5U W=1.22U AS=0.379P
+ AD=0.5368P PS=2.37U PD=3.32U
* device instance $3134 m0 *1 509.145,776.12 pfet_05v0
M$3134 VDD_DEC \$I2055 \$I4126 VDD_DEC pfet_05v0 L=0.5U W=0.36U AS=0.3852P
+ AD=0.1116P PS=2.86U PD=0.98U
* device instance $3135 m0 *1 510.265,776.12 pfet_05v0
M$3135 \$I4131 \$I4126 VDD_DEC VDD_DEC pfet_05v0 L=0.5U W=0.36U AS=0.1116P
+ AD=0.0612P PS=0.98U PD=0.7U
* device instance $3136 m0 *1 511.105,776.12 pfet_05v0
M$3136 \$I4131 \$I4126 \$I4127 VDD_DEC pfet_05v0 L=0.5U W=0.36U AS=0.3852P
+ AD=0.0612P PS=2.86U PD=0.7U
* device instance $3137 m0 *1 513.435,778.998 nfet_05v0
M$3137 \$I4130 \$I4127 \$I4128 VSS nfet_05v0 L=0.6U W=0.365U AS=0.3705P
+ AD=0.0438P PS=2.77U PD=0.605U
* device instance $3138 m0 *1 514.275,778.998 nfet_05v0
M$3138 VSS \$I4127 \$I4130 VSS nfet_05v0 L=0.6U W=0.365U AS=0.0438P
+ AD=0.282625P PS=0.605U PD=1.87U
* device instance $3139 m0 *1 515.925,778.77 nfet_05v0
M$3139 \$166 \$I4128 VSS VSS nfet_05v0 L=0.6U W=0.82U AS=0.282625P AD=0.3608P
+ PS=1.87U PD=2.52U
* device instance $3140 m0 *1 509.195,779 nfet_05v0
M$3140 VSS \$I2055 \$I4126 VSS nfet_05v0 L=0.6U W=0.36U AS=0.333P AD=0.0936P
+ PS=2.57U PD=0.88U
* device instance $3141 m0 *1 510.315,779 nfet_05v0
M$3141 \$I4129 \$I4126 VSS VSS nfet_05v0 L=0.6U W=0.36U AS=0.0936P AD=0.0432P
+ PS=0.88U PD=0.6U
* device instance $3142 m0 *1 511.155,779 nfet_05v0
M$3142 \$I4127 \$I4126 \$I4129 VSS nfet_05v0 L=0.6U W=0.36U AS=0.0432P
+ AD=0.369P PS=0.6U PD=2.77U
* device instance $3143 m0 *1 522.345,776.23 pfet_05v0
M$3143 \$I4139 \$I4134 \$I4135 VDD_DEC pfet_05v0 L=0.5U W=0.36U AS=0.3456P
+ AD=0.0612P PS=2.64U PD=0.7U
* device instance $3144 m0 *1 523.185,776.23 pfet_05v0
M$3144 \$I4139 \$I4134 VDD_DEC VDD_DEC pfet_05v0 L=0.5U W=0.36U AS=0.379P
+ AD=0.0612P PS=2.37U PD=0.7U
* device instance $3145 m0 *1 524.835,776.55 pfet_05v0
M$3145 \$190 \$I4135 VDD_DEC VDD_DEC pfet_05v0 L=0.5U W=1.22U AS=0.379P
+ AD=0.5368P PS=2.37U PD=3.32U
* device instance $3146 m0 *1 518.105,776.12 pfet_05v0
M$3146 VDD_DEC \$I2057 \$I4133 VDD_DEC pfet_05v0 L=0.5U W=0.36U AS=0.3852P
+ AD=0.1116P PS=2.86U PD=0.98U
* device instance $3147 m0 *1 519.225,776.12 pfet_05v0
M$3147 \$I4138 \$I4133 VDD_DEC VDD_DEC pfet_05v0 L=0.5U W=0.36U AS=0.1116P
+ AD=0.0612P PS=0.98U PD=0.7U
* device instance $3148 m0 *1 520.065,776.12 pfet_05v0
M$3148 \$I4138 \$I4133 \$I4134 VDD_DEC pfet_05v0 L=0.5U W=0.36U AS=0.3852P
+ AD=0.0612P PS=2.86U PD=0.7U
* device instance $3149 m0 *1 522.395,778.998 nfet_05v0
M$3149 \$I4137 \$I4134 \$I4135 VSS nfet_05v0 L=0.6U W=0.365U AS=0.3705P
+ AD=0.0438P PS=2.77U PD=0.605U
* device instance $3150 m0 *1 523.235,778.998 nfet_05v0
M$3150 VSS \$I4134 \$I4137 VSS nfet_05v0 L=0.6U W=0.365U AS=0.0438P
+ AD=0.282625P PS=0.605U PD=1.87U
* device instance $3151 m0 *1 524.885,778.77 nfet_05v0
M$3151 \$190 \$I4135 VSS VSS nfet_05v0 L=0.6U W=0.82U AS=0.282625P AD=0.3608P
+ PS=1.87U PD=2.52U
* device instance $3152 m0 *1 518.155,779 nfet_05v0
M$3152 VSS \$I2057 \$I4133 VSS nfet_05v0 L=0.6U W=0.36U AS=0.333P AD=0.0936P
+ PS=2.57U PD=0.88U
* device instance $3153 m0 *1 519.275,779 nfet_05v0
M$3153 \$I4136 \$I4133 VSS VSS nfet_05v0 L=0.6U W=0.36U AS=0.0936P AD=0.0432P
+ PS=0.88U PD=0.6U
* device instance $3154 m0 *1 520.115,779 nfet_05v0
M$3154 \$I4134 \$I4133 \$I4136 VSS nfet_05v0 L=0.6U W=0.36U AS=0.0432P
+ AD=0.369P PS=0.6U PD=2.77U
* device instance $3155 r180 *1 579.895,815.43 pfet_05v0
M$3155 \$I4146 \$I4141 \$I4142 VDD_DEC pfet_05v0 L=0.5U W=0.36U AS=0.3456P
+ AD=0.0612P PS=2.64U PD=0.7U
* device instance $3156 r180 *1 579.055,815.43 pfet_05v0
M$3156 \$I4146 \$I4141 VDD_DEC VDD_DEC pfet_05v0 L=0.5U W=0.36U AS=0.379P
+ AD=0.0612P PS=2.37U PD=0.7U
* device instance $3157 r180 *1 577.405,815.75 pfet_05v0
M$3157 \$I2384 \$I4142 VDD_DEC VDD_DEC pfet_05v0 L=0.5U W=1.22U AS=0.379P
+ AD=0.5368P PS=2.37U PD=3.32U
* device instance $3158 r180 *1 584.135,815.32 pfet_05v0
M$3158 VDD_DEC \$I2334 \$I4140 VDD_DEC pfet_05v0 L=0.5U W=0.36U AS=0.3852P
+ AD=0.1116P PS=2.86U PD=0.98U
* device instance $3159 r180 *1 583.015,815.32 pfet_05v0
M$3159 \$I4145 \$I4140 VDD_DEC VDD_DEC pfet_05v0 L=0.5U W=0.36U AS=0.1116P
+ AD=0.0612P PS=0.98U PD=0.7U
* device instance $3160 r180 *1 582.175,815.32 pfet_05v0
M$3160 \$I4145 \$I4140 \$I4141 VDD_DEC pfet_05v0 L=0.5U W=0.36U AS=0.3852P
+ AD=0.0612P PS=2.86U PD=0.7U
* device instance $3161 r180 *1 579.845,818.198 nfet_05v0
M$3161 \$I4144 \$I4141 \$I4142 VSS nfet_05v0 L=0.6U W=0.365U AS=0.3705P
+ AD=0.0438P PS=2.77U PD=0.605U
* device instance $3162 r180 *1 579.005,818.198 nfet_05v0
M$3162 VSS \$I4141 \$I4144 VSS nfet_05v0 L=0.6U W=0.365U AS=0.0438P
+ AD=0.282625P PS=0.605U PD=1.87U
* device instance $3163 r180 *1 577.355,817.97 nfet_05v0
M$3163 \$I2384 \$I4142 VSS VSS nfet_05v0 L=0.6U W=0.82U AS=0.282625P AD=0.3608P
+ PS=1.87U PD=2.52U
* device instance $3164 r180 *1 584.085,818.2 nfet_05v0
M$3164 VSS \$I2334 \$I4140 VSS nfet_05v0 L=0.6U W=0.36U AS=0.333P AD=0.0936P
+ PS=2.57U PD=0.88U
* device instance $3165 r180 *1 582.965,818.2 nfet_05v0
M$3165 \$I4143 \$I4140 VSS VSS nfet_05v0 L=0.6U W=0.36U AS=0.0936P AD=0.0432P
+ PS=0.88U PD=0.6U
* device instance $3166 r180 *1 582.125,818.2 nfet_05v0
M$3166 \$I4141 \$I4140 \$I4143 VSS nfet_05v0 L=0.6U W=0.36U AS=0.0432P
+ AD=0.369P PS=0.6U PD=2.77U
* device instance $3167 r180 *1 609.015,807.59 pfet_05v0
M$3167 \$I4153 \$I4148 \$I4149 VDD_DEC pfet_05v0 L=0.5U W=0.36U AS=0.3456P
+ AD=0.0612P PS=2.64U PD=0.7U
* device instance $3168 r180 *1 608.175,807.59 pfet_05v0
M$3168 \$I4153 \$I4148 VDD_DEC VDD_DEC pfet_05v0 L=0.5U W=0.36U AS=0.379P
+ AD=0.0612P PS=2.37U PD=0.7U
* device instance $3169 r180 *1 606.525,807.91 pfet_05v0
M$3169 \$I2284 \$I4149 VDD_DEC VDD_DEC pfet_05v0 L=0.5U W=1.22U AS=0.379P
+ AD=0.5368P PS=2.37U PD=3.32U
* device instance $3170 r180 *1 613.255,807.48 pfet_05v0
M$3170 VDD_DEC \$I2341 \$I4147 VDD_DEC pfet_05v0 L=0.5U W=0.36U AS=0.3852P
+ AD=0.1116P PS=2.86U PD=0.98U
* device instance $3171 r180 *1 612.135,807.48 pfet_05v0
M$3171 \$I4152 \$I4147 VDD_DEC VDD_DEC pfet_05v0 L=0.5U W=0.36U AS=0.1116P
+ AD=0.0612P PS=0.98U PD=0.7U
* device instance $3172 r180 *1 611.295,807.48 pfet_05v0
M$3172 \$I4152 \$I4147 \$I4148 VDD_DEC pfet_05v0 L=0.5U W=0.36U AS=0.3852P
+ AD=0.0612P PS=2.86U PD=0.7U
* device instance $3173 r180 *1 608.965,810.358 nfet_05v0
M$3173 \$I4151 \$I4148 \$I4149 VSS nfet_05v0 L=0.6U W=0.365U AS=0.3705P
+ AD=0.0438P PS=2.77U PD=0.605U
* device instance $3174 r180 *1 608.125,810.358 nfet_05v0
M$3174 VSS \$I4148 \$I4151 VSS nfet_05v0 L=0.6U W=0.365U AS=0.0438P
+ AD=0.282625P PS=0.605U PD=1.87U
* device instance $3175 r180 *1 606.475,810.13 nfet_05v0
M$3175 \$I2284 \$I4149 VSS VSS nfet_05v0 L=0.6U W=0.82U AS=0.282625P AD=0.3608P
+ PS=1.87U PD=2.52U
* device instance $3176 r180 *1 613.205,810.36 nfet_05v0
M$3176 VSS \$I2341 \$I4147 VSS nfet_05v0 L=0.6U W=0.36U AS=0.333P AD=0.0936P
+ PS=2.57U PD=0.88U
* device instance $3177 r180 *1 612.085,810.36 nfet_05v0
M$3177 \$I4150 \$I4147 VSS VSS nfet_05v0 L=0.6U W=0.36U AS=0.0936P AD=0.0432P
+ PS=0.88U PD=0.6U
* device instance $3178 r180 *1 611.245,810.36 nfet_05v0
M$3178 \$I4148 \$I4147 \$I4150 VSS nfet_05v0 L=0.6U W=0.36U AS=0.0432P
+ AD=0.369P PS=0.6U PD=2.77U
* device instance $3179 r180 *1 598.935,791.91 pfet_05v0
M$3179 \$I4160 \$I4155 \$I4156 VDD_DEC pfet_05v0 L=0.5U W=0.36U AS=0.3456P
+ AD=0.0612P PS=2.64U PD=0.7U
* device instance $3180 r180 *1 598.095,791.91 pfet_05v0
M$3180 \$I4160 \$I4155 VDD_DEC VDD_DEC pfet_05v0 L=0.5U W=0.36U AS=0.379P
+ AD=0.0612P PS=2.37U PD=0.7U
* device instance $3181 r180 *1 596.445,792.23 pfet_05v0
M$3181 \$I2172 \$I4156 VDD_DEC VDD_DEC pfet_05v0 L=0.5U W=1.22U AS=0.379P
+ AD=0.5368P PS=2.37U PD=3.32U
* device instance $3182 r180 *1 603.175,791.8 pfet_05v0
M$3182 VDD_DEC \$I2338 \$I4154 VDD_DEC pfet_05v0 L=0.5U W=0.36U AS=0.3852P
+ AD=0.1116P PS=2.86U PD=0.98U
* device instance $3183 r180 *1 602.055,791.8 pfet_05v0
M$3183 \$I4159 \$I4154 VDD_DEC VDD_DEC pfet_05v0 L=0.5U W=0.36U AS=0.1116P
+ AD=0.0612P PS=0.98U PD=0.7U
* device instance $3184 r180 *1 601.215,791.8 pfet_05v0
M$3184 \$I4159 \$I4154 \$I4155 VDD_DEC pfet_05v0 L=0.5U W=0.36U AS=0.3852P
+ AD=0.0612P PS=2.86U PD=0.7U
* device instance $3185 r180 *1 598.885,794.678 nfet_05v0
M$3185 \$I4158 \$I4155 \$I4156 VSS nfet_05v0 L=0.6U W=0.365U AS=0.3705P
+ AD=0.0438P PS=2.77U PD=0.605U
* device instance $3186 r180 *1 598.045,794.678 nfet_05v0
M$3186 VSS \$I4155 \$I4158 VSS nfet_05v0 L=0.6U W=0.365U AS=0.0438P
+ AD=0.282625P PS=0.605U PD=1.87U
* device instance $3187 r180 *1 596.395,794.45 nfet_05v0
M$3187 \$I2172 \$I4156 VSS VSS nfet_05v0 L=0.6U W=0.82U AS=0.282625P AD=0.3608P
+ PS=1.87U PD=2.52U
* device instance $3188 r180 *1 603.125,794.68 nfet_05v0
M$3188 VSS \$I2338 \$I4154 VSS nfet_05v0 L=0.6U W=0.36U AS=0.333P AD=0.0936P
+ PS=2.57U PD=0.88U
* device instance $3189 r180 *1 602.005,794.68 nfet_05v0
M$3189 \$I4157 \$I4154 VSS VSS nfet_05v0 L=0.6U W=0.36U AS=0.0936P AD=0.0432P
+ PS=0.88U PD=0.6U
* device instance $3190 r180 *1 601.165,794.68 nfet_05v0
M$3190 \$I4155 \$I4154 \$I4157 VSS nfet_05v0 L=0.6U W=0.36U AS=0.0432P
+ AD=0.369P PS=0.6U PD=2.77U
* device instance $3191 r180 *1 580.455,776.23 pfet_05v0
M$3191 \$I4167 \$I4162 \$I4163 VDD_DEC pfet_05v0 L=0.5U W=0.36U AS=0.3456P
+ AD=0.0612P PS=2.64U PD=0.7U
* device instance $3192 r180 *1 579.615,776.23 pfet_05v0
M$3192 \$I4167 \$I4162 VDD_DEC VDD_DEC pfet_05v0 L=0.5U W=0.36U AS=0.379P
+ AD=0.0612P PS=2.37U PD=0.7U
* device instance $3193 r180 *1 577.965,776.55 pfet_05v0
M$3193 \$88 \$I4163 VDD_DEC VDD_DEC pfet_05v0 L=0.5U W=1.22U AS=0.379P
+ AD=0.5368P PS=2.37U PD=3.32U
* device instance $3194 r180 *1 584.695,776.12 pfet_05v0
M$3194 VDD_DEC \$I2068 \$I4161 VDD_DEC pfet_05v0 L=0.5U W=0.36U AS=0.3852P
+ AD=0.1116P PS=2.86U PD=0.98U
* device instance $3195 r180 *1 583.575,776.12 pfet_05v0
M$3195 \$I4166 \$I4161 VDD_DEC VDD_DEC pfet_05v0 L=0.5U W=0.36U AS=0.1116P
+ AD=0.0612P PS=0.98U PD=0.7U
* device instance $3196 r180 *1 582.735,776.12 pfet_05v0
M$3196 \$I4166 \$I4161 \$I4162 VDD_DEC pfet_05v0 L=0.5U W=0.36U AS=0.3852P
+ AD=0.0612P PS=2.86U PD=0.7U
* device instance $3197 r180 *1 580.405,778.998 nfet_05v0
M$3197 \$I4165 \$I4162 \$I4163 VSS nfet_05v0 L=0.6U W=0.365U AS=0.3705P
+ AD=0.0438P PS=2.77U PD=0.605U
* device instance $3198 r180 *1 579.565,778.998 nfet_05v0
M$3198 VSS \$I4162 \$I4165 VSS nfet_05v0 L=0.6U W=0.365U AS=0.0438P
+ AD=0.282625P PS=0.605U PD=1.87U
* device instance $3199 r180 *1 577.915,778.77 nfet_05v0
M$3199 \$88 \$I4163 VSS VSS nfet_05v0 L=0.6U W=0.82U AS=0.282625P AD=0.3608P
+ PS=1.87U PD=2.52U
* device instance $3200 r180 *1 584.645,779 nfet_05v0
M$3200 VSS \$I2068 \$I4161 VSS nfet_05v0 L=0.6U W=0.36U AS=0.333P AD=0.0936P
+ PS=2.57U PD=0.88U
* device instance $3201 r180 *1 583.525,779 nfet_05v0
M$3201 \$I4164 \$I4161 VSS VSS nfet_05v0 L=0.6U W=0.36U AS=0.0936P AD=0.0432P
+ PS=0.88U PD=0.6U
* device instance $3202 r180 *1 582.685,779 nfet_05v0
M$3202 \$I4162 \$I4161 \$I4164 VSS nfet_05v0 L=0.6U W=0.36U AS=0.0432P
+ AD=0.369P PS=0.6U PD=2.77U
* device instance $3203 r180 *1 588.855,815.43 pfet_05v0
M$3203 \$I4174 \$I4169 \$I4170 VDD_DEC pfet_05v0 L=0.5U W=0.36U AS=0.3456P
+ AD=0.0612P PS=2.64U PD=0.7U
* device instance $3204 r180 *1 588.015,815.43 pfet_05v0
M$3204 \$I4174 \$I4169 VDD_DEC VDD_DEC pfet_05v0 L=0.5U W=0.36U AS=0.379P
+ AD=0.0612P PS=2.37U PD=0.7U
* device instance $3205 r180 *1 586.365,815.75 pfet_05v0
M$3205 \$I2212 \$I4170 VDD_DEC VDD_DEC pfet_05v0 L=0.5U W=1.22U AS=0.379P
+ AD=0.5368P PS=2.37U PD=3.32U
* device instance $3206 r180 *1 593.095,815.32 pfet_05v0
M$3206 VDD_DEC \$I2311 \$I4168 VDD_DEC pfet_05v0 L=0.5U W=0.36U AS=0.3852P
+ AD=0.1116P PS=2.86U PD=0.98U
* device instance $3207 r180 *1 591.975,815.32 pfet_05v0
M$3207 \$I4173 \$I4168 VDD_DEC VDD_DEC pfet_05v0 L=0.5U W=0.36U AS=0.1116P
+ AD=0.0612P PS=0.98U PD=0.7U
* device instance $3208 r180 *1 591.135,815.32 pfet_05v0
M$3208 \$I4173 \$I4168 \$I4169 VDD_DEC pfet_05v0 L=0.5U W=0.36U AS=0.3852P
+ AD=0.0612P PS=2.86U PD=0.7U
* device instance $3209 r180 *1 588.805,818.198 nfet_05v0
M$3209 \$I4172 \$I4169 \$I4170 VSS nfet_05v0 L=0.6U W=0.365U AS=0.3705P
+ AD=0.0438P PS=2.77U PD=0.605U
* device instance $3210 r180 *1 587.965,818.198 nfet_05v0
M$3210 VSS \$I4169 \$I4172 VSS nfet_05v0 L=0.6U W=0.365U AS=0.0438P
+ AD=0.282625P PS=0.605U PD=1.87U
* device instance $3211 r180 *1 586.315,817.97 nfet_05v0
M$3211 \$I2212 \$I4170 VSS VSS nfet_05v0 L=0.6U W=0.82U AS=0.282625P AD=0.3608P
+ PS=1.87U PD=2.52U
* device instance $3212 r180 *1 593.045,818.2 nfet_05v0
M$3212 VSS \$I2311 \$I4168 VSS nfet_05v0 L=0.6U W=0.36U AS=0.333P AD=0.0936P
+ PS=2.57U PD=0.88U
* device instance $3213 r180 *1 591.925,818.2 nfet_05v0
M$3213 \$I4171 \$I4168 VSS VSS nfet_05v0 L=0.6U W=0.36U AS=0.0936P AD=0.0432P
+ PS=0.88U PD=0.6U
* device instance $3214 r180 *1 591.085,818.2 nfet_05v0
M$3214 \$I4169 \$I4168 \$I4171 VSS nfet_05v0 L=0.6U W=0.36U AS=0.0432P
+ AD=0.369P PS=0.6U PD=2.77U
* device instance $3215 r180 *1 610.695,815.43 pfet_05v0
M$3215 \$I4181 \$I4176 \$I4177 VDD_DEC pfet_05v0 L=0.5U W=0.36U AS=0.3456P
+ AD=0.0612P PS=2.64U PD=0.7U
* device instance $3216 r180 *1 609.855,815.43 pfet_05v0
M$3216 \$I4181 \$I4176 VDD_DEC VDD_DEC pfet_05v0 L=0.5U W=0.36U AS=0.379P
+ AD=0.0612P PS=2.37U PD=0.7U
* device instance $3217 r180 *1 608.205,815.75 pfet_05v0
M$3217 \$I2211 \$I4177 VDD_DEC VDD_DEC pfet_05v0 L=0.5U W=1.22U AS=0.379P
+ AD=0.5368P PS=2.37U PD=3.32U
* device instance $3218 r180 *1 614.935,815.32 pfet_05v0
M$3218 VDD_DEC \$I2341 \$I4175 VDD_DEC pfet_05v0 L=0.5U W=0.36U AS=0.3852P
+ AD=0.1116P PS=2.86U PD=0.98U
* device instance $3219 r180 *1 613.815,815.32 pfet_05v0
M$3219 \$I4180 \$I4175 VDD_DEC VDD_DEC pfet_05v0 L=0.5U W=0.36U AS=0.1116P
+ AD=0.0612P PS=0.98U PD=0.7U
* device instance $3220 r180 *1 612.975,815.32 pfet_05v0
M$3220 \$I4180 \$I4175 \$I4176 VDD_DEC pfet_05v0 L=0.5U W=0.36U AS=0.3852P
+ AD=0.0612P PS=2.86U PD=0.7U
* device instance $3221 r180 *1 610.645,818.198 nfet_05v0
M$3221 \$I4179 \$I4176 \$I4177 VSS nfet_05v0 L=0.6U W=0.365U AS=0.3705P
+ AD=0.0438P PS=2.77U PD=0.605U
* device instance $3222 r180 *1 609.805,818.198 nfet_05v0
M$3222 VSS \$I4176 \$I4179 VSS nfet_05v0 L=0.6U W=0.365U AS=0.0438P
+ AD=0.282625P PS=0.605U PD=1.87U
* device instance $3223 r180 *1 608.155,817.97 nfet_05v0
M$3223 \$I2211 \$I4177 VSS VSS nfet_05v0 L=0.6U W=0.82U AS=0.282625P AD=0.3608P
+ PS=1.87U PD=2.52U
* device instance $3224 r180 *1 614.885,818.2 nfet_05v0
M$3224 VSS \$I2341 \$I4175 VSS nfet_05v0 L=0.6U W=0.36U AS=0.333P AD=0.0936P
+ PS=2.57U PD=0.88U
* device instance $3225 r180 *1 613.765,818.2 nfet_05v0
M$3225 \$I4178 \$I4175 VSS VSS nfet_05v0 L=0.6U W=0.36U AS=0.0936P AD=0.0432P
+ PS=0.88U PD=0.6U
* device instance $3226 r180 *1 612.925,818.2 nfet_05v0
M$3226 \$I4176 \$I4175 \$I4178 VSS nfet_05v0 L=0.6U W=0.36U AS=0.0432P
+ AD=0.369P PS=0.6U PD=2.77U
* device instance $3227 r180 *1 595.575,799.75 pfet_05v0
M$3227 \$I4188 \$I4183 \$I4184 VDD_DEC pfet_05v0 L=0.5U W=0.36U AS=0.3456P
+ AD=0.0612P PS=2.64U PD=0.7U
* device instance $3228 r180 *1 594.735,799.75 pfet_05v0
M$3228 \$I4188 \$I4183 VDD_DEC VDD_DEC pfet_05v0 L=0.5U W=0.36U AS=0.379P
+ AD=0.0612P PS=2.37U PD=0.7U
* device instance $3229 r180 *1 593.085,800.07 pfet_05v0
M$3229 \$I2173 \$I4184 VDD_DEC VDD_DEC pfet_05v0 L=0.5U W=1.22U AS=0.379P
+ AD=0.5368P PS=2.37U PD=3.32U
* device instance $3230 r180 *1 599.815,799.64 pfet_05v0
M$3230 VDD_DEC \$I2212 \$I4182 VDD_DEC pfet_05v0 L=0.5U W=0.36U AS=0.3852P
+ AD=0.1116P PS=2.86U PD=0.98U
* device instance $3231 r180 *1 598.695,799.64 pfet_05v0
M$3231 \$I4187 \$I4182 VDD_DEC VDD_DEC pfet_05v0 L=0.5U W=0.36U AS=0.1116P
+ AD=0.0612P PS=0.98U PD=0.7U
* device instance $3232 r180 *1 597.855,799.64 pfet_05v0
M$3232 \$I4187 \$I4182 \$I4183 VDD_DEC pfet_05v0 L=0.5U W=0.36U AS=0.3852P
+ AD=0.0612P PS=2.86U PD=0.7U
* device instance $3233 r180 *1 595.525,802.518 nfet_05v0
M$3233 \$I4186 \$I4183 \$I4184 VSS nfet_05v0 L=0.6U W=0.365U AS=0.3705P
+ AD=0.0438P PS=2.77U PD=0.605U
* device instance $3234 r180 *1 594.685,802.518 nfet_05v0
M$3234 VSS \$I4183 \$I4186 VSS nfet_05v0 L=0.6U W=0.365U AS=0.0438P
+ AD=0.282625P PS=0.605U PD=1.87U
* device instance $3235 r180 *1 593.035,802.29 nfet_05v0
M$3235 \$I2173 \$I4184 VSS VSS nfet_05v0 L=0.6U W=0.82U AS=0.282625P AD=0.3608P
+ PS=1.87U PD=2.52U
* device instance $3236 r180 *1 599.765,802.52 nfet_05v0
M$3236 VSS \$I2212 \$I4182 VSS nfet_05v0 L=0.6U W=0.36U AS=0.333P AD=0.0936P
+ PS=2.57U PD=0.88U
* device instance $3237 r180 *1 598.645,802.52 nfet_05v0
M$3237 \$I4185 \$I4182 VSS VSS nfet_05v0 L=0.6U W=0.36U AS=0.0936P AD=0.0432P
+ PS=0.88U PD=0.6U
* device instance $3238 r180 *1 597.805,802.52 nfet_05v0
M$3238 \$I4183 \$I4182 \$I4185 VSS nfet_05v0 L=0.6U W=0.36U AS=0.0432P
+ AD=0.369P PS=0.6U PD=2.77U
* device instance $3239 r180 *1 505.975,807.59 pfet_05v0
M$3239 \$I4195 \$I4190 \$I4191 VDD_DEC pfet_05v0 L=0.5U W=0.36U AS=0.3456P
+ AD=0.0612P PS=2.64U PD=0.7U
* device instance $3240 r180 *1 505.135,807.59 pfet_05v0
M$3240 \$I4195 \$I4190 VDD_DEC VDD_DEC pfet_05v0 L=0.5U W=0.36U AS=0.379P
+ AD=0.0612P PS=2.37U PD=0.7U
* device instance $3241 r180 *1 503.485,807.91 pfet_05v0
M$3241 \$I2353 \$I4191 VDD_DEC VDD_DEC pfet_05v0 L=0.5U W=1.22U AS=0.379P
+ AD=0.5368P PS=2.37U PD=3.32U
* device instance $3242 r180 *1 510.215,807.48 pfet_05v0
M$3242 VDD_DEC \$I2355 \$I4189 VDD_DEC pfet_05v0 L=0.5U W=0.36U AS=0.3852P
+ AD=0.1116P PS=2.86U PD=0.98U
* device instance $3243 r180 *1 509.095,807.48 pfet_05v0
M$3243 \$I4194 \$I4189 VDD_DEC VDD_DEC pfet_05v0 L=0.5U W=0.36U AS=0.1116P
+ AD=0.0612P PS=0.98U PD=0.7U
* device instance $3244 r180 *1 508.255,807.48 pfet_05v0
M$3244 \$I4194 \$I4189 \$I4190 VDD_DEC pfet_05v0 L=0.5U W=0.36U AS=0.3852P
+ AD=0.0612P PS=2.86U PD=0.7U
* device instance $3245 r180 *1 505.925,810.358 nfet_05v0
M$3245 \$I4193 \$I4190 \$I4191 VSS nfet_05v0 L=0.6U W=0.365U AS=0.3705P
+ AD=0.0438P PS=2.77U PD=0.605U
* device instance $3246 r180 *1 505.085,810.358 nfet_05v0
M$3246 VSS \$I4190 \$I4193 VSS nfet_05v0 L=0.6U W=0.365U AS=0.0438P
+ AD=0.282625P PS=0.605U PD=1.87U
* device instance $3247 r180 *1 503.435,810.13 nfet_05v0
M$3247 \$I2353 \$I4191 VSS VSS nfet_05v0 L=0.6U W=0.82U AS=0.282625P AD=0.3608P
+ PS=1.87U PD=2.52U
* device instance $3248 r180 *1 510.165,810.36 nfet_05v0
M$3248 VSS \$I2355 \$I4189 VSS nfet_05v0 L=0.6U W=0.36U AS=0.333P AD=0.0936P
+ PS=2.57U PD=0.88U
* device instance $3249 r180 *1 509.045,810.36 nfet_05v0
M$3249 \$I4192 \$I4189 VSS VSS nfet_05v0 L=0.6U W=0.36U AS=0.0936P AD=0.0432P
+ PS=0.88U PD=0.6U
* device instance $3250 r180 *1 508.205,810.36 nfet_05v0
M$3250 \$I4190 \$I4189 \$I4192 VSS nfet_05v0 L=0.6U W=0.36U AS=0.0432P
+ AD=0.369P PS=0.6U PD=2.77U
* device instance $3251 r180 *1 653.255,807.59 pfet_05v0
M$3251 \$I4202 \$I4197 \$I4198 VDD_DEC pfet_05v0 L=0.5U W=0.36U AS=0.3456P
+ AD=0.0612P PS=2.64U PD=0.7U
* device instance $3252 r180 *1 652.415,807.59 pfet_05v0
M$3252 \$I4202 \$I4197 VDD_DEC VDD_DEC pfet_05v0 L=0.5U W=0.36U AS=0.379P
+ AD=0.0612P PS=2.37U PD=0.7U
* device instance $3253 r180 *1 650.765,807.91 pfet_05v0
M$3253 \$I2342 \$I4198 VDD_DEC VDD_DEC pfet_05v0 L=0.5U W=1.22U AS=0.379P
+ AD=0.5368P PS=2.37U PD=3.32U
* device instance $3254 r180 *1 657.495,807.48 pfet_05v0
M$3254 VDD_DEC \$I2344 \$I4196 VDD_DEC pfet_05v0 L=0.5U W=0.36U AS=0.3852P
+ AD=0.1116P PS=2.86U PD=0.98U
* device instance $3255 r180 *1 656.375,807.48 pfet_05v0
M$3255 \$I4201 \$I4196 VDD_DEC VDD_DEC pfet_05v0 L=0.5U W=0.36U AS=0.1116P
+ AD=0.0612P PS=0.98U PD=0.7U
* device instance $3256 r180 *1 655.535,807.48 pfet_05v0
M$3256 \$I4201 \$I4196 \$I4197 VDD_DEC pfet_05v0 L=0.5U W=0.36U AS=0.3852P
+ AD=0.0612P PS=2.86U PD=0.7U
* device instance $3257 r180 *1 653.205,810.358 nfet_05v0
M$3257 \$I4200 \$I4197 \$I4198 VSS nfet_05v0 L=0.6U W=0.365U AS=0.3705P
+ AD=0.0438P PS=2.77U PD=0.605U
* device instance $3258 r180 *1 652.365,810.358 nfet_05v0
M$3258 VSS \$I4197 \$I4200 VSS nfet_05v0 L=0.6U W=0.365U AS=0.0438P
+ AD=0.282625P PS=0.605U PD=1.87U
* device instance $3259 r180 *1 650.715,810.13 nfet_05v0
M$3259 \$I2342 \$I4198 VSS VSS nfet_05v0 L=0.6U W=0.82U AS=0.282625P AD=0.3608P
+ PS=1.87U PD=2.52U
* device instance $3260 r180 *1 657.445,810.36 nfet_05v0
M$3260 VSS \$I2344 \$I4196 VSS nfet_05v0 L=0.6U W=0.36U AS=0.333P AD=0.0936P
+ PS=2.57U PD=0.88U
* device instance $3261 r180 *1 656.325,810.36 nfet_05v0
M$3261 \$I4199 \$I4196 VSS VSS nfet_05v0 L=0.6U W=0.36U AS=0.0936P AD=0.0432P
+ PS=0.88U PD=0.6U
* device instance $3262 r180 *1 655.485,810.36 nfet_05v0
M$3262 \$I4197 \$I4196 \$I4199 VSS nfet_05v0 L=0.6U W=0.36U AS=0.0432P
+ AD=0.369P PS=0.6U PD=2.77U
* device instance $3263 r180 *1 540.695,807.59 pfet_05v0
M$3263 \$I4209 \$I4204 \$I4205 VDD_DEC pfet_05v0 L=0.5U W=0.36U AS=0.3456P
+ AD=0.0612P PS=2.64U PD=0.7U
* device instance $3264 r180 *1 539.855,807.59 pfet_05v0
M$3264 \$I4209 \$I4204 VDD_DEC VDD_DEC pfet_05v0 L=0.5U W=0.36U AS=0.379P
+ AD=0.0612P PS=2.37U PD=0.7U
* device instance $3265 r180 *1 538.205,807.91 pfet_05v0
M$3265 \$I2379 \$I4205 VDD_DEC VDD_DEC pfet_05v0 L=0.5U W=1.22U AS=0.379P
+ AD=0.5368P PS=2.37U PD=3.32U
* device instance $3266 r180 *1 544.935,807.48 pfet_05v0
M$3266 VDD_DEC \$I2334 \$I4203 VDD_DEC pfet_05v0 L=0.5U W=0.36U AS=0.3852P
+ AD=0.1116P PS=2.86U PD=0.98U
* device instance $3267 r180 *1 543.815,807.48 pfet_05v0
M$3267 \$I4208 \$I4203 VDD_DEC VDD_DEC pfet_05v0 L=0.5U W=0.36U AS=0.1116P
+ AD=0.0612P PS=0.98U PD=0.7U
* device instance $3268 r180 *1 542.975,807.48 pfet_05v0
M$3268 \$I4208 \$I4203 \$I4204 VDD_DEC pfet_05v0 L=0.5U W=0.36U AS=0.3852P
+ AD=0.0612P PS=2.86U PD=0.7U
* device instance $3269 r180 *1 540.645,810.358 nfet_05v0
M$3269 \$I4207 \$I4204 \$I4205 VSS nfet_05v0 L=0.6U W=0.365U AS=0.3705P
+ AD=0.0438P PS=2.77U PD=0.605U
* device instance $3270 r180 *1 539.805,810.358 nfet_05v0
M$3270 VSS \$I4204 \$I4207 VSS nfet_05v0 L=0.6U W=0.365U AS=0.0438P
+ AD=0.282625P PS=0.605U PD=1.87U
* device instance $3271 r180 *1 538.155,810.13 nfet_05v0
M$3271 \$I2379 \$I4205 VSS VSS nfet_05v0 L=0.6U W=0.82U AS=0.282625P AD=0.3608P
+ PS=1.87U PD=2.52U
* device instance $3272 r180 *1 544.885,810.36 nfet_05v0
M$3272 VSS \$I2334 \$I4203 VSS nfet_05v0 L=0.6U W=0.36U AS=0.333P AD=0.0936P
+ PS=2.57U PD=0.88U
* device instance $3273 r180 *1 543.765,810.36 nfet_05v0
M$3273 \$I4206 \$I4203 VSS VSS nfet_05v0 L=0.6U W=0.36U AS=0.0936P AD=0.0432P
+ PS=0.88U PD=0.6U
* device instance $3274 r180 *1 542.925,810.36 nfet_05v0
M$3274 \$I4204 \$I4203 \$I4206 VSS nfet_05v0 L=0.6U W=0.36U AS=0.0432P
+ AD=0.369P PS=0.6U PD=2.77U
* device instance $3275 r180 *1 569.815,815.43 pfet_05v0
M$3275 \$I4216 \$I4211 \$I4212 VDD_DEC pfet_05v0 L=0.5U W=0.36U AS=0.3456P
+ AD=0.0612P PS=2.64U PD=0.7U
* device instance $3276 r180 *1 568.975,815.43 pfet_05v0
M$3276 \$I4216 \$I4211 VDD_DEC VDD_DEC pfet_05v0 L=0.5U W=0.36U AS=0.379P
+ AD=0.0612P PS=2.37U PD=0.7U
* device instance $3277 r180 *1 567.325,815.75 pfet_05v0
M$3277 \$I2280 \$I4212 VDD_DEC VDD_DEC pfet_05v0 L=0.5U W=1.22U AS=0.379P
+ AD=0.5368P PS=2.37U PD=3.32U
* device instance $3278 r180 *1 574.055,815.32 pfet_05v0
M$3278 VDD_DEC \$I2342 \$I4210 VDD_DEC pfet_05v0 L=0.5U W=0.36U AS=0.3852P
+ AD=0.1116P PS=2.86U PD=0.98U
* device instance $3279 r180 *1 572.935,815.32 pfet_05v0
M$3279 \$I4215 \$I4210 VDD_DEC VDD_DEC pfet_05v0 L=0.5U W=0.36U AS=0.1116P
+ AD=0.0612P PS=0.98U PD=0.7U
* device instance $3280 r180 *1 572.095,815.32 pfet_05v0
M$3280 \$I4215 \$I4210 \$I4211 VDD_DEC pfet_05v0 L=0.5U W=0.36U AS=0.3852P
+ AD=0.0612P PS=2.86U PD=0.7U
* device instance $3281 r180 *1 569.765,818.198 nfet_05v0
M$3281 \$I4214 \$I4211 \$I4212 VSS nfet_05v0 L=0.6U W=0.365U AS=0.3705P
+ AD=0.0438P PS=2.77U PD=0.605U
* device instance $3282 r180 *1 568.925,818.198 nfet_05v0
M$3282 VSS \$I4211 \$I4214 VSS nfet_05v0 L=0.6U W=0.365U AS=0.0438P
+ AD=0.282625P PS=0.605U PD=1.87U
* device instance $3283 r180 *1 567.275,817.97 nfet_05v0
M$3283 \$I2280 \$I4212 VSS VSS nfet_05v0 L=0.6U W=0.82U AS=0.282625P AD=0.3608P
+ PS=1.87U PD=2.52U
* device instance $3284 r180 *1 574.005,818.2 nfet_05v0
M$3284 VSS \$I2342 \$I4210 VSS nfet_05v0 L=0.6U W=0.36U AS=0.333P AD=0.0936P
+ PS=2.57U PD=0.88U
* device instance $3285 r180 *1 572.885,818.2 nfet_05v0
M$3285 \$I4213 \$I4210 VSS VSS nfet_05v0 L=0.6U W=0.36U AS=0.0936P AD=0.0432P
+ PS=0.88U PD=0.6U
* device instance $3286 r180 *1 572.045,818.2 nfet_05v0
M$3286 \$I4211 \$I4210 \$I4213 VSS nfet_05v0 L=0.6U W=0.36U AS=0.0432P
+ AD=0.369P PS=0.6U PD=2.77U
* device instance $3287 r180 *1 666.135,815.43 pfet_05v0
M$3287 \$I4223 \$I4218 \$I4219 VDD_DEC pfet_05v0 L=0.5U W=0.36U AS=0.3456P
+ AD=0.0612P PS=2.64U PD=0.7U
* device instance $3288 r180 *1 665.295,815.43 pfet_05v0
M$3288 \$I4223 \$I4218 VDD_DEC VDD_DEC pfet_05v0 L=0.5U W=0.36U AS=0.379P
+ AD=0.0612P PS=2.37U PD=0.7U
* device instance $3289 r180 *1 663.645,815.75 pfet_05v0
M$3289 \$18 \$I4219 VDD_DEC VDD_DEC pfet_05v0 L=0.5U W=1.22U AS=0.379P
+ AD=0.5368P PS=2.37U PD=3.32U
* device instance $3290 r180 *1 670.375,815.32 pfet_05v0
M$3290 VDD_DEC \$I2370 \$I4217 VDD_DEC pfet_05v0 L=0.5U W=0.36U AS=0.3852P
+ AD=0.1116P PS=2.86U PD=0.98U
* device instance $3291 r180 *1 669.255,815.32 pfet_05v0
M$3291 \$I4222 \$I4217 VDD_DEC VDD_DEC pfet_05v0 L=0.5U W=0.36U AS=0.1116P
+ AD=0.0612P PS=0.98U PD=0.7U
* device instance $3292 r180 *1 668.415,815.32 pfet_05v0
M$3292 \$I4222 \$I4217 \$I4218 VDD_DEC pfet_05v0 L=0.5U W=0.36U AS=0.3852P
+ AD=0.0612P PS=2.86U PD=0.7U
* device instance $3293 r180 *1 666.085,818.198 nfet_05v0
M$3293 \$I4221 \$I4218 \$I4219 VSS nfet_05v0 L=0.6U W=0.365U AS=0.3705P
+ AD=0.0438P PS=2.77U PD=0.605U
* device instance $3294 r180 *1 665.245,818.198 nfet_05v0
M$3294 VSS \$I4218 \$I4221 VSS nfet_05v0 L=0.6U W=0.365U AS=0.0438P
+ AD=0.282625P PS=0.605U PD=1.87U
* device instance $3295 r180 *1 663.595,817.97 nfet_05v0
M$3295 \$18 \$I4219 VSS VSS nfet_05v0 L=0.6U W=0.82U AS=0.282625P AD=0.3608P
+ PS=1.87U PD=2.52U
* device instance $3296 r180 *1 670.325,818.2 nfet_05v0
M$3296 VSS \$I2370 \$I4217 VSS nfet_05v0 L=0.6U W=0.36U AS=0.333P AD=0.0936P
+ PS=2.57U PD=0.88U
* device instance $3297 r180 *1 669.205,818.2 nfet_05v0
M$3297 \$I4220 \$I4217 VSS VSS nfet_05v0 L=0.6U W=0.36U AS=0.0936P AD=0.0432P
+ PS=0.88U PD=0.6U
* device instance $3298 r180 *1 668.365,818.2 nfet_05v0
M$3298 \$I4218 \$I4217 \$I4220 VSS nfet_05v0 L=0.6U W=0.36U AS=0.0432P
+ AD=0.369P PS=0.6U PD=2.77U
* device instance $3299 r180 *1 550.775,815.43 pfet_05v0
M$3299 \$I4230 \$I4225 \$I4226 VDD_DEC pfet_05v0 L=0.5U W=0.36U AS=0.3456P
+ AD=0.0612P PS=2.64U PD=0.7U
* device instance $3300 r180 *1 549.935,815.43 pfet_05v0
M$3300 \$I4230 \$I4225 VDD_DEC VDD_DEC pfet_05v0 L=0.5U W=0.36U AS=0.379P
+ AD=0.0612P PS=2.37U PD=0.7U
* device instance $3301 r180 *1 548.285,815.75 pfet_05v0
M$3301 \$I2332 \$I4226 VDD_DEC VDD_DEC pfet_05v0 L=0.5U W=1.22U AS=0.379P
+ AD=0.5368P PS=2.37U PD=3.32U
* device instance $3302 r180 *1 555.015,815.32 pfet_05v0
M$3302 VDD_DEC \$I2337 \$I4224 VDD_DEC pfet_05v0 L=0.5U W=0.36U AS=0.3852P
+ AD=0.1116P PS=2.86U PD=0.98U
* device instance $3303 r180 *1 553.895,815.32 pfet_05v0
M$3303 \$I4229 \$I4224 VDD_DEC VDD_DEC pfet_05v0 L=0.5U W=0.36U AS=0.1116P
+ AD=0.0612P PS=0.98U PD=0.7U
* device instance $3304 r180 *1 553.055,815.32 pfet_05v0
M$3304 \$I4229 \$I4224 \$I4225 VDD_DEC pfet_05v0 L=0.5U W=0.36U AS=0.3852P
+ AD=0.0612P PS=2.86U PD=0.7U
* device instance $3305 r180 *1 550.725,818.198 nfet_05v0
M$3305 \$I4228 \$I4225 \$I4226 VSS nfet_05v0 L=0.6U W=0.365U AS=0.3705P
+ AD=0.0438P PS=2.77U PD=0.605U
* device instance $3306 r180 *1 549.885,818.198 nfet_05v0
M$3306 VSS \$I4225 \$I4228 VSS nfet_05v0 L=0.6U W=0.365U AS=0.0438P
+ AD=0.282625P PS=0.605U PD=1.87U
* device instance $3307 r180 *1 548.235,817.97 nfet_05v0
M$3307 \$I2332 \$I4226 VSS VSS nfet_05v0 L=0.6U W=0.82U AS=0.282625P AD=0.3608P
+ PS=1.87U PD=2.52U
* device instance $3308 r180 *1 554.965,818.2 nfet_05v0
M$3308 VSS \$I2337 \$I4224 VSS nfet_05v0 L=0.6U W=0.36U AS=0.333P AD=0.0936P
+ PS=2.57U PD=0.88U
* device instance $3309 r180 *1 553.845,818.2 nfet_05v0
M$3309 \$I4227 \$I4224 VSS VSS nfet_05v0 L=0.6U W=0.36U AS=0.0936P AD=0.0432P
+ PS=0.88U PD=0.6U
* device instance $3310 r180 *1 553.005,818.2 nfet_05v0
M$3310 \$I4225 \$I4224 \$I4227 VSS nfet_05v0 L=0.6U W=0.36U AS=0.0432P
+ AD=0.369P PS=0.6U PD=2.77U
* device instance $3311 r180 *1 635.335,807.59 pfet_05v0
M$3311 \$I4237 \$I4232 \$I4233 VDD_DEC pfet_05v0 L=0.5U W=0.36U AS=0.3456P
+ AD=0.0612P PS=2.64U PD=0.7U
* device instance $3312 r180 *1 634.495,807.59 pfet_05v0
M$3312 \$I4237 \$I4232 VDD_DEC VDD_DEC pfet_05v0 L=0.5U W=0.36U AS=0.379P
+ AD=0.0612P PS=2.37U PD=0.7U
* device instance $3313 r180 *1 632.845,807.91 pfet_05v0
M$3313 \$I2286 \$I4233 VDD_DEC VDD_DEC pfet_05v0 L=0.5U W=1.22U AS=0.379P
+ AD=0.5368P PS=2.37U PD=3.32U
* device instance $3314 r180 *1 639.575,807.48 pfet_05v0
M$3314 VDD_DEC \$I2310 \$I4231 VDD_DEC pfet_05v0 L=0.5U W=0.36U AS=0.3852P
+ AD=0.1116P PS=2.86U PD=0.98U
* device instance $3315 r180 *1 638.455,807.48 pfet_05v0
M$3315 \$I4236 \$I4231 VDD_DEC VDD_DEC pfet_05v0 L=0.5U W=0.36U AS=0.1116P
+ AD=0.0612P PS=0.98U PD=0.7U
* device instance $3316 r180 *1 637.615,807.48 pfet_05v0
M$3316 \$I4236 \$I4231 \$I4232 VDD_DEC pfet_05v0 L=0.5U W=0.36U AS=0.3852P
+ AD=0.0612P PS=2.86U PD=0.7U
* device instance $3317 r180 *1 635.285,810.358 nfet_05v0
M$3317 \$I4235 \$I4232 \$I4233 VSS nfet_05v0 L=0.6U W=0.365U AS=0.3705P
+ AD=0.0438P PS=2.77U PD=0.605U
* device instance $3318 r180 *1 634.445,810.358 nfet_05v0
M$3318 VSS \$I4232 \$I4235 VSS nfet_05v0 L=0.6U W=0.365U AS=0.0438P
+ AD=0.282625P PS=0.605U PD=1.87U
* device instance $3319 r180 *1 632.795,810.13 nfet_05v0
M$3319 \$I2286 \$I4233 VSS VSS nfet_05v0 L=0.6U W=0.82U AS=0.282625P AD=0.3608P
+ PS=1.87U PD=2.52U
* device instance $3320 r180 *1 639.525,810.36 nfet_05v0
M$3320 VSS \$I2310 \$I4231 VSS nfet_05v0 L=0.6U W=0.36U AS=0.333P AD=0.0936P
+ PS=2.57U PD=0.88U
* device instance $3321 r180 *1 638.405,810.36 nfet_05v0
M$3321 \$I4234 \$I4231 VSS VSS nfet_05v0 L=0.6U W=0.36U AS=0.0936P AD=0.0432P
+ PS=0.88U PD=0.6U
* device instance $3322 r180 *1 637.565,810.36 nfet_05v0
M$3322 \$I4232 \$I4231 \$I4234 VSS nfet_05v0 L=0.6U W=0.36U AS=0.0432P
+ AD=0.369P PS=0.6U PD=2.77U
* device instance $3323 r180 *1 531.735,807.59 pfet_05v0
M$3323 \$I4244 \$I4239 \$I4240 VDD_DEC pfet_05v0 L=0.5U W=0.36U AS=0.3456P
+ AD=0.0612P PS=2.64U PD=0.7U
* device instance $3324 r180 *1 530.895,807.59 pfet_05v0
M$3324 \$I4244 \$I4239 VDD_DEC VDD_DEC pfet_05v0 L=0.5U W=0.36U AS=0.379P
+ AD=0.0612P PS=2.37U PD=0.7U
* device instance $3325 r180 *1 529.245,807.91 pfet_05v0
M$3325 \$I2250 \$I4240 VDD_DEC VDD_DEC pfet_05v0 L=0.5U W=1.22U AS=0.379P
+ AD=0.5368P PS=2.37U PD=3.32U
* device instance $3326 r180 *1 535.975,807.48 pfet_05v0
M$3326 VDD_DEC \$I2170 \$I4238 VDD_DEC pfet_05v0 L=0.5U W=0.36U AS=0.3852P
+ AD=0.1116P PS=2.86U PD=0.98U
* device instance $3327 r180 *1 534.855,807.48 pfet_05v0
M$3327 \$I4243 \$I4238 VDD_DEC VDD_DEC pfet_05v0 L=0.5U W=0.36U AS=0.1116P
+ AD=0.0612P PS=0.98U PD=0.7U
* device instance $3328 r180 *1 534.015,807.48 pfet_05v0
M$3328 \$I4243 \$I4238 \$I4239 VDD_DEC pfet_05v0 L=0.5U W=0.36U AS=0.3852P
+ AD=0.0612P PS=2.86U PD=0.7U
* device instance $3329 r180 *1 531.685,810.358 nfet_05v0
M$3329 \$I4242 \$I4239 \$I4240 VSS nfet_05v0 L=0.6U W=0.365U AS=0.3705P
+ AD=0.0438P PS=2.77U PD=0.605U
* device instance $3330 r180 *1 530.845,810.358 nfet_05v0
M$3330 VSS \$I4239 \$I4242 VSS nfet_05v0 L=0.6U W=0.365U AS=0.0438P
+ AD=0.282625P PS=0.605U PD=1.87U
* device instance $3331 r180 *1 529.195,810.13 nfet_05v0
M$3331 \$I2250 \$I4240 VSS VSS nfet_05v0 L=0.6U W=0.82U AS=0.282625P AD=0.3608P
+ PS=1.87U PD=2.52U
* device instance $3332 r180 *1 535.925,810.36 nfet_05v0
M$3332 VSS \$I2170 \$I4238 VSS nfet_05v0 L=0.6U W=0.36U AS=0.333P AD=0.0936P
+ PS=2.57U PD=0.88U
* device instance $3333 r180 *1 534.805,810.36 nfet_05v0
M$3333 \$I4241 \$I4238 VSS VSS nfet_05v0 L=0.6U W=0.36U AS=0.0936P AD=0.0432P
+ PS=0.88U PD=0.6U
* device instance $3334 r180 *1 533.965,810.36 nfet_05v0
M$3334 \$I4239 \$I4238 \$I4241 VSS nfet_05v0 L=0.6U W=0.36U AS=0.0432P
+ AD=0.369P PS=0.6U PD=2.77U
* device instance $3335 r180 *1 533.975,815.43 pfet_05v0
M$3335 \$I4251 \$I4246 \$I4247 VDD_DEC pfet_05v0 L=0.5U W=0.36U AS=0.3456P
+ AD=0.0612P PS=2.64U PD=0.7U
* device instance $3336 r180 *1 533.135,815.43 pfet_05v0
M$3336 \$I4251 \$I4246 VDD_DEC VDD_DEC pfet_05v0 L=0.5U W=0.36U AS=0.379P
+ AD=0.0612P PS=2.37U PD=0.7U
* device instance $3337 r180 *1 531.485,815.75 pfet_05v0
M$3337 \$I2331 \$I4247 VDD_DEC VDD_DEC pfet_05v0 L=0.5U W=1.22U AS=0.379P
+ AD=0.5368P PS=2.37U PD=3.32U
* device instance $3338 r180 *1 538.215,815.32 pfet_05v0
M$3338 VDD_DEC \$I2342 \$I4245 VDD_DEC pfet_05v0 L=0.5U W=0.36U AS=0.3852P
+ AD=0.1116P PS=2.86U PD=0.98U
* device instance $3339 r180 *1 537.095,815.32 pfet_05v0
M$3339 \$I4250 \$I4245 VDD_DEC VDD_DEC pfet_05v0 L=0.5U W=0.36U AS=0.1116P
+ AD=0.0612P PS=0.98U PD=0.7U
* device instance $3340 r180 *1 536.255,815.32 pfet_05v0
M$3340 \$I4250 \$I4245 \$I4246 VDD_DEC pfet_05v0 L=0.5U W=0.36U AS=0.3852P
+ AD=0.0612P PS=2.86U PD=0.7U
* device instance $3341 r180 *1 533.925,818.198 nfet_05v0
M$3341 \$I4249 \$I4246 \$I4247 VSS nfet_05v0 L=0.6U W=0.365U AS=0.3705P
+ AD=0.0438P PS=2.77U PD=0.605U
* device instance $3342 r180 *1 533.085,818.198 nfet_05v0
M$3342 VSS \$I4246 \$I4249 VSS nfet_05v0 L=0.6U W=0.365U AS=0.0438P
+ AD=0.282625P PS=0.605U PD=1.87U
* device instance $3343 r180 *1 531.435,817.97 nfet_05v0
M$3343 \$I2331 \$I4247 VSS VSS nfet_05v0 L=0.6U W=0.82U AS=0.282625P AD=0.3608P
+ PS=1.87U PD=2.52U
* device instance $3344 r180 *1 538.165,818.2 nfet_05v0
M$3344 VSS \$I2342 \$I4245 VSS nfet_05v0 L=0.6U W=0.36U AS=0.333P AD=0.0936P
+ PS=2.57U PD=0.88U
* device instance $3345 r180 *1 537.045,818.2 nfet_05v0
M$3345 \$I4248 \$I4245 VSS VSS nfet_05v0 L=0.6U W=0.36U AS=0.0936P AD=0.0432P
+ PS=0.88U PD=0.6U
* device instance $3346 r180 *1 536.205,818.2 nfet_05v0
M$3346 \$I4246 \$I4245 \$I4248 VSS nfet_05v0 L=0.6U W=0.36U AS=0.0432P
+ AD=0.369P PS=0.6U PD=2.77U
* device instance $3347 r180 *1 649.335,784.07 pfet_05v0
M$3347 \$I4258 \$I4253 \$I4254 VDD_DEC pfet_05v0 L=0.5U W=0.36U AS=0.3456P
+ AD=0.0612P PS=2.64U PD=0.7U
* device instance $3348 r180 *1 648.495,784.07 pfet_05v0
M$3348 \$I4258 \$I4253 VDD_DEC VDD_DEC pfet_05v0 L=0.5U W=0.36U AS=0.379P
+ AD=0.0612P PS=2.37U PD=0.7U
* device instance $3349 r180 *1 646.845,784.39 pfet_05v0
M$3349 \$I2138 \$I4254 VDD_DEC VDD_DEC pfet_05v0 L=0.5U W=1.22U AS=0.379P
+ AD=0.5368P PS=2.37U PD=3.32U
* device instance $3350 r180 *1 653.575,783.96 pfet_05v0
M$3350 VDD_DEC \$I2139 \$I4252 VDD_DEC pfet_05v0 L=0.5U W=0.36U AS=0.3852P
+ AD=0.1116P PS=2.86U PD=0.98U
* device instance $3351 r180 *1 652.455,783.96 pfet_05v0
M$3351 \$I4257 \$I4252 VDD_DEC VDD_DEC pfet_05v0 L=0.5U W=0.36U AS=0.1116P
+ AD=0.0612P PS=0.98U PD=0.7U
* device instance $3352 r180 *1 651.615,783.96 pfet_05v0
M$3352 \$I4257 \$I4252 \$I4253 VDD_DEC pfet_05v0 L=0.5U W=0.36U AS=0.3852P
+ AD=0.0612P PS=2.86U PD=0.7U
* device instance $3353 r180 *1 649.285,786.838 nfet_05v0
M$3353 \$I4256 \$I4253 \$I4254 VSS nfet_05v0 L=0.6U W=0.365U AS=0.3705P
+ AD=0.0438P PS=2.77U PD=0.605U
* device instance $3354 r180 *1 648.445,786.838 nfet_05v0
M$3354 VSS \$I4253 \$I4256 VSS nfet_05v0 L=0.6U W=0.365U AS=0.0438P
+ AD=0.282625P PS=0.605U PD=1.87U
* device instance $3355 r180 *1 646.795,786.61 nfet_05v0
M$3355 \$I2138 \$I4254 VSS VSS nfet_05v0 L=0.6U W=0.82U AS=0.282625P AD=0.3608P
+ PS=1.87U PD=2.52U
* device instance $3356 r180 *1 653.525,786.84 nfet_05v0
M$3356 VSS \$I2139 \$I4252 VSS nfet_05v0 L=0.6U W=0.36U AS=0.333P AD=0.0936P
+ PS=2.57U PD=0.88U
* device instance $3357 r180 *1 652.405,786.84 nfet_05v0
M$3357 \$I4255 \$I4252 VSS VSS nfet_05v0 L=0.6U W=0.36U AS=0.0936P AD=0.0432P
+ PS=0.88U PD=0.6U
* device instance $3358 r180 *1 651.565,786.84 nfet_05v0
M$3358 \$I4253 \$I4252 \$I4255 VSS nfet_05v0 L=0.6U W=0.36U AS=0.0432P
+ AD=0.369P PS=0.6U PD=2.77U
* device instance $3359 r180 *1 657.175,823.27 pfet_05v0
M$3359 \$I4265 \$I4260 \$I4261 VDD_DEC pfet_05v0 L=0.5U W=0.36U AS=0.3456P
+ AD=0.0612P PS=2.64U PD=0.7U
* device instance $3360 r180 *1 656.335,823.27 pfet_05v0
M$3360 \$I4265 \$I4260 VDD_DEC VDD_DEC pfet_05v0 L=0.5U W=0.36U AS=0.379P
+ AD=0.0612P PS=2.37U PD=0.7U
* device instance $3361 r180 *1 654.685,823.59 pfet_05v0
M$3361 \$17 \$I4261 VDD_DEC VDD_DEC pfet_05v0 L=0.5U W=1.22U AS=0.379P
+ AD=0.5368P PS=2.37U PD=3.32U
* device instance $3362 r180 *1 661.415,823.16 pfet_05v0
M$3362 VDD_DEC \$I2409 \$I4259 VDD_DEC pfet_05v0 L=0.5U W=0.36U AS=0.3852P
+ AD=0.1116P PS=2.86U PD=0.98U
* device instance $3363 r180 *1 660.295,823.16 pfet_05v0
M$3363 \$I4264 \$I4259 VDD_DEC VDD_DEC pfet_05v0 L=0.5U W=0.36U AS=0.1116P
+ AD=0.0612P PS=0.98U PD=0.7U
* device instance $3364 r180 *1 659.455,823.16 pfet_05v0
M$3364 \$I4264 \$I4259 \$I4260 VDD_DEC pfet_05v0 L=0.5U W=0.36U AS=0.3852P
+ AD=0.0612P PS=2.86U PD=0.7U
* device instance $3365 r180 *1 657.125,826.038 nfet_05v0
M$3365 \$I4263 \$I4260 \$I4261 VSS nfet_05v0 L=0.6U W=0.365U AS=0.3705P
+ AD=0.0438P PS=2.77U PD=0.605U
* device instance $3366 r180 *1 656.285,826.038 nfet_05v0
M$3366 VSS \$I4260 \$I4263 VSS nfet_05v0 L=0.6U W=0.365U AS=0.0438P
+ AD=0.282625P PS=0.605U PD=1.87U
* device instance $3367 r180 *1 654.635,825.81 nfet_05v0
M$3367 \$17 \$I4261 VSS VSS nfet_05v0 L=0.6U W=0.82U AS=0.282625P AD=0.3608P
+ PS=1.87U PD=2.52U
* device instance $3368 r180 *1 661.365,826.04 nfet_05v0
M$3368 VSS \$I2409 \$I4259 VSS nfet_05v0 L=0.6U W=0.36U AS=0.333P AD=0.0936P
+ PS=2.57U PD=0.88U
* device instance $3369 r180 *1 660.245,826.04 nfet_05v0
M$3369 \$I4262 \$I4259 VSS VSS nfet_05v0 L=0.6U W=0.36U AS=0.0936P AD=0.0432P
+ PS=0.88U PD=0.6U
* device instance $3370 r180 *1 659.405,826.04 nfet_05v0
M$3370 \$I4260 \$I4259 \$I4262 VSS nfet_05v0 L=0.6U W=0.36U AS=0.0432P
+ AD=0.369P PS=0.6U PD=2.77U
* device instance $3371 r180 *1 509.895,791.91 pfet_05v0
M$3371 \$I4272 \$I4267 \$I4268 VDD_DEC pfet_05v0 L=0.5U W=0.36U AS=0.3456P
+ AD=0.0612P PS=2.64U PD=0.7U
* device instance $3372 r180 *1 509.055,791.91 pfet_05v0
M$3372 \$I4272 \$I4267 VDD_DEC VDD_DEC pfet_05v0 L=0.5U W=0.36U AS=0.379P
+ AD=0.0612P PS=2.37U PD=0.7U
* device instance $3373 r180 *1 507.405,792.23 pfet_05v0
M$3373 \$I2197 \$I4268 VDD_DEC VDD_DEC pfet_05v0 L=0.5U W=1.22U AS=0.379P
+ AD=0.5368P PS=2.37U PD=3.32U
* device instance $3374 r180 *1 514.135,791.8 pfet_05v0
M$3374 VDD_DEC \$I2200 \$I4266 VDD_DEC pfet_05v0 L=0.5U W=0.36U AS=0.3852P
+ AD=0.1116P PS=2.86U PD=0.98U
* device instance $3375 r180 *1 513.015,791.8 pfet_05v0
M$3375 \$I4271 \$I4266 VDD_DEC VDD_DEC pfet_05v0 L=0.5U W=0.36U AS=0.1116P
+ AD=0.0612P PS=0.98U PD=0.7U
* device instance $3376 r180 *1 512.175,791.8 pfet_05v0
M$3376 \$I4271 \$I4266 \$I4267 VDD_DEC pfet_05v0 L=0.5U W=0.36U AS=0.3852P
+ AD=0.0612P PS=2.86U PD=0.7U
* device instance $3377 r180 *1 509.845,794.678 nfet_05v0
M$3377 \$I4270 \$I4267 \$I4268 VSS nfet_05v0 L=0.6U W=0.365U AS=0.3705P
+ AD=0.0438P PS=2.77U PD=0.605U
* device instance $3378 r180 *1 509.005,794.678 nfet_05v0
M$3378 VSS \$I4267 \$I4270 VSS nfet_05v0 L=0.6U W=0.365U AS=0.0438P
+ AD=0.282625P PS=0.605U PD=1.87U
* device instance $3379 r180 *1 507.355,794.45 nfet_05v0
M$3379 \$I2197 \$I4268 VSS VSS nfet_05v0 L=0.6U W=0.82U AS=0.282625P AD=0.3608P
+ PS=1.87U PD=2.52U
* device instance $3380 r180 *1 514.085,794.68 nfet_05v0
M$3380 VSS \$I2200 \$I4266 VSS nfet_05v0 L=0.6U W=0.36U AS=0.333P AD=0.0936P
+ PS=2.57U PD=0.88U
* device instance $3381 r180 *1 512.965,794.68 nfet_05v0
M$3381 \$I4269 \$I4266 VSS VSS nfet_05v0 L=0.6U W=0.36U AS=0.0936P AD=0.0432P
+ PS=0.88U PD=0.6U
* device instance $3382 r180 *1 512.125,794.68 nfet_05v0
M$3382 \$I4267 \$I4266 \$I4269 VSS nfet_05v0 L=0.6U W=0.36U AS=0.0432P
+ AD=0.369P PS=0.6U PD=2.77U
* device instance $3383 r180 *1 627.495,799.75 pfet_05v0
M$3383 \$I4279 \$I4274 \$I4275 VDD_DEC pfet_05v0 L=0.5U W=0.36U AS=0.3456P
+ AD=0.0612P PS=2.64U PD=0.7U
* device instance $3384 r180 *1 626.655,799.75 pfet_05v0
M$3384 \$I4279 \$I4274 VDD_DEC VDD_DEC pfet_05v0 L=0.5U W=0.36U AS=0.379P
+ AD=0.0612P PS=2.37U PD=0.7U
* device instance $3385 r180 *1 625.005,800.07 pfet_05v0
M$3385 \$I2214 \$I4275 VDD_DEC VDD_DEC pfet_05v0 L=0.5U W=1.22U AS=0.379P
+ AD=0.5368P PS=2.37U PD=3.32U
* device instance $3386 r180 *1 631.735,799.64 pfet_05v0
M$3386 VDD_DEC \$I2176 \$I4273 VDD_DEC pfet_05v0 L=0.5U W=0.36U AS=0.3852P
+ AD=0.1116P PS=2.86U PD=0.98U
* device instance $3387 r180 *1 630.615,799.64 pfet_05v0
M$3387 \$I4278 \$I4273 VDD_DEC VDD_DEC pfet_05v0 L=0.5U W=0.36U AS=0.1116P
+ AD=0.0612P PS=0.98U PD=0.7U
* device instance $3388 r180 *1 629.775,799.64 pfet_05v0
M$3388 \$I4278 \$I4273 \$I4274 VDD_DEC pfet_05v0 L=0.5U W=0.36U AS=0.3852P
+ AD=0.0612P PS=2.86U PD=0.7U
* device instance $3389 r180 *1 627.445,802.518 nfet_05v0
M$3389 \$I4277 \$I4274 \$I4275 VSS nfet_05v0 L=0.6U W=0.365U AS=0.3705P
+ AD=0.0438P PS=2.77U PD=0.605U
* device instance $3390 r180 *1 626.605,802.518 nfet_05v0
M$3390 VSS \$I4274 \$I4277 VSS nfet_05v0 L=0.6U W=0.365U AS=0.0438P
+ AD=0.282625P PS=0.605U PD=1.87U
* device instance $3391 r180 *1 624.955,802.29 nfet_05v0
M$3391 \$I2214 \$I4275 VSS VSS nfet_05v0 L=0.6U W=0.82U AS=0.282625P AD=0.3608P
+ PS=1.87U PD=2.52U
* device instance $3392 r180 *1 631.685,802.52 nfet_05v0
M$3392 VSS \$I2176 \$I4273 VSS nfet_05v0 L=0.6U W=0.36U AS=0.333P AD=0.0936P
+ PS=2.57U PD=0.88U
* device instance $3393 r180 *1 630.565,802.52 nfet_05v0
M$3393 \$I4276 \$I4273 VSS VSS nfet_05v0 L=0.6U W=0.36U AS=0.0936P AD=0.0432P
+ PS=0.88U PD=0.6U
* device instance $3394 r180 *1 629.725,802.52 nfet_05v0
M$3394 \$I4274 \$I4273 \$I4276 VSS nfet_05v0 L=0.6U W=0.36U AS=0.0432P
+ AD=0.369P PS=0.6U PD=2.77U
* device instance $3395 r180 *1 559.735,791.91 pfet_05v0
M$3395 \$I4286 \$I4281 \$I4282 VDD_DEC pfet_05v0 L=0.5U W=0.36U AS=0.3456P
+ AD=0.0612P PS=2.64U PD=0.7U
* device instance $3396 r180 *1 558.895,791.91 pfet_05v0
M$3396 \$I4286 \$I4281 VDD_DEC VDD_DEC pfet_05v0 L=0.5U W=0.36U AS=0.379P
+ AD=0.0612P PS=2.37U PD=0.7U
* device instance $3397 r180 *1 557.245,792.23 pfet_05v0
M$3397 \$I2418 \$I4282 VDD_DEC VDD_DEC pfet_05v0 L=0.5U W=1.22U AS=0.379P
+ AD=0.5368P PS=2.37U PD=3.32U
* device instance $3398 r180 *1 563.975,791.8 pfet_05v0
M$3398 VDD_DEC \$I2203 \$I4280 VDD_DEC pfet_05v0 L=0.5U W=0.36U AS=0.3852P
+ AD=0.1116P PS=2.86U PD=0.98U
* device instance $3399 r180 *1 562.855,791.8 pfet_05v0
M$3399 \$I4285 \$I4280 VDD_DEC VDD_DEC pfet_05v0 L=0.5U W=0.36U AS=0.1116P
+ AD=0.0612P PS=0.98U PD=0.7U
* device instance $3400 r180 *1 562.015,791.8 pfet_05v0
M$3400 \$I4285 \$I4280 \$I4281 VDD_DEC pfet_05v0 L=0.5U W=0.36U AS=0.3852P
+ AD=0.0612P PS=2.86U PD=0.7U
* device instance $3401 r180 *1 559.685,794.678 nfet_05v0
M$3401 \$I4284 \$I4281 \$I4282 VSS nfet_05v0 L=0.6U W=0.365U AS=0.3705P
+ AD=0.0438P PS=2.77U PD=0.605U
* device instance $3402 r180 *1 558.845,794.678 nfet_05v0
M$3402 VSS \$I4281 \$I4284 VSS nfet_05v0 L=0.6U W=0.365U AS=0.0438P
+ AD=0.282625P PS=0.605U PD=1.87U
* device instance $3403 r180 *1 557.195,794.45 nfet_05v0
M$3403 \$I2418 \$I4282 VSS VSS nfet_05v0 L=0.6U W=0.82U AS=0.282625P AD=0.3608P
+ PS=1.87U PD=2.52U
* device instance $3404 r180 *1 563.925,794.68 nfet_05v0
M$3404 VSS \$I2203 \$I4280 VSS nfet_05v0 L=0.6U W=0.36U AS=0.333P AD=0.0936P
+ PS=2.57U PD=0.88U
* device instance $3405 r180 *1 562.805,794.68 nfet_05v0
M$3405 \$I4283 \$I4280 VSS VSS nfet_05v0 L=0.6U W=0.36U AS=0.0936P AD=0.0432P
+ PS=0.88U PD=0.6U
* device instance $3406 r180 *1 561.965,794.68 nfet_05v0
M$3406 \$I4281 \$I4280 \$I4283 VSS nfet_05v0 L=0.6U W=0.36U AS=0.0432P
+ AD=0.369P PS=0.6U PD=2.77U
* device instance $3407 r180 *1 620.215,791.91 pfet_05v0
M$3407 \$I4293 \$I4288 \$I4289 VDD_DEC pfet_05v0 L=0.5U W=0.36U AS=0.3456P
+ AD=0.0612P PS=2.64U PD=0.7U
* device instance $3408 r180 *1 619.375,791.91 pfet_05v0
M$3408 \$I4293 \$I4288 VDD_DEC VDD_DEC pfet_05v0 L=0.5U W=0.36U AS=0.379P
+ AD=0.0612P PS=2.37U PD=0.7U
* device instance $3409 r180 *1 617.725,792.23 pfet_05v0
M$3409 \$I2240 \$I4289 VDD_DEC VDD_DEC pfet_05v0 L=0.5U W=1.22U AS=0.379P
+ AD=0.5368P PS=2.37U PD=3.32U
* device instance $3410 r180 *1 624.455,791.8 pfet_05v0
M$3410 VDD_DEC \$I2214 \$I4287 VDD_DEC pfet_05v0 L=0.5U W=0.36U AS=0.3852P
+ AD=0.1116P PS=2.86U PD=0.98U
* device instance $3411 r180 *1 623.335,791.8 pfet_05v0
M$3411 \$I4292 \$I4287 VDD_DEC VDD_DEC pfet_05v0 L=0.5U W=0.36U AS=0.1116P
+ AD=0.0612P PS=0.98U PD=0.7U
* device instance $3412 r180 *1 622.495,791.8 pfet_05v0
M$3412 \$I4292 \$I4287 \$I4288 VDD_DEC pfet_05v0 L=0.5U W=0.36U AS=0.3852P
+ AD=0.0612P PS=2.86U PD=0.7U
* device instance $3413 r180 *1 620.165,794.678 nfet_05v0
M$3413 \$I4291 \$I4288 \$I4289 VSS nfet_05v0 L=0.6U W=0.365U AS=0.3705P
+ AD=0.0438P PS=2.77U PD=0.605U
* device instance $3414 r180 *1 619.325,794.678 nfet_05v0
M$3414 VSS \$I4288 \$I4291 VSS nfet_05v0 L=0.6U W=0.365U AS=0.0438P
+ AD=0.282625P PS=0.605U PD=1.87U
* device instance $3415 r180 *1 617.675,794.45 nfet_05v0
M$3415 \$I2240 \$I4289 VSS VSS nfet_05v0 L=0.6U W=0.82U AS=0.282625P AD=0.3608P
+ PS=1.87U PD=2.52U
* device instance $3416 r180 *1 624.405,794.68 nfet_05v0
M$3416 VSS \$I2214 \$I4287 VSS nfet_05v0 L=0.6U W=0.36U AS=0.333P AD=0.0936P
+ PS=2.57U PD=0.88U
* device instance $3417 r180 *1 623.285,794.68 nfet_05v0
M$3417 \$I4290 \$I4287 VSS VSS nfet_05v0 L=0.6U W=0.36U AS=0.0936P AD=0.0432P
+ PS=0.88U PD=0.6U
* device instance $3418 r180 *1 622.445,794.68 nfet_05v0
M$3418 \$I4288 \$I4287 \$I4290 VSS nfet_05v0 L=0.6U W=0.36U AS=0.0432P
+ AD=0.369P PS=0.6U PD=2.77U
* device instance $3419 r180 *1 535.095,791.91 pfet_05v0
M$3419 \$I4300 \$I4295 \$I4296 VDD_DEC pfet_05v0 L=0.5U W=0.36U AS=0.3456P
+ AD=0.0612P PS=2.64U PD=0.7U
* device instance $3420 r180 *1 534.255,791.91 pfet_05v0
M$3420 \$I4300 \$I4295 VDD_DEC VDD_DEC pfet_05v0 L=0.5U W=0.36U AS=0.379P
+ AD=0.0612P PS=2.37U PD=0.7U
* device instance $3421 r180 *1 532.605,792.23 pfet_05v0
M$3421 \$I2201 \$I4296 VDD_DEC VDD_DEC pfet_05v0 L=0.5U W=1.22U AS=0.379P
+ AD=0.5368P PS=2.37U PD=3.32U
* device instance $3422 r180 *1 539.335,791.8 pfet_05v0
M$3422 VDD_DEC \$I2331 \$I4294 VDD_DEC pfet_05v0 L=0.5U W=0.36U AS=0.3852P
+ AD=0.1116P PS=2.86U PD=0.98U
* device instance $3423 r180 *1 538.215,791.8 pfet_05v0
M$3423 \$I4299 \$I4294 VDD_DEC VDD_DEC pfet_05v0 L=0.5U W=0.36U AS=0.1116P
+ AD=0.0612P PS=0.98U PD=0.7U
* device instance $3424 r180 *1 537.375,791.8 pfet_05v0
M$3424 \$I4299 \$I4294 \$I4295 VDD_DEC pfet_05v0 L=0.5U W=0.36U AS=0.3852P
+ AD=0.0612P PS=2.86U PD=0.7U
* device instance $3425 r180 *1 535.045,794.678 nfet_05v0
M$3425 \$I4298 \$I4295 \$I4296 VSS nfet_05v0 L=0.6U W=0.365U AS=0.3705P
+ AD=0.0438P PS=2.77U PD=0.605U
* device instance $3426 r180 *1 534.205,794.678 nfet_05v0
M$3426 VSS \$I4295 \$I4298 VSS nfet_05v0 L=0.6U W=0.365U AS=0.0438P
+ AD=0.282625P PS=0.605U PD=1.87U
* device instance $3427 r180 *1 532.555,794.45 nfet_05v0
M$3427 \$I2201 \$I4296 VSS VSS nfet_05v0 L=0.6U W=0.82U AS=0.282625P AD=0.3608P
+ PS=1.87U PD=2.52U
* device instance $3428 r180 *1 539.285,794.68 nfet_05v0
M$3428 VSS \$I2331 \$I4294 VSS nfet_05v0 L=0.6U W=0.36U AS=0.333P AD=0.0936P
+ PS=2.57U PD=0.88U
* device instance $3429 r180 *1 538.165,794.68 nfet_05v0
M$3429 \$I4297 \$I4294 VSS VSS nfet_05v0 L=0.6U W=0.36U AS=0.0936P AD=0.0432P
+ PS=0.88U PD=0.6U
* device instance $3430 r180 *1 537.325,794.68 nfet_05v0
M$3430 \$I4295 \$I4294 \$I4297 VSS nfet_05v0 L=0.6U W=0.36U AS=0.0432P
+ AD=0.369P PS=0.6U PD=2.77U
* device instance $3431 r180 *1 573.735,799.75 pfet_05v0
M$3431 \$I4307 \$I4302 \$I4303 VDD_DEC pfet_05v0 L=0.5U W=0.36U AS=0.3456P
+ AD=0.0612P PS=2.64U PD=0.7U
* device instance $3432 r180 *1 572.895,799.75 pfet_05v0
M$3432 \$I4307 \$I4302 VDD_DEC VDD_DEC pfet_05v0 L=0.5U W=0.36U AS=0.379P
+ AD=0.0612P PS=2.37U PD=0.7U
* device instance $3433 r180 *1 571.245,800.07 pfet_05v0
M$3433 \$I2204 \$I4303 VDD_DEC VDD_DEC pfet_05v0 L=0.5U W=1.22U AS=0.379P
+ AD=0.5368P PS=2.37U PD=3.32U
* device instance $3434 r180 *1 577.975,799.64 pfet_05v0
M$3434 VDD_DEC \$I2280 \$I4301 VDD_DEC pfet_05v0 L=0.5U W=0.36U AS=0.3852P
+ AD=0.1116P PS=2.86U PD=0.98U
* device instance $3435 r180 *1 576.855,799.64 pfet_05v0
M$3435 \$I4306 \$I4301 VDD_DEC VDD_DEC pfet_05v0 L=0.5U W=0.36U AS=0.1116P
+ AD=0.0612P PS=0.98U PD=0.7U
* device instance $3436 r180 *1 576.015,799.64 pfet_05v0
M$3436 \$I4306 \$I4301 \$I4302 VDD_DEC pfet_05v0 L=0.5U W=0.36U AS=0.3852P
+ AD=0.0612P PS=2.86U PD=0.7U
* device instance $3437 r180 *1 573.685,802.518 nfet_05v0
M$3437 \$I4305 \$I4302 \$I4303 VSS nfet_05v0 L=0.6U W=0.365U AS=0.3705P
+ AD=0.0438P PS=2.77U PD=0.605U
* device instance $3438 r180 *1 572.845,802.518 nfet_05v0
M$3438 VSS \$I4302 \$I4305 VSS nfet_05v0 L=0.6U W=0.365U AS=0.0438P
+ AD=0.282625P PS=0.605U PD=1.87U
* device instance $3439 r180 *1 571.195,802.29 nfet_05v0
M$3439 \$I2204 \$I4303 VSS VSS nfet_05v0 L=0.6U W=0.82U AS=0.282625P AD=0.3608P
+ PS=1.87U PD=2.52U
* device instance $3440 r180 *1 577.925,802.52 nfet_05v0
M$3440 VSS \$I2280 \$I4301 VSS nfet_05v0 L=0.6U W=0.36U AS=0.333P AD=0.0936P
+ PS=2.57U PD=0.88U
* device instance $3441 r180 *1 576.805,802.52 nfet_05v0
M$3441 \$I4304 \$I4301 VSS VSS nfet_05v0 L=0.6U W=0.36U AS=0.0936P AD=0.0432P
+ PS=0.88U PD=0.6U
* device instance $3442 r180 *1 575.965,802.52 nfet_05v0
M$3442 \$I4302 \$I4301 \$I4304 VSS nfet_05v0 L=0.6U W=0.36U AS=0.0432P
+ AD=0.369P PS=0.6U PD=2.77U
* device instance $3443 r180 *1 638.135,799.75 pfet_05v0
M$3443 \$I4314 \$I4309 \$I4310 VDD_DEC pfet_05v0 L=0.5U W=0.36U AS=0.3456P
+ AD=0.0612P PS=2.64U PD=0.7U
* device instance $3444 r180 *1 637.295,799.75 pfet_05v0
M$3444 \$I4314 \$I4309 VDD_DEC VDD_DEC pfet_05v0 L=0.5U W=0.36U AS=0.379P
+ AD=0.0612P PS=2.37U PD=0.7U
* device instance $3445 r180 *1 635.645,800.07 pfet_05v0
M$3445 \$I2285 \$I4310 VDD_DEC VDD_DEC pfet_05v0 L=0.5U W=1.22U AS=0.379P
+ AD=0.5368P PS=2.37U PD=3.32U
* device instance $3446 r180 *1 642.375,799.64 pfet_05v0
M$3446 VDD_DEC \$I2311 \$I4308 VDD_DEC pfet_05v0 L=0.5U W=0.36U AS=0.3852P
+ AD=0.1116P PS=2.86U PD=0.98U
* device instance $3447 r180 *1 641.255,799.64 pfet_05v0
M$3447 \$I4313 \$I4308 VDD_DEC VDD_DEC pfet_05v0 L=0.5U W=0.36U AS=0.1116P
+ AD=0.0612P PS=0.98U PD=0.7U
* device instance $3448 r180 *1 640.415,799.64 pfet_05v0
M$3448 \$I4313 \$I4308 \$I4309 VDD_DEC pfet_05v0 L=0.5U W=0.36U AS=0.3852P
+ AD=0.0612P PS=2.86U PD=0.7U
* device instance $3449 r180 *1 638.085,802.518 nfet_05v0
M$3449 \$I4312 \$I4309 \$I4310 VSS nfet_05v0 L=0.6U W=0.365U AS=0.3705P
+ AD=0.0438P PS=2.77U PD=0.605U
* device instance $3450 r180 *1 637.245,802.518 nfet_05v0
M$3450 VSS \$I4309 \$I4312 VSS nfet_05v0 L=0.6U W=0.365U AS=0.0438P
+ AD=0.282625P PS=0.605U PD=1.87U
* device instance $3451 r180 *1 635.595,802.29 nfet_05v0
M$3451 \$I2285 \$I4310 VSS VSS nfet_05v0 L=0.6U W=0.82U AS=0.282625P AD=0.3608P
+ PS=1.87U PD=2.52U
* device instance $3452 r180 *1 642.325,802.52 nfet_05v0
M$3452 VSS \$I2311 \$I4308 VSS nfet_05v0 L=0.6U W=0.36U AS=0.333P AD=0.0936P
+ PS=2.57U PD=0.88U
* device instance $3453 r180 *1 641.205,802.52 nfet_05v0
M$3453 \$I4311 \$I4308 VSS VSS nfet_05v0 L=0.6U W=0.36U AS=0.0936P AD=0.0432P
+ PS=0.88U PD=0.6U
* device instance $3454 r180 *1 640.365,802.52 nfet_05v0
M$3454 \$I4309 \$I4308 \$I4311 VSS nfet_05v0 L=0.6U W=0.36U AS=0.0432P
+ AD=0.369P PS=0.6U PD=2.77U
* device instance $3455 r180 *1 648.775,799.75 pfet_05v0
M$3455 \$I4321 \$I4316 \$I4317 VDD_DEC pfet_05v0 L=0.5U W=0.36U AS=0.3456P
+ AD=0.0612P PS=2.64U PD=0.7U
* device instance $3456 r180 *1 647.935,799.75 pfet_05v0
M$3456 \$I4321 \$I4316 VDD_DEC VDD_DEC pfet_05v0 L=0.5U W=0.36U AS=0.379P
+ AD=0.0612P PS=2.37U PD=0.7U
* device instance $3457 r180 *1 646.285,800.07 pfet_05v0
M$3457 \$I2208 \$I4317 VDD_DEC VDD_DEC pfet_05v0 L=0.5U W=1.22U AS=0.379P
+ AD=0.5368P PS=2.37U PD=3.32U
* device instance $3458 r180 *1 653.015,799.64 pfet_05v0
M$3458 VDD_DEC \$I2385 \$I4315 VDD_DEC pfet_05v0 L=0.5U W=0.36U AS=0.3852P
+ AD=0.1116P PS=2.86U PD=0.98U
* device instance $3459 r180 *1 651.895,799.64 pfet_05v0
M$3459 \$I4320 \$I4315 VDD_DEC VDD_DEC pfet_05v0 L=0.5U W=0.36U AS=0.1116P
+ AD=0.0612P PS=0.98U PD=0.7U
* device instance $3460 r180 *1 651.055,799.64 pfet_05v0
M$3460 \$I4320 \$I4315 \$I4316 VDD_DEC pfet_05v0 L=0.5U W=0.36U AS=0.3852P
+ AD=0.0612P PS=2.86U PD=0.7U
* device instance $3461 r180 *1 648.725,802.518 nfet_05v0
M$3461 \$I4319 \$I4316 \$I4317 VSS nfet_05v0 L=0.6U W=0.365U AS=0.3705P
+ AD=0.0438P PS=2.77U PD=0.605U
* device instance $3462 r180 *1 647.885,802.518 nfet_05v0
M$3462 VSS \$I4316 \$I4319 VSS nfet_05v0 L=0.6U W=0.365U AS=0.0438P
+ AD=0.282625P PS=0.605U PD=1.87U
* device instance $3463 r180 *1 646.235,802.29 nfet_05v0
M$3463 \$I2208 \$I4317 VSS VSS nfet_05v0 L=0.6U W=0.82U AS=0.282625P AD=0.3608P
+ PS=1.87U PD=2.52U
* device instance $3464 r180 *1 652.965,802.52 nfet_05v0
M$3464 VSS \$I2385 \$I4315 VSS nfet_05v0 L=0.6U W=0.36U AS=0.333P AD=0.0936P
+ PS=2.57U PD=0.88U
* device instance $3465 r180 *1 651.845,802.52 nfet_05v0
M$3465 \$I4318 \$I4315 VSS VSS nfet_05v0 L=0.6U W=0.36U AS=0.0936P AD=0.0432P
+ PS=0.88U PD=0.6U
* device instance $3466 r180 *1 651.005,802.52 nfet_05v0
M$3466 \$I4316 \$I4315 \$I4318 VSS nfet_05v0 L=0.6U W=0.36U AS=0.0432P
+ AD=0.369P PS=0.6U PD=2.77U
* device instance $3467 r0 *1 634.905,814.17 pfet_05v0
M$3467 \$I4328 \$I4323 \$I4324 VDD_DEC pfet_05v0 L=0.5U W=0.36U AS=0.3456P
+ AD=0.0612P PS=2.64U PD=0.7U
* device instance $3468 r0 *1 635.745,814.17 pfet_05v0
M$3468 \$I4328 \$I4323 VDD_DEC VDD_DEC pfet_05v0 L=0.5U W=0.36U AS=0.379P
+ AD=0.0612P PS=2.37U PD=0.7U
* device instance $3469 r0 *1 637.395,813.85 pfet_05v0
M$3469 \$I2215 \$I4324 VDD_DEC VDD_DEC pfet_05v0 L=0.5U W=1.22U AS=0.379P
+ AD=0.5368P PS=2.37U PD=3.32U
* device instance $3470 r0 *1 630.665,814.28 pfet_05v0
M$3470 VDD_DEC \$I2286 \$I4322 VDD_DEC pfet_05v0 L=0.5U W=0.36U AS=0.3852P
+ AD=0.1116P PS=2.86U PD=0.98U
* device instance $3471 r0 *1 631.785,814.28 pfet_05v0
M$3471 \$I4327 \$I4322 VDD_DEC VDD_DEC pfet_05v0 L=0.5U W=0.36U AS=0.1116P
+ AD=0.0612P PS=0.98U PD=0.7U
* device instance $3472 r0 *1 632.625,814.28 pfet_05v0
M$3472 \$I4327 \$I4322 \$I4323 VDD_DEC pfet_05v0 L=0.5U W=0.36U AS=0.3852P
+ AD=0.0612P PS=2.86U PD=0.7U
* device instance $3473 r0 *1 634.955,811.402 nfet_05v0
M$3473 \$I4326 \$I4323 \$I4324 VSS nfet_05v0 L=0.6U W=0.365U AS=0.3705P
+ AD=0.0438P PS=2.77U PD=0.605U
* device instance $3474 r0 *1 635.795,811.402 nfet_05v0
M$3474 VSS \$I4323 \$I4326 VSS nfet_05v0 L=0.6U W=0.365U AS=0.0438P
+ AD=0.282625P PS=0.605U PD=1.87U
* device instance $3475 r0 *1 637.445,811.63 nfet_05v0
M$3475 \$I2215 \$I4324 VSS VSS nfet_05v0 L=0.6U W=0.82U AS=0.282625P AD=0.3608P
+ PS=1.87U PD=2.52U
* device instance $3476 r0 *1 630.715,811.4 nfet_05v0
M$3476 VSS \$I2286 \$I4322 VSS nfet_05v0 L=0.6U W=0.36U AS=0.333P AD=0.0936P
+ PS=2.57U PD=0.88U
* device instance $3477 r0 *1 631.835,811.4 nfet_05v0
M$3477 \$I4325 \$I4322 VSS VSS nfet_05v0 L=0.6U W=0.36U AS=0.0936P AD=0.0432P
+ PS=0.88U PD=0.6U
* device instance $3478 r0 *1 632.675,811.4 nfet_05v0
M$3478 \$I4323 \$I4322 \$I4325 VSS nfet_05v0 L=0.6U W=0.36U AS=0.0432P
+ AD=0.369P PS=0.6U PD=2.77U
* device instance $3479 r0 *1 521.225,774.97 pfet_05v0
M$3479 \$I4335 \$I4330 \$I4331 VDD_DEC pfet_05v0 L=0.5U W=0.36U AS=0.3456P
+ AD=0.0612P PS=2.64U PD=0.7U
* device instance $3480 r0 *1 522.065,774.97 pfet_05v0
M$3480 \$I4335 \$I4330 VDD_DEC VDD_DEC pfet_05v0 L=0.5U W=0.36U AS=0.379P
+ AD=0.0612P PS=2.37U PD=0.7U
* device instance $3481 r0 *1 523.715,774.65 pfet_05v0
M$3481 \$152 \$I4331 VDD_DEC VDD_DEC pfet_05v0 L=0.5U W=1.22U AS=0.379P
+ AD=0.5368P PS=2.37U PD=3.32U
* device instance $3482 r0 *1 516.985,775.08 pfet_05v0
M$3482 VDD_DEC \$I2022 \$I4329 VDD_DEC pfet_05v0 L=0.5U W=0.36U AS=0.3852P
+ AD=0.1116P PS=2.86U PD=0.98U
* device instance $3483 r0 *1 518.105,775.08 pfet_05v0
M$3483 \$I4334 \$I4329 VDD_DEC VDD_DEC pfet_05v0 L=0.5U W=0.36U AS=0.1116P
+ AD=0.0612P PS=0.98U PD=0.7U
* device instance $3484 r0 *1 518.945,775.08 pfet_05v0
M$3484 \$I4334 \$I4329 \$I4330 VDD_DEC pfet_05v0 L=0.5U W=0.36U AS=0.3852P
+ AD=0.0612P PS=2.86U PD=0.7U
* device instance $3485 r0 *1 521.275,772.202 nfet_05v0
M$3485 \$I4333 \$I4330 \$I4331 VSS nfet_05v0 L=0.6U W=0.365U AS=0.3705P
+ AD=0.0438P PS=2.77U PD=0.605U
* device instance $3486 r0 *1 522.115,772.202 nfet_05v0
M$3486 VSS \$I4330 \$I4333 VSS nfet_05v0 L=0.6U W=0.365U AS=0.0438P
+ AD=0.282625P PS=0.605U PD=1.87U
* device instance $3487 r0 *1 523.765,772.43 nfet_05v0
M$3487 \$152 \$I4331 VSS VSS nfet_05v0 L=0.6U W=0.82U AS=0.282625P AD=0.3608P
+ PS=1.87U PD=2.52U
* device instance $3488 r0 *1 517.035,772.2 nfet_05v0
M$3488 VSS \$I2022 \$I4329 VSS nfet_05v0 L=0.6U W=0.36U AS=0.333P AD=0.0936P
+ PS=2.57U PD=0.88U
* device instance $3489 r0 *1 518.155,772.2 nfet_05v0
M$3489 \$I4332 \$I4329 VSS VSS nfet_05v0 L=0.6U W=0.36U AS=0.0936P AD=0.0432P
+ PS=0.88U PD=0.6U
* device instance $3490 r0 *1 518.995,772.2 nfet_05v0
M$3490 \$I4330 \$I4329 \$I4332 VSS nfet_05v0 L=0.6U W=0.36U AS=0.0432P
+ AD=0.369P PS=0.6U PD=2.77U
* device instance $3491 r0 *1 524.025,782.81 pfet_05v0
M$3491 \$I4342 \$I4337 \$I4338 VDD_DEC pfet_05v0 L=0.5U W=0.36U AS=0.3456P
+ AD=0.0612P PS=2.64U PD=0.7U
* device instance $3492 r0 *1 524.865,782.81 pfet_05v0
M$3492 \$I4342 \$I4337 VDD_DEC VDD_DEC pfet_05v0 L=0.5U W=0.36U AS=0.379P
+ AD=0.0612P PS=2.37U PD=0.7U
* device instance $3493 r0 *1 526.515,782.49 pfet_05v0
M$3493 \$184 \$I4338 VDD_DEC VDD_DEC pfet_05v0 L=0.5U W=1.22U AS=0.379P
+ AD=0.5368P PS=2.37U PD=3.32U
* device instance $3494 r0 *1 519.785,782.92 pfet_05v0
M$3494 VDD_DEC \$I2058 \$I4336 VDD_DEC pfet_05v0 L=0.5U W=0.36U AS=0.3852P
+ AD=0.1116P PS=2.86U PD=0.98U
* device instance $3495 r0 *1 520.905,782.92 pfet_05v0
M$3495 \$I4341 \$I4336 VDD_DEC VDD_DEC pfet_05v0 L=0.5U W=0.36U AS=0.1116P
+ AD=0.0612P PS=0.98U PD=0.7U
* device instance $3496 r0 *1 521.745,782.92 pfet_05v0
M$3496 \$I4341 \$I4336 \$I4337 VDD_DEC pfet_05v0 L=0.5U W=0.36U AS=0.3852P
+ AD=0.0612P PS=2.86U PD=0.7U
* device instance $3497 r0 *1 524.075,780.042 nfet_05v0
M$3497 \$I4340 \$I4337 \$I4338 VSS nfet_05v0 L=0.6U W=0.365U AS=0.3705P
+ AD=0.0438P PS=2.77U PD=0.605U
* device instance $3498 r0 *1 524.915,780.042 nfet_05v0
M$3498 VSS \$I4337 \$I4340 VSS nfet_05v0 L=0.6U W=0.365U AS=0.0438P
+ AD=0.282625P PS=0.605U PD=1.87U
* device instance $3499 r0 *1 526.565,780.27 nfet_05v0
M$3499 \$184 \$I4338 VSS VSS nfet_05v0 L=0.6U W=0.82U AS=0.282625P AD=0.3608P
+ PS=1.87U PD=2.52U
* device instance $3500 r0 *1 519.835,780.04 nfet_05v0
M$3500 VSS \$I2058 \$I4336 VSS nfet_05v0 L=0.6U W=0.36U AS=0.333P AD=0.0936P
+ PS=2.57U PD=0.88U
* device instance $3501 r0 *1 520.955,780.04 nfet_05v0
M$3501 \$I4339 \$I4336 VSS VSS nfet_05v0 L=0.6U W=0.36U AS=0.0936P AD=0.0432P
+ PS=0.88U PD=0.6U
* device instance $3502 r0 *1 521.795,780.04 nfet_05v0
M$3502 \$I4337 \$I4336 \$I4339 VSS nfet_05v0 L=0.6U W=0.36U AS=0.0432P
+ AD=0.369P PS=0.6U PD=2.77U
* device instance $3503 r0 *1 501.625,837.69 pfet_05v0
M$3503 \$I4349 \$I4344 \$I4345 VDD_DEC pfet_05v0 L=0.5U W=0.36U AS=0.3456P
+ AD=0.0612P PS=2.64U PD=0.7U
* device instance $3504 r0 *1 502.465,837.69 pfet_05v0
M$3504 \$I4349 \$I4344 VDD_DEC VDD_DEC pfet_05v0 L=0.5U W=0.36U AS=0.379P
+ AD=0.0612P PS=2.37U PD=0.7U
* device instance $3505 r0 *1 504.115,837.37 pfet_05v0
M$3505 \$I2355 \$I4345 VDD_DEC VDD_DEC pfet_05v0 L=0.5U W=1.22U AS=0.379P
+ AD=0.5368P PS=2.37U PD=3.32U
* device instance $3506 r0 *1 497.385,837.8 pfet_05v0
M$3506 VDD_DEC D[0] \$I4343 VDD_DEC pfet_05v0 L=0.5U W=0.36U AS=0.3852P
+ AD=0.1116P PS=2.86U PD=0.98U
* device instance $3507 r0 *1 498.505,837.8 pfet_05v0
M$3507 \$I4348 \$I4343 VDD_DEC VDD_DEC pfet_05v0 L=0.5U W=0.36U AS=0.1116P
+ AD=0.0612P PS=0.98U PD=0.7U
* device instance $3508 r0 *1 499.345,837.8 pfet_05v0
M$3508 \$I4348 \$I4343 \$I4344 VDD_DEC pfet_05v0 L=0.5U W=0.36U AS=0.3852P
+ AD=0.0612P PS=2.86U PD=0.7U
* device instance $3509 r0 *1 501.675,834.922 nfet_05v0
M$3509 \$I4347 \$I4344 \$I4345 VSS nfet_05v0 L=0.6U W=0.365U AS=0.3705P
+ AD=0.0438P PS=2.77U PD=0.605U
* device instance $3510 r0 *1 502.515,834.922 nfet_05v0
M$3510 VSS \$I4344 \$I4347 VSS nfet_05v0 L=0.6U W=0.365U AS=0.0438P
+ AD=0.282625P PS=0.605U PD=1.87U
* device instance $3511 r0 *1 504.165,835.15 nfet_05v0
M$3511 \$I2355 \$I4345 VSS VSS nfet_05v0 L=0.6U W=0.82U AS=0.282625P AD=0.3608P
+ PS=1.87U PD=2.52U
* device instance $3512 r0 *1 497.435,834.92 nfet_05v0
M$3512 VSS D[0] \$I4343 VSS nfet_05v0 L=0.6U W=0.36U AS=0.333P AD=0.0936P
+ PS=2.57U PD=0.88U
* device instance $3513 r0 *1 498.555,834.92 nfet_05v0
M$3513 \$I4346 \$I4343 VSS VSS nfet_05v0 L=0.6U W=0.36U AS=0.0936P AD=0.0432P
+ PS=0.88U PD=0.6U
* device instance $3514 r0 *1 499.395,834.92 nfet_05v0
M$3514 \$I4344 \$I4343 \$I4346 VSS nfet_05v0 L=0.6U W=0.36U AS=0.0432P
+ AD=0.369P PS=0.6U PD=2.77U
* device instance $3515 r0 *1 559.305,774.97 pfet_05v0
M$3515 \$I4356 \$I4351 \$I4352 VDD_DEC pfet_05v0 L=0.5U W=0.36U AS=0.3456P
+ AD=0.0612P PS=2.64U PD=0.7U
* device instance $3516 r0 *1 560.145,774.97 pfet_05v0
M$3516 \$I4356 \$I4351 VDD_DEC VDD_DEC pfet_05v0 L=0.5U W=0.36U AS=0.379P
+ AD=0.0612P PS=2.37U PD=0.7U
* device instance $3517 r0 *1 561.795,774.65 pfet_05v0
M$3517 \$174 \$I4352 VDD_DEC VDD_DEC pfet_05v0 L=0.5U W=1.22U AS=0.379P
+ AD=0.5368P PS=2.37U PD=3.32U
* device instance $3518 r0 *1 555.065,775.08 pfet_05v0
M$3518 VDD_DEC \$I2026 \$I4350 VDD_DEC pfet_05v0 L=0.5U W=0.36U AS=0.3852P
+ AD=0.1116P PS=2.86U PD=0.98U
* device instance $3519 r0 *1 556.185,775.08 pfet_05v0
M$3519 \$I4355 \$I4350 VDD_DEC VDD_DEC pfet_05v0 L=0.5U W=0.36U AS=0.1116P
+ AD=0.0612P PS=0.98U PD=0.7U
* device instance $3520 r0 *1 557.025,775.08 pfet_05v0
M$3520 \$I4355 \$I4350 \$I4351 VDD_DEC pfet_05v0 L=0.5U W=0.36U AS=0.3852P
+ AD=0.0612P PS=2.86U PD=0.7U
* device instance $3521 r0 *1 559.355,772.202 nfet_05v0
M$3521 \$I4354 \$I4351 \$I4352 VSS nfet_05v0 L=0.6U W=0.365U AS=0.3705P
+ AD=0.0438P PS=2.77U PD=0.605U
* device instance $3522 r0 *1 560.195,772.202 nfet_05v0
M$3522 VSS \$I4351 \$I4354 VSS nfet_05v0 L=0.6U W=0.365U AS=0.0438P
+ AD=0.282625P PS=0.605U PD=1.87U
* device instance $3523 r0 *1 561.845,772.43 nfet_05v0
M$3523 \$174 \$I4352 VSS VSS nfet_05v0 L=0.6U W=0.82U AS=0.282625P AD=0.3608P
+ PS=1.87U PD=2.52U
* device instance $3524 r0 *1 555.115,772.2 nfet_05v0
M$3524 VSS \$I2026 \$I4350 VSS nfet_05v0 L=0.6U W=0.36U AS=0.333P AD=0.0936P
+ PS=2.57U PD=0.88U
* device instance $3525 r0 *1 556.235,772.2 nfet_05v0
M$3525 \$I4353 \$I4350 VSS VSS nfet_05v0 L=0.6U W=0.36U AS=0.0936P AD=0.0432P
+ PS=0.88U PD=0.6U
* device instance $3526 r0 *1 557.075,772.2 nfet_05v0
M$3526 \$I4351 \$I4350 \$I4353 VSS nfet_05v0 L=0.6U W=0.36U AS=0.0432P
+ AD=0.369P PS=0.6U PD=2.77U
* device instance $3527 r0 *1 645.545,837.69 pfet_05v0
M$3527 \$I4363 \$I4358 \$I4359 VDD_DEC pfet_05v0 L=0.5U W=0.36U AS=0.3456P
+ AD=0.0612P PS=2.64U PD=0.7U
* device instance $3528 r0 *1 646.385,837.69 pfet_05v0
M$3528 \$I4363 \$I4358 VDD_DEC VDD_DEC pfet_05v0 L=0.5U W=0.36U AS=0.379P
+ AD=0.0612P PS=2.37U PD=0.7U
* device instance $3529 r0 *1 648.035,837.37 pfet_05v0
M$3529 \$I2404 \$I4359 VDD_DEC VDD_DEC pfet_05v0 L=0.5U W=1.22U AS=0.379P
+ AD=0.5368P PS=2.37U PD=3.32U
* device instance $3530 r0 *1 641.305,837.8 pfet_05v0
M$3530 VDD_DEC D[5] \$I4357 VDD_DEC pfet_05v0 L=0.5U W=0.36U AS=0.3852P
+ AD=0.1116P PS=2.86U PD=0.98U
* device instance $3531 r0 *1 642.425,837.8 pfet_05v0
M$3531 \$I4362 \$I4357 VDD_DEC VDD_DEC pfet_05v0 L=0.5U W=0.36U AS=0.1116P
+ AD=0.0612P PS=0.98U PD=0.7U
* device instance $3532 r0 *1 643.265,837.8 pfet_05v0
M$3532 \$I4362 \$I4357 \$I4358 VDD_DEC pfet_05v0 L=0.5U W=0.36U AS=0.3852P
+ AD=0.0612P PS=2.86U PD=0.7U
* device instance $3533 r0 *1 645.595,834.922 nfet_05v0
M$3533 \$I4361 \$I4358 \$I4359 VSS nfet_05v0 L=0.6U W=0.365U AS=0.3705P
+ AD=0.0438P PS=2.77U PD=0.605U
* device instance $3534 r0 *1 646.435,834.922 nfet_05v0
M$3534 VSS \$I4358 \$I4361 VSS nfet_05v0 L=0.6U W=0.365U AS=0.0438P
+ AD=0.282625P PS=0.605U PD=1.87U
* device instance $3535 r0 *1 648.085,835.15 nfet_05v0
M$3535 \$I2404 \$I4359 VSS VSS nfet_05v0 L=0.6U W=0.82U AS=0.282625P AD=0.3608P
+ PS=1.87U PD=2.52U
* device instance $3536 r0 *1 641.355,834.92 nfet_05v0
M$3536 VSS D[5] \$I4357 VSS nfet_05v0 L=0.6U W=0.36U AS=0.333P AD=0.0936P
+ PS=2.57U PD=0.88U
* device instance $3537 r0 *1 642.475,834.92 nfet_05v0
M$3537 \$I4360 \$I4357 VSS VSS nfet_05v0 L=0.6U W=0.36U AS=0.0936P AD=0.0432P
+ PS=0.88U PD=0.6U
* device instance $3538 r0 *1 643.315,834.92 nfet_05v0
M$3538 \$I4358 \$I4357 \$I4360 VSS nfet_05v0 L=0.6U W=0.36U AS=0.0432P
+ AD=0.369P PS=0.6U PD=2.77U
* device instance $3539 r0 *1 552.025,829.85 pfet_05v0
M$3539 \$I4370 \$I4365 \$I4366 VDD_DEC pfet_05v0 L=0.5U W=0.36U AS=0.3456P
+ AD=0.0612P PS=2.64U PD=0.7U
* device instance $3540 r0 *1 552.865,829.85 pfet_05v0
M$3540 \$I4370 \$I4365 VDD_DEC VDD_DEC pfet_05v0 L=0.5U W=0.36U AS=0.379P
+ AD=0.0612P PS=2.37U PD=0.7U
* device instance $3541 r0 *1 554.515,829.53 pfet_05v0
M$3541 \$I2354 \$I4366 VDD_DEC VDD_DEC pfet_05v0 L=0.5U W=1.22U AS=0.379P
+ AD=0.5368P PS=2.37U PD=3.32U
* device instance $3542 r0 *1 547.785,829.96 pfet_05v0
M$3542 VDD_DEC \$I2417 \$I4364 VDD_DEC pfet_05v0 L=0.5U W=0.36U AS=0.3852P
+ AD=0.1116P PS=2.86U PD=0.98U
* device instance $3543 r0 *1 548.905,829.96 pfet_05v0
M$3543 \$I4369 \$I4364 VDD_DEC VDD_DEC pfet_05v0 L=0.5U W=0.36U AS=0.1116P
+ AD=0.0612P PS=0.98U PD=0.7U
* device instance $3544 r0 *1 549.745,829.96 pfet_05v0
M$3544 \$I4369 \$I4364 \$I4365 VDD_DEC pfet_05v0 L=0.5U W=0.36U AS=0.3852P
+ AD=0.0612P PS=2.86U PD=0.7U
* device instance $3545 r0 *1 552.075,827.082 nfet_05v0
M$3545 \$I4368 \$I4365 \$I4366 VSS nfet_05v0 L=0.6U W=0.365U AS=0.3705P
+ AD=0.0438P PS=2.77U PD=0.605U
* device instance $3546 r0 *1 552.915,827.082 nfet_05v0
M$3546 VSS \$I4365 \$I4368 VSS nfet_05v0 L=0.6U W=0.365U AS=0.0438P
+ AD=0.282625P PS=0.605U PD=1.87U
* device instance $3547 r0 *1 554.565,827.31 nfet_05v0
M$3547 \$I2354 \$I4366 VSS VSS nfet_05v0 L=0.6U W=0.82U AS=0.282625P AD=0.3608P
+ PS=1.87U PD=2.52U
* device instance $3548 r0 *1 547.835,827.08 nfet_05v0
M$3548 VSS \$I2417 \$I4364 VSS nfet_05v0 L=0.6U W=0.36U AS=0.333P AD=0.0936P
+ PS=2.57U PD=0.88U
* device instance $3549 r0 *1 548.955,827.08 nfet_05v0
M$3549 \$I4367 \$I4364 VSS VSS nfet_05v0 L=0.6U W=0.36U AS=0.0936P AD=0.0432P
+ PS=0.88U PD=0.6U
* device instance $3550 r0 *1 549.795,827.08 nfet_05v0
M$3550 \$I4365 \$I4364 \$I4367 VSS nfet_05v0 L=0.6U W=0.36U AS=0.0432P
+ AD=0.369P PS=0.6U PD=2.77U
* device instance $3551 r0 *1 531.305,774.97 pfet_05v0
M$3551 \$I4377 \$I4372 \$I4373 VDD_DEC pfet_05v0 L=0.5U W=0.36U AS=0.3456P
+ AD=0.0612P PS=2.64U PD=0.7U
* device instance $3552 r0 *1 532.145,774.97 pfet_05v0
M$3552 \$I4377 \$I4372 VDD_DEC VDD_DEC pfet_05v0 L=0.5U W=0.36U AS=0.379P
+ AD=0.0612P PS=2.37U PD=0.7U
* device instance $3553 r0 *1 533.795,774.65 pfet_05v0
M$3553 \$167 \$I4373 VDD_DEC VDD_DEC pfet_05v0 L=0.5U W=1.22U AS=0.379P
+ AD=0.5368P PS=2.37U PD=3.32U
* device instance $3554 r0 *1 527.065,775.08 pfet_05v0
M$3554 VDD_DEC \$I2023 \$I4371 VDD_DEC pfet_05v0 L=0.5U W=0.36U AS=0.3852P
+ AD=0.1116P PS=2.86U PD=0.98U
* device instance $3555 r0 *1 528.185,775.08 pfet_05v0
M$3555 \$I4376 \$I4371 VDD_DEC VDD_DEC pfet_05v0 L=0.5U W=0.36U AS=0.1116P
+ AD=0.0612P PS=0.98U PD=0.7U
* device instance $3556 r0 *1 529.025,775.08 pfet_05v0
M$3556 \$I4376 \$I4371 \$I4372 VDD_DEC pfet_05v0 L=0.5U W=0.36U AS=0.3852P
+ AD=0.0612P PS=2.86U PD=0.7U
* device instance $3557 r0 *1 531.355,772.202 nfet_05v0
M$3557 \$I4375 \$I4372 \$I4373 VSS nfet_05v0 L=0.6U W=0.365U AS=0.3705P
+ AD=0.0438P PS=2.77U PD=0.605U
* device instance $3558 r0 *1 532.195,772.202 nfet_05v0
M$3558 VSS \$I4372 \$I4375 VSS nfet_05v0 L=0.6U W=0.365U AS=0.0438P
+ AD=0.282625P PS=0.605U PD=1.87U
* device instance $3559 r0 *1 533.845,772.43 nfet_05v0
M$3559 \$167 \$I4373 VSS VSS nfet_05v0 L=0.6U W=0.82U AS=0.282625P AD=0.3608P
+ PS=1.87U PD=2.52U
* device instance $3560 r0 *1 527.115,772.2 nfet_05v0
M$3560 VSS \$I2023 \$I4371 VSS nfet_05v0 L=0.6U W=0.36U AS=0.333P AD=0.0936P
+ PS=2.57U PD=0.88U
* device instance $3561 r0 *1 528.235,772.2 nfet_05v0
M$3561 \$I4374 \$I4371 VSS VSS nfet_05v0 L=0.6U W=0.36U AS=0.0936P AD=0.0432P
+ PS=0.88U PD=0.6U
* device instance $3562 r0 *1 529.075,772.2 nfet_05v0
M$3562 \$I4372 \$I4371 \$I4374 VSS nfet_05v0 L=0.6U W=0.36U AS=0.0432P
+ AD=0.369P PS=0.6U PD=2.77U
* device instance $3563 r0 *1 572.185,782.81 pfet_05v0
M$3563 \$I4384 \$I4379 \$I4380 VDD_DEC pfet_05v0 L=0.5U W=0.36U AS=0.3456P
+ AD=0.0612P PS=2.64U PD=0.7U
* device instance $3564 r0 *1 573.025,782.81 pfet_05v0
M$3564 \$I4384 \$I4379 VDD_DEC VDD_DEC pfet_05v0 L=0.5U W=0.36U AS=0.379P
+ AD=0.0612P PS=2.37U PD=0.7U
* device instance $3565 r0 *1 574.675,782.49 pfet_05v0
M$3565 \$183 \$I4380 VDD_DEC VDD_DEC pfet_05v0 L=0.5U W=1.22U AS=0.379P
+ AD=0.5368P PS=2.37U PD=3.32U
* device instance $3566 r0 *1 567.945,782.92 pfet_05v0
M$3566 VDD_DEC \$I2062 \$I4378 VDD_DEC pfet_05v0 L=0.5U W=0.36U AS=0.3852P
+ AD=0.1116P PS=2.86U PD=0.98U
* device instance $3567 r0 *1 569.065,782.92 pfet_05v0
M$3567 \$I4383 \$I4378 VDD_DEC VDD_DEC pfet_05v0 L=0.5U W=0.36U AS=0.1116P
+ AD=0.0612P PS=0.98U PD=0.7U
* device instance $3568 r0 *1 569.905,782.92 pfet_05v0
M$3568 \$I4383 \$I4378 \$I4379 VDD_DEC pfet_05v0 L=0.5U W=0.36U AS=0.3852P
+ AD=0.0612P PS=2.86U PD=0.7U
* device instance $3569 r0 *1 572.235,780.042 nfet_05v0
M$3569 \$I4382 \$I4379 \$I4380 VSS nfet_05v0 L=0.6U W=0.365U AS=0.3705P
+ AD=0.0438P PS=2.77U PD=0.605U
* device instance $3570 r0 *1 573.075,780.042 nfet_05v0
M$3570 VSS \$I4379 \$I4382 VSS nfet_05v0 L=0.6U W=0.365U AS=0.0438P
+ AD=0.282625P PS=0.605U PD=1.87U
* device instance $3571 r0 *1 574.725,780.27 nfet_05v0
M$3571 \$183 \$I4380 VSS VSS nfet_05v0 L=0.6U W=0.82U AS=0.282625P AD=0.3608P
+ PS=1.87U PD=2.52U
* device instance $3572 r0 *1 567.995,780.04 nfet_05v0
M$3572 VSS \$I2062 \$I4378 VSS nfet_05v0 L=0.6U W=0.36U AS=0.333P AD=0.0936P
+ PS=2.57U PD=0.88U
* device instance $3573 r0 *1 569.115,780.04 nfet_05v0
M$3573 \$I4381 \$I4378 VSS VSS nfet_05v0 L=0.6U W=0.36U AS=0.0936P AD=0.0432P
+ PS=0.88U PD=0.6U
* device instance $3574 r0 *1 569.955,780.04 nfet_05v0
M$3574 \$I4379 \$I4378 \$I4381 VSS nfet_05v0 L=0.6U W=0.36U AS=0.0432P
+ AD=0.369P PS=0.6U PD=2.77U
* device instance $3575 r0 *1 554.265,782.81 pfet_05v0
M$3575 \$I4391 \$I4386 \$I4387 VDD_DEC pfet_05v0 L=0.5U W=0.36U AS=0.3456P
+ AD=0.0612P PS=2.64U PD=0.7U
* device instance $3576 r0 *1 555.105,782.81 pfet_05v0
M$3576 \$I4391 \$I4386 VDD_DEC VDD_DEC pfet_05v0 L=0.5U W=0.36U AS=0.379P
+ AD=0.0612P PS=2.37U PD=0.7U
* device instance $3577 r0 *1 556.755,782.49 pfet_05v0
M$3577 \$150 \$I4387 VDD_DEC VDD_DEC pfet_05v0 L=0.5U W=1.22U AS=0.379P
+ AD=0.5368P PS=2.37U PD=3.32U
* device instance $3578 r0 *1 550.025,782.92 pfet_05v0
M$3578 VDD_DEC \$I2063 \$I4385 VDD_DEC pfet_05v0 L=0.5U W=0.36U AS=0.3852P
+ AD=0.1116P PS=2.86U PD=0.98U
* device instance $3579 r0 *1 551.145,782.92 pfet_05v0
M$3579 \$I4390 \$I4385 VDD_DEC VDD_DEC pfet_05v0 L=0.5U W=0.36U AS=0.1116P
+ AD=0.0612P PS=0.98U PD=0.7U
* device instance $3580 r0 *1 551.985,782.92 pfet_05v0
M$3580 \$I4390 \$I4385 \$I4386 VDD_DEC pfet_05v0 L=0.5U W=0.36U AS=0.3852P
+ AD=0.0612P PS=2.86U PD=0.7U
* device instance $3581 r0 *1 554.315,780.042 nfet_05v0
M$3581 \$I4389 \$I4386 \$I4387 VSS nfet_05v0 L=0.6U W=0.365U AS=0.3705P
+ AD=0.0438P PS=2.77U PD=0.605U
* device instance $3582 r0 *1 555.155,780.042 nfet_05v0
M$3582 VSS \$I4386 \$I4389 VSS nfet_05v0 L=0.6U W=0.365U AS=0.0438P
+ AD=0.282625P PS=0.605U PD=1.87U
* device instance $3583 r0 *1 556.805,780.27 nfet_05v0
M$3583 \$150 \$I4387 VSS VSS nfet_05v0 L=0.6U W=0.82U AS=0.282625P AD=0.3608P
+ PS=1.87U PD=2.52U
* device instance $3584 r0 *1 550.075,780.04 nfet_05v0
M$3584 VSS \$I2063 \$I4385 VSS nfet_05v0 L=0.6U W=0.36U AS=0.333P AD=0.0936P
+ PS=2.57U PD=0.88U
* device instance $3585 r0 *1 551.195,780.04 nfet_05v0
M$3585 \$I4388 \$I4385 VSS VSS nfet_05v0 L=0.6U W=0.36U AS=0.0936P AD=0.0432P
+ PS=0.88U PD=0.6U
* device instance $3586 r0 *1 552.035,780.04 nfet_05v0
M$3586 \$I4386 \$I4385 \$I4388 VSS nfet_05v0 L=0.6U W=0.36U AS=0.0432P
+ AD=0.369P PS=0.6U PD=2.77U
* device instance $3587 r0 *1 531.305,837.69 pfet_05v0
M$3587 \$I4398 \$I4393 \$I4394 VDD_DEC pfet_05v0 L=0.5U W=0.36U AS=0.3456P
+ AD=0.0612P PS=2.64U PD=0.7U
* device instance $3588 r0 *1 532.145,837.69 pfet_05v0
M$3588 \$I4398 \$I4393 VDD_DEC VDD_DEC pfet_05v0 L=0.5U W=0.36U AS=0.379P
+ AD=0.0612P PS=2.37U PD=0.7U
* device instance $3589 r0 *1 533.795,837.37 pfet_05v0
M$3589 \$I2365 \$I4394 VDD_DEC VDD_DEC pfet_05v0 L=0.5U W=1.22U AS=0.379P
+ AD=0.5368P PS=2.37U PD=3.32U
* device instance $3590 r0 *1 527.065,837.8 pfet_05v0
M$3590 VDD_DEC D[1] \$I4392 VDD_DEC pfet_05v0 L=0.5U W=0.36U AS=0.3852P
+ AD=0.1116P PS=2.86U PD=0.98U
* device instance $3591 r0 *1 528.185,837.8 pfet_05v0
M$3591 \$I4397 \$I4392 VDD_DEC VDD_DEC pfet_05v0 L=0.5U W=0.36U AS=0.1116P
+ AD=0.0612P PS=0.98U PD=0.7U
* device instance $3592 r0 *1 529.025,837.8 pfet_05v0
M$3592 \$I4397 \$I4392 \$I4393 VDD_DEC pfet_05v0 L=0.5U W=0.36U AS=0.3852P
+ AD=0.0612P PS=2.86U PD=0.7U
* device instance $3593 r0 *1 531.355,834.922 nfet_05v0
M$3593 \$I4396 \$I4393 \$I4394 VSS nfet_05v0 L=0.6U W=0.365U AS=0.3705P
+ AD=0.0438P PS=2.77U PD=0.605U
* device instance $3594 r0 *1 532.195,834.922 nfet_05v0
M$3594 VSS \$I4393 \$I4396 VSS nfet_05v0 L=0.6U W=0.365U AS=0.0438P
+ AD=0.282625P PS=0.605U PD=1.87U
* device instance $3595 r0 *1 533.845,835.15 nfet_05v0
M$3595 \$I2365 \$I4394 VSS VSS nfet_05v0 L=0.6U W=0.82U AS=0.282625P AD=0.3608P
+ PS=1.87U PD=2.52U
* device instance $3596 r0 *1 527.115,834.92 nfet_05v0
M$3596 VSS D[1] \$I4392 VSS nfet_05v0 L=0.6U W=0.36U AS=0.333P AD=0.0936P
+ PS=2.57U PD=0.88U
* device instance $3597 r0 *1 528.235,834.92 nfet_05v0
M$3597 \$I4395 \$I4392 VSS VSS nfet_05v0 L=0.6U W=0.36U AS=0.0936P AD=0.0432P
+ PS=0.88U PD=0.6U
* device instance $3598 r0 *1 529.075,834.92 nfet_05v0
M$3598 \$I4393 \$I4392 \$I4395 VSS nfet_05v0 L=0.6U W=0.36U AS=0.0432P
+ AD=0.369P PS=0.6U PD=2.77U
* device instance $3599 r0 *1 541.945,782.81 pfet_05v0
M$3599 \$I4405 \$I4400 \$I4401 VDD_DEC pfet_05v0 L=0.5U W=0.36U AS=0.3456P
+ AD=0.0612P PS=2.64U PD=0.7U
* device instance $3600 r0 *1 542.785,782.81 pfet_05v0
M$3600 \$I4405 \$I4400 VDD_DEC VDD_DEC pfet_05v0 L=0.5U W=0.36U AS=0.379P
+ AD=0.0612P PS=2.37U PD=0.7U
* device instance $3601 r0 *1 544.435,782.49 pfet_05v0
M$3601 \$176 \$I4401 VDD_DEC VDD_DEC pfet_05v0 L=0.5U W=1.22U AS=0.379P
+ AD=0.5368P PS=2.37U PD=3.32U
* device instance $3602 r0 *1 537.705,782.92 pfet_05v0
M$3602 VDD_DEC \$I2060 \$I4399 VDD_DEC pfet_05v0 L=0.5U W=0.36U AS=0.3852P
+ AD=0.1116P PS=2.86U PD=0.98U
* device instance $3603 r0 *1 538.825,782.92 pfet_05v0
M$3603 \$I4404 \$I4399 VDD_DEC VDD_DEC pfet_05v0 L=0.5U W=0.36U AS=0.1116P
+ AD=0.0612P PS=0.98U PD=0.7U
* device instance $3604 r0 *1 539.665,782.92 pfet_05v0
M$3604 \$I4404 \$I4399 \$I4400 VDD_DEC pfet_05v0 L=0.5U W=0.36U AS=0.3852P
+ AD=0.0612P PS=2.86U PD=0.7U
* device instance $3605 r0 *1 541.995,780.042 nfet_05v0
M$3605 \$I4403 \$I4400 \$I4401 VSS nfet_05v0 L=0.6U W=0.365U AS=0.3705P
+ AD=0.0438P PS=2.77U PD=0.605U
* device instance $3606 r0 *1 542.835,780.042 nfet_05v0
M$3606 VSS \$I4400 \$I4403 VSS nfet_05v0 L=0.6U W=0.365U AS=0.0438P
+ AD=0.282625P PS=0.605U PD=1.87U
* device instance $3607 r0 *1 544.485,780.27 nfet_05v0
M$3607 \$176 \$I4401 VSS VSS nfet_05v0 L=0.6U W=0.82U AS=0.282625P AD=0.3608P
+ PS=1.87U PD=2.52U
* device instance $3608 r0 *1 537.755,780.04 nfet_05v0
M$3608 VSS \$I2060 \$I4399 VSS nfet_05v0 L=0.6U W=0.36U AS=0.333P AD=0.0936P
+ PS=2.57U PD=0.88U
* device instance $3609 r0 *1 538.875,780.04 nfet_05v0
M$3609 \$I4402 \$I4399 VSS VSS nfet_05v0 L=0.6U W=0.36U AS=0.0936P AD=0.0432P
+ PS=0.88U PD=0.6U
* device instance $3610 r0 *1 539.715,780.04 nfet_05v0
M$3610 \$I4400 \$I4399 \$I4402 VSS nfet_05v0 L=0.6U W=0.36U AS=0.0432P
+ AD=0.369P PS=0.6U PD=2.77U
* device instance $3611 r0 *1 569.385,774.97 pfet_05v0
M$3611 \$I4412 \$I4407 \$I4408 VDD_DEC pfet_05v0 L=0.5U W=0.36U AS=0.3456P
+ AD=0.0612P PS=2.64U PD=0.7U
* device instance $3612 r0 *1 570.225,774.97 pfet_05v0
M$3612 \$I4412 \$I4407 VDD_DEC VDD_DEC pfet_05v0 L=0.5U W=0.36U AS=0.379P
+ AD=0.0612P PS=2.37U PD=0.7U
* device instance $3613 r0 *1 571.875,774.65 pfet_05v0
M$3613 \$189 \$I4408 VDD_DEC VDD_DEC pfet_05v0 L=0.5U W=1.22U AS=0.379P
+ AD=0.5368P PS=2.37U PD=3.32U
* device instance $3614 r0 *1 565.145,775.08 pfet_05v0
M$3614 VDD_DEC \$I2027 \$I4406 VDD_DEC pfet_05v0 L=0.5U W=0.36U AS=0.3852P
+ AD=0.1116P PS=2.86U PD=0.98U
* device instance $3615 r0 *1 566.265,775.08 pfet_05v0
M$3615 \$I4411 \$I4406 VDD_DEC VDD_DEC pfet_05v0 L=0.5U W=0.36U AS=0.1116P
+ AD=0.0612P PS=0.98U PD=0.7U
* device instance $3616 r0 *1 567.105,775.08 pfet_05v0
M$3616 \$I4411 \$I4406 \$I4407 VDD_DEC pfet_05v0 L=0.5U W=0.36U AS=0.3852P
+ AD=0.0612P PS=2.86U PD=0.7U
* device instance $3617 r0 *1 569.435,772.202 nfet_05v0
M$3617 \$I4410 \$I4407 \$I4408 VSS nfet_05v0 L=0.6U W=0.365U AS=0.3705P
+ AD=0.0438P PS=2.77U PD=0.605U
* device instance $3618 r0 *1 570.275,772.202 nfet_05v0
M$3618 VSS \$I4407 \$I4410 VSS nfet_05v0 L=0.6U W=0.365U AS=0.0438P
+ AD=0.282625P PS=0.605U PD=1.87U
* device instance $3619 r0 *1 571.925,772.43 nfet_05v0
M$3619 \$189 \$I4408 VSS VSS nfet_05v0 L=0.6U W=0.82U AS=0.282625P AD=0.3608P
+ PS=1.87U PD=2.52U
* device instance $3620 r0 *1 565.195,772.2 nfet_05v0
M$3620 VSS \$I2027 \$I4406 VSS nfet_05v0 L=0.6U W=0.36U AS=0.333P AD=0.0936P
+ PS=2.57U PD=0.88U
* device instance $3621 r0 *1 566.315,772.2 nfet_05v0
M$3621 \$I4409 \$I4406 VSS VSS nfet_05v0 L=0.6U W=0.36U AS=0.0936P AD=0.0432P
+ PS=0.88U PD=0.6U
* device instance $3622 r0 *1 567.155,772.2 nfet_05v0
M$3622 \$I4407 \$I4406 \$I4409 VSS nfet_05v0 L=0.6U W=0.36U AS=0.0432P
+ AD=0.369P PS=0.6U PD=2.77U
* device instance $3623 r0 *1 540.265,774.97 pfet_05v0
M$3623 \$I4419 \$I4414 \$I4415 VDD_DEC pfet_05v0 L=0.5U W=0.36U AS=0.3456P
+ AD=0.0612P PS=2.64U PD=0.7U
* device instance $3624 r0 *1 541.105,774.97 pfet_05v0
M$3624 \$I4419 \$I4414 VDD_DEC VDD_DEC pfet_05v0 L=0.5U W=0.36U AS=0.379P
+ AD=0.0612P PS=2.37U PD=0.7U
* device instance $3625 r0 *1 542.755,774.65 pfet_05v0
M$3625 \$188 \$I4415 VDD_DEC VDD_DEC pfet_05v0 L=0.5U W=1.22U AS=0.379P
+ AD=0.5368P PS=2.37U PD=3.32U
* device instance $3626 r0 *1 536.025,775.08 pfet_05v0
M$3626 VDD_DEC \$I2024 \$I4413 VDD_DEC pfet_05v0 L=0.5U W=0.36U AS=0.3852P
+ AD=0.1116P PS=2.86U PD=0.98U
* device instance $3627 r0 *1 537.145,775.08 pfet_05v0
M$3627 \$I4418 \$I4413 VDD_DEC VDD_DEC pfet_05v0 L=0.5U W=0.36U AS=0.1116P
+ AD=0.0612P PS=0.98U PD=0.7U
* device instance $3628 r0 *1 537.985,775.08 pfet_05v0
M$3628 \$I4418 \$I4413 \$I4414 VDD_DEC pfet_05v0 L=0.5U W=0.36U AS=0.3852P
+ AD=0.0612P PS=2.86U PD=0.7U
* device instance $3629 r0 *1 540.315,772.202 nfet_05v0
M$3629 \$I4417 \$I4414 \$I4415 VSS nfet_05v0 L=0.6U W=0.365U AS=0.3705P
+ AD=0.0438P PS=2.77U PD=0.605U
* device instance $3630 r0 *1 541.155,772.202 nfet_05v0
M$3630 VSS \$I4414 \$I4417 VSS nfet_05v0 L=0.6U W=0.365U AS=0.0438P
+ AD=0.282625P PS=0.605U PD=1.87U
* device instance $3631 r0 *1 542.805,772.43 nfet_05v0
M$3631 \$188 \$I4415 VSS VSS nfet_05v0 L=0.6U W=0.82U AS=0.282625P AD=0.3608P
+ PS=1.87U PD=2.52U
* device instance $3632 r0 *1 536.075,772.2 nfet_05v0
M$3632 VSS \$I2024 \$I4413 VSS nfet_05v0 L=0.6U W=0.36U AS=0.333P AD=0.0936P
+ PS=2.57U PD=0.88U
* device instance $3633 r0 *1 537.195,772.2 nfet_05v0
M$3633 \$I4416 \$I4413 VSS VSS nfet_05v0 L=0.6U W=0.36U AS=0.0936P AD=0.0432P
+ PS=0.88U PD=0.6U
* device instance $3634 r0 *1 538.035,772.2 nfet_05v0
M$3634 \$I4414 \$I4413 \$I4416 VSS nfet_05v0 L=0.6U W=0.36U AS=0.0432P
+ AD=0.369P PS=0.6U PD=2.77U
* device instance $3635 r0 *1 652.265,806.33 pfet_05v0
M$3635 \$I4426 \$I4421 \$I4422 VDD_DEC pfet_05v0 L=0.5U W=0.36U AS=0.3456P
+ AD=0.0612P PS=2.64U PD=0.7U
* device instance $3636 r0 *1 653.105,806.33 pfet_05v0
M$3636 \$I4426 \$I4421 VDD_DEC VDD_DEC pfet_05v0 L=0.5U W=0.36U AS=0.379P
+ AD=0.0612P PS=2.37U PD=0.7U
* device instance $3637 r0 *1 654.755,806.01 pfet_05v0
M$3637 \$I2139 \$I4422 VDD_DEC VDD_DEC pfet_05v0 L=0.5U W=1.22U AS=0.379P
+ AD=0.5368P PS=2.37U PD=3.32U
* device instance $3638 r0 *1 648.025,806.44 pfet_05v0
M$3638 VDD_DEC \$I2176 \$I4420 VDD_DEC pfet_05v0 L=0.5U W=0.36U AS=0.3852P
+ AD=0.1116P PS=2.86U PD=0.98U
* device instance $3639 r0 *1 649.145,806.44 pfet_05v0
M$3639 \$I4425 \$I4420 VDD_DEC VDD_DEC pfet_05v0 L=0.5U W=0.36U AS=0.1116P
+ AD=0.0612P PS=0.98U PD=0.7U
* device instance $3640 r0 *1 649.985,806.44 pfet_05v0
M$3640 \$I4425 \$I4420 \$I4421 VDD_DEC pfet_05v0 L=0.5U W=0.36U AS=0.3852P
+ AD=0.0612P PS=2.86U PD=0.7U
* device instance $3641 r0 *1 652.315,803.562 nfet_05v0
M$3641 \$I4424 \$I4421 \$I4422 VSS nfet_05v0 L=0.6U W=0.365U AS=0.3705P
+ AD=0.0438P PS=2.77U PD=0.605U
* device instance $3642 r0 *1 653.155,803.562 nfet_05v0
M$3642 VSS \$I4421 \$I4424 VSS nfet_05v0 L=0.6U W=0.365U AS=0.0438P
+ AD=0.282625P PS=0.605U PD=1.87U
* device instance $3643 r0 *1 654.805,803.79 nfet_05v0
M$3643 \$I2139 \$I4422 VSS VSS nfet_05v0 L=0.6U W=0.82U AS=0.282625P AD=0.3608P
+ PS=1.87U PD=2.52U
* device instance $3644 r0 *1 648.075,803.56 nfet_05v0
M$3644 VSS \$I2176 \$I4420 VSS nfet_05v0 L=0.6U W=0.36U AS=0.333P AD=0.0936P
+ PS=2.57U PD=0.88U
* device instance $3645 r0 *1 649.195,803.56 nfet_05v0
M$3645 \$I4423 \$I4420 VSS VSS nfet_05v0 L=0.6U W=0.36U AS=0.0936P AD=0.0432P
+ PS=0.88U PD=0.6U
* device instance $3646 r0 *1 650.035,803.56 nfet_05v0
M$3646 \$I4421 \$I4420 \$I4423 VSS nfet_05v0 L=0.6U W=0.36U AS=0.0432P
+ AD=0.369P PS=0.6U PD=2.77U
* device instance $3647 r0 *1 539.705,822.01 pfet_05v0
M$3647 \$I4433 \$I4428 \$I4429 VDD_DEC pfet_05v0 L=0.5U W=0.36U AS=0.3456P
+ AD=0.0612P PS=2.64U PD=0.7U
* device instance $3648 r0 *1 540.545,822.01 pfet_05v0
M$3648 \$I4433 \$I4428 VDD_DEC VDD_DEC pfet_05v0 L=0.5U W=0.36U AS=0.379P
+ AD=0.0612P PS=2.37U PD=0.7U
* device instance $3649 r0 *1 542.195,821.69 pfet_05v0
M$3649 \$I2322 \$I4429 VDD_DEC VDD_DEC pfet_05v0 L=0.5U W=1.22U AS=0.379P
+ AD=0.5368P PS=2.37U PD=3.32U
* device instance $3650 r0 *1 535.465,822.12 pfet_05v0
M$3650 VDD_DEC \$I2365 \$I4427 VDD_DEC pfet_05v0 L=0.5U W=0.36U AS=0.3852P
+ AD=0.1116P PS=2.86U PD=0.98U
* device instance $3651 r0 *1 536.585,822.12 pfet_05v0
M$3651 \$I4432 \$I4427 VDD_DEC VDD_DEC pfet_05v0 L=0.5U W=0.36U AS=0.1116P
+ AD=0.0612P PS=0.98U PD=0.7U
* device instance $3652 r0 *1 537.425,822.12 pfet_05v0
M$3652 \$I4432 \$I4427 \$I4428 VDD_DEC pfet_05v0 L=0.5U W=0.36U AS=0.3852P
+ AD=0.0612P PS=2.86U PD=0.7U
* device instance $3653 r0 *1 539.755,819.242 nfet_05v0
M$3653 \$I4431 \$I4428 \$I4429 VSS nfet_05v0 L=0.6U W=0.365U AS=0.3705P
+ AD=0.0438P PS=2.77U PD=0.605U
* device instance $3654 r0 *1 540.595,819.242 nfet_05v0
M$3654 VSS \$I4428 \$I4431 VSS nfet_05v0 L=0.6U W=0.365U AS=0.0438P
+ AD=0.282625P PS=0.605U PD=1.87U
* device instance $3655 r0 *1 542.245,819.47 nfet_05v0
M$3655 \$I2322 \$I4429 VSS VSS nfet_05v0 L=0.6U W=0.82U AS=0.282625P AD=0.3608P
+ PS=1.87U PD=2.52U
* device instance $3656 r0 *1 535.515,819.24 nfet_05v0
M$3656 VSS \$I2365 \$I4427 VSS nfet_05v0 L=0.6U W=0.36U AS=0.333P AD=0.0936P
+ PS=2.57U PD=0.88U
* device instance $3657 r0 *1 536.635,819.24 nfet_05v0
M$3657 \$I4430 \$I4427 VSS VSS nfet_05v0 L=0.6U W=0.36U AS=0.0936P AD=0.0432P
+ PS=0.88U PD=0.6U
* device instance $3658 r0 *1 537.475,819.24 nfet_05v0
M$3658 \$I4428 \$I4427 \$I4430 VSS nfet_05v0 L=0.6U W=0.36U AS=0.0432P
+ AD=0.369P PS=0.6U PD=2.77U
* device instance $3659 r0 *1 532.985,782.81 pfet_05v0
M$3659 \$I4440 \$I4435 \$I4436 VDD_DEC pfet_05v0 L=0.5U W=0.36U AS=0.3456P
+ AD=0.0612P PS=2.64U PD=0.7U
* device instance $3660 r0 *1 533.825,782.81 pfet_05v0
M$3660 \$I4440 \$I4435 VDD_DEC VDD_DEC pfet_05v0 L=0.5U W=0.36U AS=0.379P
+ AD=0.0612P PS=2.37U PD=0.7U
* device instance $3661 r0 *1 535.475,782.49 pfet_05v0
M$3661 \$158 \$I4436 VDD_DEC VDD_DEC pfet_05v0 L=0.5U W=1.22U AS=0.379P
+ AD=0.5368P PS=2.37U PD=3.32U
* device instance $3662 r0 *1 528.745,782.92 pfet_05v0
M$3662 VDD_DEC \$I2051 \$I4434 VDD_DEC pfet_05v0 L=0.5U W=0.36U AS=0.3852P
+ AD=0.1116P PS=2.86U PD=0.98U
* device instance $3663 r0 *1 529.865,782.92 pfet_05v0
M$3663 \$I4439 \$I4434 VDD_DEC VDD_DEC pfet_05v0 L=0.5U W=0.36U AS=0.1116P
+ AD=0.0612P PS=0.98U PD=0.7U
* device instance $3664 r0 *1 530.705,782.92 pfet_05v0
M$3664 \$I4439 \$I4434 \$I4435 VDD_DEC pfet_05v0 L=0.5U W=0.36U AS=0.3852P
+ AD=0.0612P PS=2.86U PD=0.7U
* device instance $3665 r0 *1 533.035,780.042 nfet_05v0
M$3665 \$I4438 \$I4435 \$I4436 VSS nfet_05v0 L=0.6U W=0.365U AS=0.3705P
+ AD=0.0438P PS=2.77U PD=0.605U
* device instance $3666 r0 *1 533.875,780.042 nfet_05v0
M$3666 VSS \$I4435 \$I4438 VSS nfet_05v0 L=0.6U W=0.365U AS=0.0438P
+ AD=0.282625P PS=0.605U PD=1.87U
* device instance $3667 r0 *1 535.525,780.27 nfet_05v0
M$3667 \$158 \$I4436 VSS VSS nfet_05v0 L=0.6U W=0.82U AS=0.282625P AD=0.3608P
+ PS=1.87U PD=2.52U
* device instance $3668 r0 *1 528.795,780.04 nfet_05v0
M$3668 VSS \$I2051 \$I4434 VSS nfet_05v0 L=0.6U W=0.36U AS=0.333P AD=0.0936P
+ PS=2.57U PD=0.88U
* device instance $3669 r0 *1 529.915,780.04 nfet_05v0
M$3669 \$I4437 \$I4434 VSS VSS nfet_05v0 L=0.6U W=0.36U AS=0.0936P AD=0.0432P
+ PS=0.88U PD=0.6U
* device instance $3670 r0 *1 530.755,780.04 nfet_05v0
M$3670 \$I4435 \$I4434 \$I4437 VSS nfet_05v0 L=0.6U W=0.36U AS=0.0432P
+ AD=0.369P PS=0.6U PD=2.77U
* device instance $3671 r0 *1 516.745,790.65 pfet_05v0
M$3671 \$I4447 \$I4442 \$I4443 VDD_DEC pfet_05v0 L=0.5U W=0.36U AS=0.3456P
+ AD=0.0612P PS=2.64U PD=0.7U
* device instance $3672 r0 *1 517.585,790.65 pfet_05v0
M$3672 \$I4447 \$I4442 VDD_DEC VDD_DEC pfet_05v0 L=0.5U W=0.36U AS=0.379P
+ AD=0.0612P PS=2.37U PD=0.7U
* device instance $3673 r0 *1 519.235,790.33 pfet_05v0
M$3673 \$145 \$I4443 VDD_DEC VDD_DEC pfet_05v0 L=0.5U W=1.22U AS=0.379P
+ AD=0.5368P PS=2.37U PD=3.32U
* device instance $3674 r0 *1 512.505,790.76 pfet_05v0
M$3674 VDD_DEC \$I2161 \$I4441 VDD_DEC pfet_05v0 L=0.5U W=0.36U AS=0.3852P
+ AD=0.1116P PS=2.86U PD=0.98U
* device instance $3675 r0 *1 513.625,790.76 pfet_05v0
M$3675 \$I4446 \$I4441 VDD_DEC VDD_DEC pfet_05v0 L=0.5U W=0.36U AS=0.1116P
+ AD=0.0612P PS=0.98U PD=0.7U
* device instance $3676 r0 *1 514.465,790.76 pfet_05v0
M$3676 \$I4446 \$I4441 \$I4442 VDD_DEC pfet_05v0 L=0.5U W=0.36U AS=0.3852P
+ AD=0.0612P PS=2.86U PD=0.7U
* device instance $3677 r0 *1 516.795,787.882 nfet_05v0
M$3677 \$I4445 \$I4442 \$I4443 VSS nfet_05v0 L=0.6U W=0.365U AS=0.3705P
+ AD=0.0438P PS=2.77U PD=0.605U
* device instance $3678 r0 *1 517.635,787.882 nfet_05v0
M$3678 VSS \$I4442 \$I4445 VSS nfet_05v0 L=0.6U W=0.365U AS=0.0438P
+ AD=0.282625P PS=0.605U PD=1.87U
* device instance $3679 r0 *1 519.285,788.11 nfet_05v0
M$3679 \$145 \$I4443 VSS VSS nfet_05v0 L=0.6U W=0.82U AS=0.282625P AD=0.3608P
+ PS=1.87U PD=2.52U
* device instance $3680 r0 *1 512.555,787.88 nfet_05v0
M$3680 VSS \$I2161 \$I4441 VSS nfet_05v0 L=0.6U W=0.36U AS=0.333P AD=0.0936P
+ PS=2.57U PD=0.88U
* device instance $3681 r0 *1 513.675,787.88 nfet_05v0
M$3681 \$I4444 \$I4441 VSS VSS nfet_05v0 L=0.6U W=0.36U AS=0.0936P AD=0.0432P
+ PS=0.88U PD=0.6U
* device instance $3682 r0 *1 514.515,787.88 nfet_05v0
M$3682 \$I4442 \$I4441 \$I4444 VSS nfet_05v0 L=0.6U W=0.36U AS=0.0432P
+ AD=0.369P PS=0.6U PD=2.77U
* device instance $3683 r0 *1 655.065,798.49 pfet_05v0
M$3683 \$I4454 \$I4449 \$I4450 VDD_DEC pfet_05v0 L=0.5U W=0.36U AS=0.3456P
+ AD=0.0612P PS=2.64U PD=0.7U
* device instance $3684 r0 *1 655.905,798.49 pfet_05v0
M$3684 \$I4454 \$I4449 VDD_DEC VDD_DEC pfet_05v0 L=0.5U W=0.36U AS=0.379P
+ AD=0.0612P PS=2.37U PD=0.7U
* device instance $3685 r0 *1 657.555,798.17 pfet_05v0
M$3685 \$I2178 \$I4450 VDD_DEC VDD_DEC pfet_05v0 L=0.5U W=1.22U AS=0.379P
+ AD=0.5368P PS=2.37U PD=3.32U
* device instance $3686 r0 *1 650.825,798.6 pfet_05v0
M$3686 VDD_DEC \$I2139 \$I4448 VDD_DEC pfet_05v0 L=0.5U W=0.36U AS=0.3852P
+ AD=0.1116P PS=2.86U PD=0.98U
* device instance $3687 r0 *1 651.945,798.6 pfet_05v0
M$3687 \$I4453 \$I4448 VDD_DEC VDD_DEC pfet_05v0 L=0.5U W=0.36U AS=0.1116P
+ AD=0.0612P PS=0.98U PD=0.7U
* device instance $3688 r0 *1 652.785,798.6 pfet_05v0
M$3688 \$I4453 \$I4448 \$I4449 VDD_DEC pfet_05v0 L=0.5U W=0.36U AS=0.3852P
+ AD=0.0612P PS=2.86U PD=0.7U
* device instance $3689 r0 *1 655.115,795.722 nfet_05v0
M$3689 \$I4452 \$I4449 \$I4450 VSS nfet_05v0 L=0.6U W=0.365U AS=0.3705P
+ AD=0.0438P PS=2.77U PD=0.605U
* device instance $3690 r0 *1 655.955,795.722 nfet_05v0
M$3690 VSS \$I4449 \$I4452 VSS nfet_05v0 L=0.6U W=0.365U AS=0.0438P
+ AD=0.282625P PS=0.605U PD=1.87U
* device instance $3691 r0 *1 657.605,795.95 nfet_05v0
M$3691 \$I2178 \$I4450 VSS VSS nfet_05v0 L=0.6U W=0.82U AS=0.282625P AD=0.3608P
+ PS=1.87U PD=2.52U
* device instance $3692 r0 *1 650.875,795.72 nfet_05v0
M$3692 VSS \$I2139 \$I4448 VSS nfet_05v0 L=0.6U W=0.36U AS=0.333P AD=0.0936P
+ PS=2.57U PD=0.88U
* device instance $3693 r0 *1 651.995,795.72 nfet_05v0
M$3693 \$I4451 \$I4448 VSS VSS nfet_05v0 L=0.6U W=0.36U AS=0.0936P AD=0.0432P
+ PS=0.88U PD=0.6U
* device instance $3694 r0 *1 652.835,795.72 nfet_05v0
M$3694 \$I4449 \$I4448 \$I4451 VSS nfet_05v0 L=0.6U W=0.36U AS=0.0432P
+ AD=0.369P PS=0.6U PD=2.77U
* device instance $3695 r0 *1 646.105,798.49 pfet_05v0
M$3695 \$I4461 \$I4456 \$I4457 VDD_DEC pfet_05v0 L=0.5U W=0.36U AS=0.3456P
+ AD=0.0612P PS=2.64U PD=0.7U
* device instance $3696 r0 *1 646.945,798.49 pfet_05v0
M$3696 \$I4461 \$I4456 VDD_DEC VDD_DEC pfet_05v0 L=0.5U W=0.36U AS=0.379P
+ AD=0.0612P PS=2.37U PD=0.7U
* device instance $3697 r0 *1 648.595,798.17 pfet_05v0
M$3697 \$I2179 \$I4457 VDD_DEC VDD_DEC pfet_05v0 L=0.5U W=1.22U AS=0.379P
+ AD=0.5368P PS=2.37U PD=3.32U
* device instance $3698 r0 *1 641.865,798.6 pfet_05v0
M$3698 VDD_DEC \$I2243 \$I4455 VDD_DEC pfet_05v0 L=0.5U W=0.36U AS=0.3852P
+ AD=0.1116P PS=2.86U PD=0.98U
* device instance $3699 r0 *1 642.985,798.6 pfet_05v0
M$3699 \$I4460 \$I4455 VDD_DEC VDD_DEC pfet_05v0 L=0.5U W=0.36U AS=0.1116P
+ AD=0.0612P PS=0.98U PD=0.7U
* device instance $3700 r0 *1 643.825,798.6 pfet_05v0
M$3700 \$I4460 \$I4455 \$I4456 VDD_DEC pfet_05v0 L=0.5U W=0.36U AS=0.3852P
+ AD=0.0612P PS=2.86U PD=0.7U
* device instance $3701 r0 *1 646.155,795.722 nfet_05v0
M$3701 \$I4459 \$I4456 \$I4457 VSS nfet_05v0 L=0.6U W=0.365U AS=0.3705P
+ AD=0.0438P PS=2.77U PD=0.605U
* device instance $3702 r0 *1 646.995,795.722 nfet_05v0
M$3702 VSS \$I4456 \$I4459 VSS nfet_05v0 L=0.6U W=0.365U AS=0.0438P
+ AD=0.282625P PS=0.605U PD=1.87U
* device instance $3703 r0 *1 648.645,795.95 nfet_05v0
M$3703 \$I2179 \$I4457 VSS VSS nfet_05v0 L=0.6U W=0.82U AS=0.282625P AD=0.3608P
+ PS=1.87U PD=2.52U
* device instance $3704 r0 *1 641.915,795.72 nfet_05v0
M$3704 VSS \$I2243 \$I4455 VSS nfet_05v0 L=0.6U W=0.36U AS=0.333P AD=0.0936P
+ PS=2.57U PD=0.88U
* device instance $3705 r0 *1 643.035,795.72 nfet_05v0
M$3705 \$I4458 \$I4455 VSS VSS nfet_05v0 L=0.6U W=0.36U AS=0.0936P AD=0.0432P
+ PS=0.88U PD=0.6U
* device instance $3706 r0 *1 643.875,795.72 nfet_05v0
M$3706 \$I4456 \$I4455 \$I4458 VSS nfet_05v0 L=0.6U W=0.36U AS=0.0432P
+ AD=0.369P PS=0.6U PD=2.77U
* device instance $3707 r0 *1 525.705,790.65 pfet_05v0
M$3707 \$I4468 \$I4463 \$I4464 VDD_DEC pfet_05v0 L=0.5U W=0.36U AS=0.3456P
+ AD=0.0612P PS=2.64U PD=0.7U
* device instance $3708 r0 *1 526.545,790.65 pfet_05v0
M$3708 \$I4468 \$I4463 VDD_DEC VDD_DEC pfet_05v0 L=0.5U W=0.36U AS=0.379P
+ AD=0.0612P PS=2.37U PD=0.7U
* device instance $3709 r0 *1 528.195,790.33 pfet_05v0
M$3709 \$172 \$I4464 VDD_DEC VDD_DEC pfet_05v0 L=0.5U W=1.22U AS=0.379P
+ AD=0.5368P PS=2.37U PD=3.32U
* device instance $3710 r0 *1 521.465,790.76 pfet_05v0
M$3710 VDD_DEC \$I2162 \$I4462 VDD_DEC pfet_05v0 L=0.5U W=0.36U AS=0.3852P
+ AD=0.1116P PS=2.86U PD=0.98U
* device instance $3711 r0 *1 522.585,790.76 pfet_05v0
M$3711 \$I4467 \$I4462 VDD_DEC VDD_DEC pfet_05v0 L=0.5U W=0.36U AS=0.1116P
+ AD=0.0612P PS=0.98U PD=0.7U
* device instance $3712 r0 *1 523.425,790.76 pfet_05v0
M$3712 \$I4467 \$I4462 \$I4463 VDD_DEC pfet_05v0 L=0.5U W=0.36U AS=0.3852P
+ AD=0.0612P PS=2.86U PD=0.7U
* device instance $3713 r0 *1 525.755,787.882 nfet_05v0
M$3713 \$I4466 \$I4463 \$I4464 VSS nfet_05v0 L=0.6U W=0.365U AS=0.3705P
+ AD=0.0438P PS=2.77U PD=0.605U
* device instance $3714 r0 *1 526.595,787.882 nfet_05v0
M$3714 VSS \$I4463 \$I4466 VSS nfet_05v0 L=0.6U W=0.365U AS=0.0438P
+ AD=0.282625P PS=0.605U PD=1.87U
* device instance $3715 r0 *1 528.245,788.11 nfet_05v0
M$3715 \$172 \$I4464 VSS VSS nfet_05v0 L=0.6U W=0.82U AS=0.282625P AD=0.3608P
+ PS=1.87U PD=2.52U
* device instance $3716 r0 *1 521.515,787.88 nfet_05v0
M$3716 VSS \$I2162 \$I4462 VSS nfet_05v0 L=0.6U W=0.36U AS=0.333P AD=0.0936P
+ PS=2.57U PD=0.88U
* device instance $3717 r0 *1 522.635,787.88 nfet_05v0
M$3717 \$I4465 \$I4462 VSS VSS nfet_05v0 L=0.6U W=0.36U AS=0.0936P AD=0.0432P
+ PS=0.88U PD=0.6U
* device instance $3718 r0 *1 523.475,787.88 nfet_05v0
M$3718 \$I4463 \$I4462 \$I4465 VSS nfet_05v0 L=0.6U W=0.36U AS=0.0432P
+ AD=0.369P PS=0.6U PD=2.77U
* device instance $3719 r0 *1 502.745,790.65 pfet_05v0
M$3719 \$I4475 \$I4470 \$I4471 VDD_DEC pfet_05v0 L=0.5U W=0.36U AS=0.3456P
+ AD=0.0612P PS=2.64U PD=0.7U
* device instance $3720 r0 *1 503.585,790.65 pfet_05v0
M$3720 \$I4475 \$I4470 VDD_DEC VDD_DEC pfet_05v0 L=0.5U W=0.36U AS=0.379P
+ AD=0.0612P PS=2.37U PD=0.7U
* device instance $3721 r0 *1 505.235,790.33 pfet_05v0
M$3721 \$272 \$I4471 VDD_DEC VDD_DEC pfet_05v0 L=0.5U W=1.22U AS=0.379P
+ AD=0.5368P PS=2.37U PD=3.32U
* device instance $3722 r0 *1 498.505,790.76 pfet_05v0
M$3722 VDD_DEC \$I2160 \$I4469 VDD_DEC pfet_05v0 L=0.5U W=0.36U AS=0.3852P
+ AD=0.1116P PS=2.86U PD=0.98U
* device instance $3723 r0 *1 499.625,790.76 pfet_05v0
M$3723 \$I4474 \$I4469 VDD_DEC VDD_DEC pfet_05v0 L=0.5U W=0.36U AS=0.1116P
+ AD=0.0612P PS=0.98U PD=0.7U
* device instance $3724 r0 *1 500.465,790.76 pfet_05v0
M$3724 \$I4474 \$I4469 \$I4470 VDD_DEC pfet_05v0 L=0.5U W=0.36U AS=0.3852P
+ AD=0.0612P PS=2.86U PD=0.7U
* device instance $3725 r0 *1 502.795,787.882 nfet_05v0
M$3725 \$I4473 \$I4470 \$I4471 VSS nfet_05v0 L=0.6U W=0.365U AS=0.3705P
+ AD=0.0438P PS=2.77U PD=0.605U
* device instance $3726 r0 *1 503.635,787.882 nfet_05v0
M$3726 VSS \$I4470 \$I4473 VSS nfet_05v0 L=0.6U W=0.365U AS=0.0438P
+ AD=0.282625P PS=0.605U PD=1.87U
* device instance $3727 r0 *1 505.285,788.11 nfet_05v0
M$3727 \$272 \$I4471 VSS VSS nfet_05v0 L=0.6U W=0.82U AS=0.282625P AD=0.3608P
+ PS=1.87U PD=2.52U
* device instance $3728 r0 *1 498.555,787.88 nfet_05v0
M$3728 VSS \$I2160 \$I4469 VSS nfet_05v0 L=0.6U W=0.36U AS=0.333P AD=0.0936P
+ PS=2.57U PD=0.88U
* device instance $3729 r0 *1 499.675,787.88 nfet_05v0
M$3729 \$I4472 \$I4469 VSS VSS nfet_05v0 L=0.6U W=0.36U AS=0.0936P AD=0.0432P
+ PS=0.88U PD=0.6U
* device instance $3730 r0 *1 500.515,787.88 nfet_05v0
M$3730 \$I4470 \$I4469 \$I4472 VSS nfet_05v0 L=0.6U W=0.36U AS=0.0432P
+ AD=0.369P PS=0.6U PD=2.77U
* device instance $3731 r0 *1 617.545,814.17 pfet_05v0
M$3731 \$I4482 \$I4477 \$I4478 VDD_DEC pfet_05v0 L=0.5U W=0.36U AS=0.3456P
+ AD=0.0612P PS=2.64U PD=0.7U
* device instance $3732 r0 *1 618.385,814.17 pfet_05v0
M$3732 \$I4482 \$I4477 VDD_DEC VDD_DEC pfet_05v0 L=0.5U W=0.36U AS=0.379P
+ AD=0.0612P PS=2.37U PD=0.7U
* device instance $3733 r0 *1 620.035,813.85 pfet_05v0
M$3733 \$I2287 \$I4478 VDD_DEC VDD_DEC pfet_05v0 L=0.5U W=1.22U AS=0.379P
+ AD=0.5368P PS=2.37U PD=3.32U
* device instance $3734 r0 *1 613.305,814.28 pfet_05v0
M$3734 VDD_DEC \$I2341 \$I4476 VDD_DEC pfet_05v0 L=0.5U W=0.36U AS=0.3852P
+ AD=0.1116P PS=2.86U PD=0.98U
* device instance $3735 r0 *1 614.425,814.28 pfet_05v0
M$3735 \$I4481 \$I4476 VDD_DEC VDD_DEC pfet_05v0 L=0.5U W=0.36U AS=0.1116P
+ AD=0.0612P PS=0.98U PD=0.7U
* device instance $3736 r0 *1 615.265,814.28 pfet_05v0
M$3736 \$I4481 \$I4476 \$I4477 VDD_DEC pfet_05v0 L=0.5U W=0.36U AS=0.3852P
+ AD=0.0612P PS=2.86U PD=0.7U
* device instance $3737 r0 *1 617.595,811.402 nfet_05v0
M$3737 \$I4480 \$I4477 \$I4478 VSS nfet_05v0 L=0.6U W=0.365U AS=0.3705P
+ AD=0.0438P PS=2.77U PD=0.605U
* device instance $3738 r0 *1 618.435,811.402 nfet_05v0
M$3738 VSS \$I4477 \$I4480 VSS nfet_05v0 L=0.6U W=0.365U AS=0.0438P
+ AD=0.282625P PS=0.605U PD=1.87U
* device instance $3739 r0 *1 620.085,811.63 nfet_05v0
M$3739 \$I2287 \$I4478 VSS VSS nfet_05v0 L=0.6U W=0.82U AS=0.282625P AD=0.3608P
+ PS=1.87U PD=2.52U
* device instance $3740 r0 *1 613.355,811.4 nfet_05v0
M$3740 VSS \$I2341 \$I4476 VSS nfet_05v0 L=0.6U W=0.36U AS=0.333P AD=0.0936P
+ PS=2.57U PD=0.88U
* device instance $3741 r0 *1 614.475,811.4 nfet_05v0
M$3741 \$I4479 \$I4476 VSS VSS nfet_05v0 L=0.6U W=0.36U AS=0.0936P AD=0.0432P
+ PS=0.88U PD=0.6U
* device instance $3742 r0 *1 615.315,811.4 nfet_05v0
M$3742 \$I4477 \$I4476 \$I4479 VSS nfet_05v0 L=0.6U W=0.36U AS=0.0432P
+ AD=0.369P PS=0.6U PD=2.77U
* device instance $3743 r0 *1 502.745,782.81 pfet_05v0
M$3743 \$I4489 \$I4484 \$I4485 VDD_DEC pfet_05v0 L=0.5U W=0.36U AS=0.3456P
+ AD=0.0612P PS=2.64U PD=0.7U
* device instance $3744 r0 *1 503.585,782.81 pfet_05v0
M$3744 \$I4489 \$I4484 VDD_DEC VDD_DEC pfet_05v0 L=0.5U W=0.36U AS=0.379P
+ AD=0.0612P PS=2.37U PD=0.7U
* device instance $3745 r0 *1 505.235,782.49 pfet_05v0
M$3745 \$277 \$I4485 VDD_DEC VDD_DEC pfet_05v0 L=0.5U W=1.22U AS=0.379P
+ AD=0.5368P PS=2.37U PD=3.32U
* device instance $3746 r0 *1 498.505,782.92 pfet_05v0
M$3746 VDD_DEC \$I2053 \$I4483 VDD_DEC pfet_05v0 L=0.5U W=0.36U AS=0.3852P
+ AD=0.1116P PS=2.86U PD=0.98U
* device instance $3747 r0 *1 499.625,782.92 pfet_05v0
M$3747 \$I4488 \$I4483 VDD_DEC VDD_DEC pfet_05v0 L=0.5U W=0.36U AS=0.1116P
+ AD=0.0612P PS=0.98U PD=0.7U
* device instance $3748 r0 *1 500.465,782.92 pfet_05v0
M$3748 \$I4488 \$I4483 \$I4484 VDD_DEC pfet_05v0 L=0.5U W=0.36U AS=0.3852P
+ AD=0.0612P PS=2.86U PD=0.7U
* device instance $3749 r0 *1 502.795,780.042 nfet_05v0
M$3749 \$I4487 \$I4484 \$I4485 VSS nfet_05v0 L=0.6U W=0.365U AS=0.3705P
+ AD=0.0438P PS=2.77U PD=0.605U
* device instance $3750 r0 *1 503.635,780.042 nfet_05v0
M$3750 VSS \$I4484 \$I4487 VSS nfet_05v0 L=0.6U W=0.365U AS=0.0438P
+ AD=0.282625P PS=0.605U PD=1.87U
* device instance $3751 r0 *1 505.285,780.27 nfet_05v0
M$3751 \$277 \$I4485 VSS VSS nfet_05v0 L=0.6U W=0.82U AS=0.282625P AD=0.3608P
+ PS=1.87U PD=2.52U
* device instance $3752 r0 *1 498.555,780.04 nfet_05v0
M$3752 VSS \$I2053 \$I4483 VSS nfet_05v0 L=0.6U W=0.36U AS=0.333P AD=0.0936P
+ PS=2.57U PD=0.88U
* device instance $3753 r0 *1 499.675,780.04 nfet_05v0
M$3753 \$I4486 \$I4483 VSS VSS nfet_05v0 L=0.6U W=0.36U AS=0.0936P AD=0.0432P
+ PS=0.88U PD=0.6U
* device instance $3754 r0 *1 500.515,780.04 nfet_05v0
M$3754 \$I4484 \$I4483 \$I4486 VSS nfet_05v0 L=0.6U W=0.36U AS=0.0432P
+ AD=0.369P PS=0.6U PD=2.77U
* device instance $3755 r0 *1 512.265,774.97 pfet_05v0
M$3755 \$I4496 \$I4491 \$I4492 VDD_DEC pfet_05v0 L=0.5U W=0.36U AS=0.3456P
+ AD=0.0612P PS=2.64U PD=0.7U
* device instance $3756 r0 *1 513.105,774.97 pfet_05v0
M$3756 \$I4496 \$I4491 VDD_DEC VDD_DEC pfet_05v0 L=0.5U W=0.36U AS=0.379P
+ AD=0.0612P PS=2.37U PD=0.7U
* device instance $3757 r0 *1 514.755,774.65 pfet_05v0
M$3757 \$181 \$I4492 VDD_DEC VDD_DEC pfet_05v0 L=0.5U W=1.22U AS=0.379P
+ AD=0.5368P PS=2.37U PD=3.32U
* device instance $3758 r0 *1 508.025,775.08 pfet_05v0
M$3758 VDD_DEC \$I2021 \$I4490 VDD_DEC pfet_05v0 L=0.5U W=0.36U AS=0.3852P
+ AD=0.1116P PS=2.86U PD=0.98U
* device instance $3759 r0 *1 509.145,775.08 pfet_05v0
M$3759 \$I4495 \$I4490 VDD_DEC VDD_DEC pfet_05v0 L=0.5U W=0.36U AS=0.1116P
+ AD=0.0612P PS=0.98U PD=0.7U
* device instance $3760 r0 *1 509.985,775.08 pfet_05v0
M$3760 \$I4495 \$I4490 \$I4491 VDD_DEC pfet_05v0 L=0.5U W=0.36U AS=0.3852P
+ AD=0.0612P PS=2.86U PD=0.7U
* device instance $3761 r0 *1 512.315,772.202 nfet_05v0
M$3761 \$I4494 \$I4491 \$I4492 VSS nfet_05v0 L=0.6U W=0.365U AS=0.3705P
+ AD=0.0438P PS=2.77U PD=0.605U
* device instance $3762 r0 *1 513.155,772.202 nfet_05v0
M$3762 VSS \$I4491 \$I4494 VSS nfet_05v0 L=0.6U W=0.365U AS=0.0438P
+ AD=0.282625P PS=0.605U PD=1.87U
* device instance $3763 r0 *1 514.805,772.43 nfet_05v0
M$3763 \$181 \$I4492 VSS VSS nfet_05v0 L=0.6U W=0.82U AS=0.282625P AD=0.3608P
+ PS=1.87U PD=2.52U
* device instance $3764 r0 *1 508.075,772.2 nfet_05v0
M$3764 VSS \$I2021 \$I4490 VSS nfet_05v0 L=0.6U W=0.36U AS=0.333P AD=0.0936P
+ PS=2.57U PD=0.88U
* device instance $3765 r0 *1 509.195,772.2 nfet_05v0
M$3765 \$I4493 \$I4490 VSS VSS nfet_05v0 L=0.6U W=0.36U AS=0.0936P AD=0.0432P
+ PS=0.88U PD=0.6U
* device instance $3766 r0 *1 510.035,772.2 nfet_05v0
M$3766 \$I4491 \$I4490 \$I4493 VSS nfet_05v0 L=0.6U W=0.36U AS=0.0432P
+ AD=0.369P PS=0.6U PD=2.77U
* device instance $3767 r0 *1 515.065,782.81 pfet_05v0
M$3767 \$I4503 \$I4498 \$I4499 VDD_DEC pfet_05v0 L=0.5U W=0.36U AS=0.3456P
+ AD=0.0612P PS=2.64U PD=0.7U
* device instance $3768 r0 *1 515.905,782.81 pfet_05v0
M$3768 \$I4503 \$I4498 VDD_DEC VDD_DEC pfet_05v0 L=0.5U W=0.36U AS=0.379P
+ AD=0.0612P PS=2.37U PD=0.7U
* device instance $3769 r0 *1 517.555,782.49 pfet_05v0
M$3769 \$160 \$I4499 VDD_DEC VDD_DEC pfet_05v0 L=0.5U W=1.22U AS=0.379P
+ AD=0.5368P PS=2.37U PD=3.32U
* device instance $3770 r0 *1 510.825,782.92 pfet_05v0
M$3770 VDD_DEC \$I2056 \$I4497 VDD_DEC pfet_05v0 L=0.5U W=0.36U AS=0.3852P
+ AD=0.1116P PS=2.86U PD=0.98U
* device instance $3771 r0 *1 511.945,782.92 pfet_05v0
M$3771 \$I4502 \$I4497 VDD_DEC VDD_DEC pfet_05v0 L=0.5U W=0.36U AS=0.1116P
+ AD=0.0612P PS=0.98U PD=0.7U
* device instance $3772 r0 *1 512.785,782.92 pfet_05v0
M$3772 \$I4502 \$I4497 \$I4498 VDD_DEC pfet_05v0 L=0.5U W=0.36U AS=0.3852P
+ AD=0.0612P PS=2.86U PD=0.7U
* device instance $3773 r0 *1 515.115,780.042 nfet_05v0
M$3773 \$I4501 \$I4498 \$I4499 VSS nfet_05v0 L=0.6U W=0.365U AS=0.3705P
+ AD=0.0438P PS=2.77U PD=0.605U
* device instance $3774 r0 *1 515.955,780.042 nfet_05v0
M$3774 VSS \$I4498 \$I4501 VSS nfet_05v0 L=0.6U W=0.365U AS=0.0438P
+ AD=0.282625P PS=0.605U PD=1.87U
* device instance $3775 r0 *1 517.605,780.27 nfet_05v0
M$3775 \$160 \$I4499 VSS VSS nfet_05v0 L=0.6U W=0.82U AS=0.282625P AD=0.3608P
+ PS=1.87U PD=2.52U
* device instance $3776 r0 *1 510.875,780.04 nfet_05v0
M$3776 VSS \$I2056 \$I4497 VSS nfet_05v0 L=0.6U W=0.36U AS=0.333P AD=0.0936P
+ PS=2.57U PD=0.88U
* device instance $3777 r0 *1 511.995,780.04 nfet_05v0
M$3777 \$I4500 \$I4497 VSS VSS nfet_05v0 L=0.6U W=0.36U AS=0.0936P AD=0.0432P
+ PS=0.88U PD=0.6U
* device instance $3778 r0 *1 512.835,780.04 nfet_05v0
M$3778 \$I4498 \$I4497 \$I4500 VSS nfet_05v0 L=0.6U W=0.36U AS=0.0432P
+ AD=0.369P PS=0.6U PD=2.77U
* device instance $3779 r0 *1 502.185,774.97 pfet_05v0
M$3779 \$I4510 \$I4505 \$I4506 VDD_DEC pfet_05v0 L=0.5U W=0.36U AS=0.3456P
+ AD=0.0612P PS=2.64U PD=0.7U
* device instance $3780 r0 *1 503.025,774.97 pfet_05v0
M$3780 \$I4510 \$I4505 VDD_DEC VDD_DEC pfet_05v0 L=0.5U W=0.36U AS=0.379P
+ AD=0.0612P PS=2.37U PD=0.7U
* device instance $3781 r0 *1 504.675,774.65 pfet_05v0
M$3781 \$154 \$I4506 VDD_DEC VDD_DEC pfet_05v0 L=0.5U W=1.22U AS=0.379P
+ AD=0.5368P PS=2.37U PD=3.32U
* device instance $3782 r0 *1 497.945,775.08 pfet_05v0
M$3782 VDD_DEC \$I2020 \$I4504 VDD_DEC pfet_05v0 L=0.5U W=0.36U AS=0.3852P
+ AD=0.1116P PS=2.86U PD=0.98U
* device instance $3783 r0 *1 499.065,775.08 pfet_05v0
M$3783 \$I4509 \$I4504 VDD_DEC VDD_DEC pfet_05v0 L=0.5U W=0.36U AS=0.1116P
+ AD=0.0612P PS=0.98U PD=0.7U
* device instance $3784 r0 *1 499.905,775.08 pfet_05v0
M$3784 \$I4509 \$I4504 \$I4505 VDD_DEC pfet_05v0 L=0.5U W=0.36U AS=0.3852P
+ AD=0.0612P PS=2.86U PD=0.7U
* device instance $3785 r0 *1 502.235,772.202 nfet_05v0
M$3785 \$I4508 \$I4505 \$I4506 VSS nfet_05v0 L=0.6U W=0.365U AS=0.3705P
+ AD=0.0438P PS=2.77U PD=0.605U
* device instance $3786 r0 *1 503.075,772.202 nfet_05v0
M$3786 VSS \$I4505 \$I4508 VSS nfet_05v0 L=0.6U W=0.365U AS=0.0438P
+ AD=0.282625P PS=0.605U PD=1.87U
* device instance $3787 r0 *1 504.725,772.43 nfet_05v0
M$3787 \$154 \$I4506 VSS VSS nfet_05v0 L=0.6U W=0.82U AS=0.282625P AD=0.3608P
+ PS=1.87U PD=2.52U
* device instance $3788 r0 *1 497.995,772.2 nfet_05v0
M$3788 VSS \$I2020 \$I4504 VSS nfet_05v0 L=0.6U W=0.36U AS=0.333P AD=0.0936P
+ PS=2.57U PD=0.88U
* device instance $3789 r0 *1 499.115,772.2 nfet_05v0
M$3789 \$I4507 \$I4504 VSS VSS nfet_05v0 L=0.6U W=0.36U AS=0.0936P AD=0.0432P
+ PS=0.88U PD=0.6U
* device instance $3790 r0 *1 499.955,772.2 nfet_05v0
M$3790 \$I4505 \$I4504 \$I4507 VSS nfet_05v0 L=0.6U W=0.36U AS=0.0432P
+ AD=0.369P PS=0.6U PD=2.77U
* device instance $3791 r0 *1 550.345,774.97 pfet_05v0
M$3791 \$I4517 \$I4512 \$I4513 VDD_DEC pfet_05v0 L=0.5U W=0.36U AS=0.3456P
+ AD=0.0612P PS=2.64U PD=0.7U
* device instance $3792 r0 *1 551.185,774.97 pfet_05v0
M$3792 \$I4517 \$I4512 VDD_DEC VDD_DEC pfet_05v0 L=0.5U W=0.36U AS=0.379P
+ AD=0.0612P PS=2.37U PD=0.7U
* device instance $3793 r0 *1 552.835,774.65 pfet_05v0
M$3793 \$162 \$I4513 VDD_DEC VDD_DEC pfet_05v0 L=0.5U W=1.22U AS=0.379P
+ AD=0.5368P PS=2.37U PD=3.32U
* device instance $3794 r0 *1 546.105,775.08 pfet_05v0
M$3794 VDD_DEC \$I2025 \$I4511 VDD_DEC pfet_05v0 L=0.5U W=0.36U AS=0.3852P
+ AD=0.1116P PS=2.86U PD=0.98U
* device instance $3795 r0 *1 547.225,775.08 pfet_05v0
M$3795 \$I4516 \$I4511 VDD_DEC VDD_DEC pfet_05v0 L=0.5U W=0.36U AS=0.1116P
+ AD=0.0612P PS=0.98U PD=0.7U
* device instance $3796 r0 *1 548.065,775.08 pfet_05v0
M$3796 \$I4516 \$I4511 \$I4512 VDD_DEC pfet_05v0 L=0.5U W=0.36U AS=0.3852P
+ AD=0.0612P PS=2.86U PD=0.7U
* device instance $3797 r0 *1 550.395,772.202 nfet_05v0
M$3797 \$I4515 \$I4512 \$I4513 VSS nfet_05v0 L=0.6U W=0.365U AS=0.3705P
+ AD=0.0438P PS=2.77U PD=0.605U
* device instance $3798 r0 *1 551.235,772.202 nfet_05v0
M$3798 VSS \$I4512 \$I4515 VSS nfet_05v0 L=0.6U W=0.365U AS=0.0438P
+ AD=0.282625P PS=0.605U PD=1.87U
* device instance $3799 r0 *1 552.885,772.43 nfet_05v0
M$3799 \$162 \$I4513 VSS VSS nfet_05v0 L=0.6U W=0.82U AS=0.282625P AD=0.3608P
+ PS=1.87U PD=2.52U
* device instance $3800 r0 *1 546.155,772.2 nfet_05v0
M$3800 VSS \$I2025 \$I4511 VSS nfet_05v0 L=0.6U W=0.36U AS=0.333P AD=0.0936P
+ PS=2.57U PD=0.88U
* device instance $3801 r0 *1 547.275,772.2 nfet_05v0
M$3801 \$I4514 \$I4511 VSS VSS nfet_05v0 L=0.6U W=0.36U AS=0.0936P AD=0.0432P
+ PS=0.88U PD=0.6U
* device instance $3802 r0 *1 548.115,772.2 nfet_05v0
M$3802 \$I4512 \$I4511 \$I4514 VSS nfet_05v0 L=0.6U W=0.36U AS=0.0432P
+ AD=0.369P PS=0.6U PD=2.77U
* device instance $3803 r0 *1 613.625,837.69 pfet_05v0
M$3803 \$I4524 \$I4519 \$I4520 VDD_DEC pfet_05v0 L=0.5U W=0.36U AS=0.3456P
+ AD=0.0612P PS=2.64U PD=0.7U
* device instance $3804 r0 *1 614.465,837.69 pfet_05v0
M$3804 \$I4524 \$I4519 VDD_DEC VDD_DEC pfet_05v0 L=0.5U W=0.36U AS=0.379P
+ AD=0.0612P PS=2.37U PD=0.7U
* device instance $3805 r0 *1 616.115,837.37 pfet_05v0
M$3805 \$I2401 \$I4520 VDD_DEC VDD_DEC pfet_05v0 L=0.5U W=1.22U AS=0.379P
+ AD=0.5368P PS=2.37U PD=3.32U
* device instance $3806 r0 *1 609.385,837.8 pfet_05v0
M$3806 VDD_DEC D[4] \$I4518 VDD_DEC pfet_05v0 L=0.5U W=0.36U AS=0.3852P
+ AD=0.1116P PS=2.86U PD=0.98U
* device instance $3807 r0 *1 610.505,837.8 pfet_05v0
M$3807 \$I4523 \$I4518 VDD_DEC VDD_DEC pfet_05v0 L=0.5U W=0.36U AS=0.1116P
+ AD=0.0612P PS=0.98U PD=0.7U
* device instance $3808 r0 *1 611.345,837.8 pfet_05v0
M$3808 \$I4523 \$I4518 \$I4519 VDD_DEC pfet_05v0 L=0.5U W=0.36U AS=0.3852P
+ AD=0.0612P PS=2.86U PD=0.7U
* device instance $3809 r0 *1 613.675,834.922 nfet_05v0
M$3809 \$I4522 \$I4519 \$I4520 VSS nfet_05v0 L=0.6U W=0.365U AS=0.3705P
+ AD=0.0438P PS=2.77U PD=0.605U
* device instance $3810 r0 *1 614.515,834.922 nfet_05v0
M$3810 VSS \$I4519 \$I4522 VSS nfet_05v0 L=0.6U W=0.365U AS=0.0438P
+ AD=0.282625P PS=0.605U PD=1.87U
* device instance $3811 r0 *1 616.165,835.15 nfet_05v0
M$3811 \$I2401 \$I4520 VSS VSS nfet_05v0 L=0.6U W=0.82U AS=0.282625P AD=0.3608P
+ PS=1.87U PD=2.52U
* device instance $3812 r0 *1 609.435,834.92 nfet_05v0
M$3812 VSS D[4] \$I4518 VSS nfet_05v0 L=0.6U W=0.36U AS=0.333P AD=0.0936P
+ PS=2.57U PD=0.88U
* device instance $3813 r0 *1 610.555,834.92 nfet_05v0
M$3813 \$I4521 \$I4518 VSS VSS nfet_05v0 L=0.6U W=0.36U AS=0.0936P AD=0.0432P
+ PS=0.88U PD=0.6U
* device instance $3814 r0 *1 611.395,834.92 nfet_05v0
M$3814 \$I4519 \$I4518 \$I4521 VSS nfet_05v0 L=0.6U W=0.36U AS=0.0432P
+ AD=0.369P PS=0.6U PD=2.77U
* device instance $3815 r180 *1 79.345,833.6 pfet_05v0
M$3815 VDD_DEC VCO_EN \$I2440 VDD_DEC pfet_05v0 L=0.5U W=2U AS=1.54P AD=1.54P
+ PS=5.54U PD=5.54U
* device instance $3816 r90 *1 86.37,830.525 nfet_05v0
M$3816 \$5 VCO_EN \$I2010 VSS nfet_05v0 L=0.6U W=2U AS=1.46P AD=1.46P PS=5.46U
+ PD=5.46U
* device instance $3817 r90 *1 82.86,830.495 pfet_05v0
M$3817 \$5 \$I2440 \$I2010 VDD_DEC pfet_05v0 L=0.5U W=6U AS=3.14P AD=3.14P
+ PS=11.14U PD=11.14U
* device instance $3820 r0 *1 86.4,834.52 nfet_05v0
M$3820 VSS VCO_EN \$I2440 VSS nfet_05v0 L=0.6U W=1U AS=0.73P AD=0.73P PS=3.46U
+ PD=3.46U
* device instance $3821 r0 *1 76.66,829.04 diode_nw2ps_06v0
D$3821 VSS VCO_EN diode_nw2ps_06v0 A=1.728P P=12.48U
* device instance $3822 r0 *1 86.4,832.605 nfet_05v0
M$3822 VSS \$I2440 \$I2010 VSS nfet_05v0 L=0.6U W=0.42U AS=0.315P AD=0.315P
+ PS=2.34U PD=2.34U
* device instance $3824 r0 *1 190.72,834.52 nfet_05v0
M$3824 VSS VCO_EN \$I2441 VSS nfet_05v0 L=0.6U W=1U AS=0.73P AD=0.73P PS=3.46U
+ PD=3.46U
* device instance $3825 r90 *1 187.18,830.495 pfet_05v0
M$3825 \$I2011 \$I2441 \$4 VDD_DEC pfet_05v0 L=0.5U W=6U AS=3.14P AD=3.14P
+ PS=11.14U PD=11.14U
* device instance $3828 r90 *1 190.69,830.525 nfet_05v0
M$3828 \$I2011 VCO_EN \$4 VSS nfet_05v0 L=0.6U W=2U AS=1.46P AD=1.46P PS=5.46U
+ PD=5.46U
* device instance $3829 r180 *1 183.665,833.6 pfet_05v0
M$3829 VDD_DEC VCO_EN \$I2441 VDD_DEC pfet_05v0 L=0.5U W=2U AS=1.54P AD=1.54P
+ PS=5.54U PD=5.54U
* device instance $3830 r180 *1 91.67,833.6 pfet_05v0
M$3830 VDD_DEC VCO_EN \$I2442 VDD_DEC pfet_05v0 L=0.5U W=2U AS=1.54P AD=1.54P
+ PS=5.54U PD=5.54U
* device instance $3831 r90 *1 98.695,830.525 nfet_05v0
M$3831 \$5 \$I2442 OUT VSS nfet_05v0 L=0.6U W=2U AS=1.46P AD=1.46P PS=5.46U
+ PD=5.46U
* device instance $3832 r90 *1 95.185,830.495 pfet_05v0
M$3832 \$5 VCO_EN OUT VDD_DEC pfet_05v0 L=0.5U W=6U AS=3.14P AD=3.14P PS=11.14U
+ PD=11.14U
* device instance $3835 r0 *1 98.725,834.52 nfet_05v0
M$3835 VSS VCO_EN \$I2442 VSS nfet_05v0 L=0.6U W=1U AS=0.73P AD=0.73P PS=3.46U
+ PD=3.46U
* device instance $3837 r180 *1 171.34,833.6 pfet_05v0
M$3837 VDD_DEC VCO_EN \$I2443 VDD_DEC pfet_05v0 L=0.5U W=2U AS=1.54P AD=1.54P
+ PS=5.54U PD=5.54U
* device instance $3838 r90 *1 178.365,830.525 nfet_05v0
M$3838 IN \$I2443 \$4 VSS nfet_05v0 L=0.6U W=2U AS=1.46P AD=1.46P PS=5.46U
+ PD=5.46U
* device instance $3839 r90 *1 174.855,830.495 pfet_05v0
M$3839 IN VCO_EN \$4 VDD_DEC pfet_05v0 L=0.5U W=6U AS=3.14P AD=3.14P PS=11.14U
+ PD=11.14U
* device instance $3842 r0 *1 178.395,834.52 nfet_05v0
M$3842 VSS VCO_EN \$I2443 VSS nfet_05v0 L=0.6U W=1U AS=0.73P AD=0.73P PS=3.46U
+ PD=3.46U
* device instance $3844 r0 *1 123.95,843.775 nfet_05v0
M$3844 VSS \$I2444 FOUT VSS nfet_05v0 L=0.6U W=4U AS=1.93P AD=1.93P PS=8.86U
+ PD=8.86U
* device instance $3848 r0 *1 124.28,849.335 pfet_05v0
M$3848 VDD_INV \$I2444 FOUT VDD_INV pfet_05v0 L=0.5U W=8U AS=3.94P AD=3.94P
+ PS=13.94U PD=13.94U
* device instance $3852 m90 *1 121.225,843.775 nfet_05v0
M$3852 VSS \$I2015 \$I2444 VSS nfet_05v0 L=0.6U W=1U AS=0.73P AD=0.73P PS=3.46U
+ PD=3.46U
* device instance $3853 m90 *1 121.225,849.335 pfet_05v0
M$3853 VDD_INV \$I2015 \$I2444 VDD_INV pfet_05v0 L=0.5U W=2U AS=1.54P AD=1.54P
+ PS=5.54U PD=5.54U
* device instance $3854 r180 *1 51.51,39.02 pfet_05v0
M$3854 VDD_DEC \$6 \$I4525 VDD_DEC pfet_05v0 L=0.5U W=2U AS=1.54P AD=1.54P
+ PS=5.54U PD=5.54U
* device instance $3855 r180 *1 171.51,117.02 pfet_05v0
M$3855 VDD_DEC \$28 \$I4526 VDD_DEC pfet_05v0 L=0.5U W=2U AS=1.54P AD=1.54P
+ PS=5.54U PD=5.54U
* device instance $3856 r180 *1 171.51,39.02 pfet_05v0
M$3856 VDD_DEC \$9 \$I4527 VDD_DEC pfet_05v0 L=0.5U W=2U AS=1.54P AD=1.54P
+ PS=5.54U PD=5.54U
* device instance $3857 r180 *1 211.51,585.02 pfet_05v0
M$3857 VDD_DEC \$269 \$I4528 VDD_DEC pfet_05v0 L=0.5U W=2U AS=1.54P AD=1.54P
+ PS=5.54U PD=5.54U
* device instance $3858 r180 *1 291.51,351.02 pfet_05v0
M$3858 VDD_DEC \$165 \$I4529 VDD_DEC pfet_05v0 L=0.5U W=2U AS=1.54P AD=1.54P
+ PS=5.54U PD=5.54U
* device instance $3859 r180 *1 531.51,39.02 pfet_05v0
M$3859 VDD_DEC \$18 \$I4530 VDD_DEC pfet_05v0 L=0.5U W=2U AS=1.54P AD=1.54P
+ PS=5.54U PD=5.54U
* device instance $3860 r180 *1 171.51,351.02 pfet_05v0
M$3860 VDD_DEC \$156 \$I4531 VDD_DEC pfet_05v0 L=0.5U W=2U AS=1.54P AD=1.54P
+ PS=5.54U PD=5.54U
* device instance $3861 r180 *1 251.51,351.02 pfet_05v0
M$3861 VDD_DEC \$162 \$I4532 VDD_DEC pfet_05v0 L=0.5U W=2U AS=1.54P AD=1.54P
+ PS=5.54U PD=5.54U
* device instance $3862 r180 *1 651.51,39.02 pfet_05v0
M$3862 VDD_DEC \$21 \$I4533 VDD_DEC pfet_05v0 L=0.5U W=2U AS=1.54P AD=1.54P
+ PS=5.54U PD=5.54U
* device instance $3863 r180 *1 291.51,429.02 pfet_05v0
M$3863 VDD_DEC \$164 \$I4534 VDD_DEC pfet_05v0 L=0.5U W=2U AS=1.54P AD=1.54P
+ PS=5.54U PD=5.54U
* device instance $3864 r180 *1 171.51,195.02 pfet_05v0
M$3864 VDD_DEC \$89 \$I4535 VDD_DEC pfet_05v0 L=0.5U W=2U AS=1.54P AD=1.54P
+ PS=5.54U PD=5.54U
* device instance $3865 r180 *1 651.51,195.02 pfet_05v0
M$3865 VDD_DEC \$113 \$I4536 VDD_DEC pfet_05v0 L=0.5U W=2U AS=1.54P AD=1.54P
+ PS=5.54U PD=5.54U
* device instance $3866 r180 *1 51.51,585.02 pfet_05v0
M$3866 VDD_DEC \$265 \$I4537 VDD_DEC pfet_05v0 L=0.5U W=2U AS=1.54P AD=1.54P
+ PS=5.54U PD=5.54U
* device instance $3867 r180 *1 611.51,195.02 pfet_05v0
M$3867 VDD_DEC \$111 \$I4538 VDD_DEC pfet_05v0 L=0.5U W=2U AS=1.54P AD=1.54P
+ PS=5.54U PD=5.54U
* device instance $3868 r180 *1 571.51,195.02 pfet_05v0
M$3868 VDD_DEC \$109 \$I4539 VDD_DEC pfet_05v0 L=0.5U W=2U AS=1.54P AD=1.54P
+ PS=5.54U PD=5.54U
* device instance $3869 r180 *1 531.51,195.02 pfet_05v0
M$3869 VDD_DEC \$107 \$I4540 VDD_DEC pfet_05v0 L=0.5U W=2U AS=1.54P AD=1.54P
+ PS=5.54U PD=5.54U
* device instance $3870 r180 *1 371.51,117.02 pfet_05v0
M$3870 VDD_DEC \$33 \$I4541 VDD_DEC pfet_05v0 L=0.5U W=2U AS=1.54P AD=1.54P
+ PS=5.54U PD=5.54U
* device instance $3871 r180 *1 91.51,351.02 pfet_05v0
M$3871 VDD_DEC \$150 \$I4542 VDD_DEC pfet_05v0 L=0.5U W=2U AS=1.54P AD=1.54P
+ PS=5.54U PD=5.54U
* device instance $3872 r180 *1 371.51,39.02 pfet_05v0
M$3872 VDD_DEC \$14 \$I4543 VDD_DEC pfet_05v0 L=0.5U W=2U AS=1.54P AD=1.54P
+ PS=5.54U PD=5.54U
* device instance $3873 r180 *1 51.51,351.02 pfet_05v0
M$3873 VDD_DEC \$147 \$I4544 VDD_DEC pfet_05v0 L=0.5U W=2U AS=1.54P AD=1.54P
+ PS=5.54U PD=5.54U
* device instance $3874 r180 *1 571.51,39.02 pfet_05v0
M$3874 VDD_DEC \$19 \$I4545 VDD_DEC pfet_05v0 L=0.5U W=2U AS=1.54P AD=1.54P
+ PS=5.54U PD=5.54U
* device instance $3875 r180 *1 611.51,39.02 pfet_05v0
M$3875 VDD_DEC \$20 \$I4546 VDD_DEC pfet_05v0 L=0.5U W=2U AS=1.54P AD=1.54P
+ PS=5.54U PD=5.54U
* device instance $3876 r180 *1 531.51,117.02 pfet_05v0
M$3876 VDD_DEC \$37 \$I4547 VDD_DEC pfet_05v0 L=0.5U W=2U AS=1.54P AD=1.54P
+ PS=5.54U PD=5.54U
* device instance $3877 r180 *1 571.51,117.02 pfet_05v0
M$3877 VDD_DEC \$38 \$I4548 VDD_DEC pfet_05v0 L=0.5U W=2U AS=1.54P AD=1.54P
+ PS=5.54U PD=5.54U
* device instance $3878 r180 *1 251.51,429.02 pfet_05v0
M$3878 VDD_DEC \$161 \$I4549 VDD_DEC pfet_05v0 L=0.5U W=2U AS=1.54P AD=1.54P
+ PS=5.54U PD=5.54U
* device instance $3879 r180 *1 611.51,117.02 pfet_05v0
M$3879 VDD_DEC \$39 \$I4550 VDD_DEC pfet_05v0 L=0.5U W=2U AS=1.54P AD=1.54P
+ PS=5.54U PD=5.54U
* device instance $3880 r180 *1 131.51,429.02 pfet_05v0
M$3880 VDD_DEC \$152 \$I4551 VDD_DEC pfet_05v0 L=0.5U W=2U AS=1.54P AD=1.54P
+ PS=5.54U PD=5.54U
* device instance $3881 r180 *1 651.51,117.02 pfet_05v0
M$3881 VDD_DEC \$40 \$I4552 VDD_DEC pfet_05v0 L=0.5U W=2U AS=1.54P AD=1.54P
+ PS=5.54U PD=5.54U
* device instance $3882 r180 *1 211.51,351.02 pfet_05v0
M$3882 VDD_DEC \$159 \$I4553 VDD_DEC pfet_05v0 L=0.5U W=2U AS=1.54P AD=1.54P
+ PS=5.54U PD=5.54U
* device instance $3883 r180 *1 211.51,429.02 pfet_05v0
M$3883 VDD_DEC \$158 \$I4554 VDD_DEC pfet_05v0 L=0.5U W=2U AS=1.54P AD=1.54P
+ PS=5.54U PD=5.54U
* device instance $3884 r180 *1 331.51,585.02 pfet_05v0
M$3884 VDD_DEC \$272 \$I4555 VDD_DEC pfet_05v0 L=0.5U W=2U AS=1.54P AD=1.54P
+ PS=5.54U PD=5.54U
* device instance $3885 r180 *1 131.51,351.02 pfet_05v0
M$3885 VDD_DEC \$153 \$I4556 VDD_DEC pfet_05v0 L=0.5U W=2U AS=1.54P AD=1.54P
+ PS=5.54U PD=5.54U
* device instance $3886 r180 *1 331.51,429.02 pfet_05v0
M$3886 VDD_DEC \$167 \$I4557 VDD_DEC pfet_05v0 L=0.5U W=2U AS=1.54P AD=1.54P
+ PS=5.54U PD=5.54U
* device instance $3887 r180 *1 331.51,351.02 pfet_05v0
M$3887 VDD_DEC \$168 \$I4558 VDD_DEC pfet_05v0 L=0.5U W=2U AS=1.54P AD=1.54P
+ PS=5.54U PD=5.54U
* device instance $3888 r180 *1 331.51,273.02 pfet_05v0
M$3888 VDD_DEC \$96 \$I4559 VDD_DEC pfet_05v0 L=0.5U W=2U AS=1.54P AD=1.54P
+ PS=5.54U PD=5.54U
* device instance $3889 r180 *1 331.51,195.02 pfet_05v0
M$3889 VDD_DEC \$97 \$I4560 VDD_DEC pfet_05v0 L=0.5U W=2U AS=1.54P AD=1.54P
+ PS=5.54U PD=5.54U
* device instance $3890 r180 *1 331.51,117.02 pfet_05v0
M$3890 VDD_DEC \$32 \$I4561 VDD_DEC pfet_05v0 L=0.5U W=2U AS=1.54P AD=1.54P
+ PS=5.54U PD=5.54U
* device instance $3891 r180 *1 331.51,39.02 pfet_05v0
M$3891 VDD_DEC \$13 \$I4562 VDD_DEC pfet_05v0 L=0.5U W=2U AS=1.54P AD=1.54P
+ PS=5.54U PD=5.54U
* device instance $3892 r180 *1 371.51,507.02 pfet_05v0
M$3892 VDD_DEC \$169 \$I4563 VDD_DEC pfet_05v0 L=0.5U W=2U AS=1.54P AD=1.54P
+ PS=5.54U PD=5.54U
* device instance $3893 r180 *1 411.51,507.02 pfet_05v0
M$3893 VDD_DEC \$172 \$I4564 VDD_DEC pfet_05v0 L=0.5U W=2U AS=1.54P AD=1.54P
+ PS=5.54U PD=5.54U
* device instance $3894 r180 *1 451.51,507.02 pfet_05v0
M$3894 VDD_DEC \$175 \$I4565 VDD_DEC pfet_05v0 L=0.5U W=2U AS=1.54P AD=1.54P
+ PS=5.54U PD=5.54U
* device instance $3895 r180 *1 491.51,507.02 pfet_05v0
M$3895 VDD_DEC \$178 \$I4566 VDD_DEC pfet_05v0 L=0.5U W=2U AS=1.54P AD=1.54P
+ PS=5.54U PD=5.54U
* device instance $3896 r180 *1 611.51,507.02 pfet_05v0
M$3896 VDD_DEC \$187 \$I4567 VDD_DEC pfet_05v0 L=0.5U W=2U AS=1.54P AD=1.54P
+ PS=5.54U PD=5.54U
* device instance $3897 r180 *1 651.51,507.02 pfet_05v0
M$3897 VDD_DEC \$190 \$I4568 VDD_DEC pfet_05v0 L=0.5U W=2U AS=1.54P AD=1.54P
+ PS=5.54U PD=5.54U
* device instance $3898 r180 *1 531.51,507.02 pfet_05v0
M$3898 VDD_DEC \$181 \$I4569 VDD_DEC pfet_05v0 L=0.5U W=2U AS=1.54P AD=1.54P
+ PS=5.54U PD=5.54U
* device instance $3899 r180 *1 571.51,507.02 pfet_05v0
M$3899 VDD_DEC \$184 \$I4570 VDD_DEC pfet_05v0 L=0.5U W=2U AS=1.54P AD=1.54P
+ PS=5.54U PD=5.54U
* device instance $3900 r180 *1 171.51,507.02 pfet_05v0
M$3900 VDD_DEC \$154 \$I4571 VDD_DEC pfet_05v0 L=0.5U W=2U AS=1.54P AD=1.54P
+ PS=5.54U PD=5.54U
* device instance $3901 r180 *1 131.51,585.02 pfet_05v0
M$3901 VDD_DEC \$267 \$I4572 VDD_DEC pfet_05v0 L=0.5U W=2U AS=1.54P AD=1.54P
+ PS=5.54U PD=5.54U
* device instance $3902 r180 *1 51.51,507.02 pfet_05v0
M$3902 VDD_DEC \$145 \$I4573 VDD_DEC pfet_05v0 L=0.5U W=2U AS=1.54P AD=1.54P
+ PS=5.54U PD=5.54U
* device instance $3903 r180 *1 91.51,507.02 pfet_05v0
M$3903 VDD_DEC \$148 \$I4574 VDD_DEC pfet_05v0 L=0.5U W=2U AS=1.54P AD=1.54P
+ PS=5.54U PD=5.54U
* device instance $3904 r180 *1 131.51,507.02 pfet_05v0
M$3904 VDD_DEC \$151 \$I4575 VDD_DEC pfet_05v0 L=0.5U W=2U AS=1.54P AD=1.54P
+ PS=5.54U PD=5.54U
* device instance $3905 r180 *1 211.51,507.02 pfet_05v0
M$3905 VDD_DEC \$157 \$I4576 VDD_DEC pfet_05v0 L=0.5U W=2U AS=1.54P AD=1.54P
+ PS=5.54U PD=5.54U
* device instance $3906 r180 *1 251.51,507.02 pfet_05v0
M$3906 VDD_DEC \$160 \$I4577 VDD_DEC pfet_05v0 L=0.5U W=2U AS=1.54P AD=1.54P
+ PS=5.54U PD=5.54U
* device instance $3907 r180 *1 291.51,507.02 pfet_05v0
M$3907 VDD_DEC \$163 \$I4578 VDD_DEC pfet_05v0 L=0.5U W=2U AS=1.54P AD=1.54P
+ PS=5.54U PD=5.54U
* device instance $3908 r180 *1 291.51,585.02 pfet_05v0
M$3908 VDD_DEC \$271 \$I4579 VDD_DEC pfet_05v0 L=0.5U W=2U AS=1.54P AD=1.54P
+ PS=5.54U PD=5.54U
* device instance $3909 r180 *1 251.51,273.02 pfet_05v0
M$3909 VDD_DEC \$92 \$I4580 VDD_DEC pfet_05v0 L=0.5U W=2U AS=1.54P AD=1.54P
+ PS=5.54U PD=5.54U
* device instance $3910 r180 *1 291.51,273.02 pfet_05v0
M$3910 VDD_DEC \$94 \$I4581 VDD_DEC pfet_05v0 L=0.5U W=2U AS=1.54P AD=1.54P
+ PS=5.54U PD=5.54U
* device instance $3911 r180 *1 131.51,273.02 pfet_05v0
M$3911 VDD_DEC \$86 \$I4582 VDD_DEC pfet_05v0 L=0.5U W=2U AS=1.54P AD=1.54P
+ PS=5.54U PD=5.54U
* device instance $3912 r180 *1 91.51,273.02 pfet_05v0
M$3912 VDD_DEC \$84 \$I4583 VDD_DEC pfet_05v0 L=0.5U W=2U AS=1.54P AD=1.54P
+ PS=5.54U PD=5.54U
* device instance $3913 r180 *1 251.51,585.02 pfet_05v0
M$3913 VDD_DEC \$270 \$I4584 VDD_DEC pfet_05v0 L=0.5U W=2U AS=1.54P AD=1.54P
+ PS=5.54U PD=5.54U
* device instance $3914 r180 *1 51.51,273.02 pfet_05v0
M$3914 VDD_DEC \$82 \$I4585 VDD_DEC pfet_05v0 L=0.5U W=2U AS=1.54P AD=1.54P
+ PS=5.54U PD=5.54U
* device instance $3915 r180 *1 171.51,429.02 pfet_05v0
M$3915 VDD_DEC \$155 \$I4586 VDD_DEC pfet_05v0 L=0.5U W=2U AS=1.54P AD=1.54P
+ PS=5.54U PD=5.54U
* device instance $3916 r180 *1 171.51,273.02 pfet_05v0
M$3916 VDD_DEC \$88 \$I4587 VDD_DEC pfet_05v0 L=0.5U W=2U AS=1.54P AD=1.54P
+ PS=5.54U PD=5.54U
* device instance $3917 r180 *1 211.51,273.02 pfet_05v0
M$3917 VDD_DEC \$90 \$I4588 VDD_DEC pfet_05v0 L=0.5U W=2U AS=1.54P AD=1.54P
+ PS=5.54U PD=5.54U
* device instance $3918 r180 *1 251.51,195.02 pfet_05v0
M$3918 VDD_DEC \$93 \$I4589 VDD_DEC pfet_05v0 L=0.5U W=2U AS=1.54P AD=1.54P
+ PS=5.54U PD=5.54U
* device instance $3919 r180 *1 451.51,585.02 pfet_05v0
M$3919 VDD_DEC \$275 \$I4590 VDD_DEC pfet_05v0 L=0.5U W=2U AS=1.54P AD=1.54P
+ PS=5.54U PD=5.54U
* device instance $3920 r180 *1 491.51,585.02 pfet_05v0
M$3920 VDD_DEC \$276 \$I4591 VDD_DEC pfet_05v0 L=0.5U W=2U AS=1.54P AD=1.54P
+ PS=5.54U PD=5.54U
* device instance $3921 r180 *1 371.51,351.02 pfet_05v0
M$3921 VDD_DEC \$171 \$I4592 VDD_DEC pfet_05v0 L=0.5U W=2U AS=1.54P AD=1.54P
+ PS=5.54U PD=5.54U
* device instance $3922 r180 *1 371.51,429.02 pfet_05v0
M$3922 VDD_DEC \$170 \$I4593 VDD_DEC pfet_05v0 L=0.5U W=2U AS=1.54P AD=1.54P
+ PS=5.54U PD=5.54U
* device instance $3923 r180 *1 491.51,429.02 pfet_05v0
M$3923 VDD_DEC \$179 \$I4594 VDD_DEC pfet_05v0 L=0.5U W=2U AS=1.54P AD=1.54P
+ PS=5.54U PD=5.54U
* device instance $3924 r180 *1 251.51,39.02 pfet_05v0
M$3924 VDD_DEC \$11 \$I4595 VDD_DEC pfet_05v0 L=0.5U W=2U AS=1.54P AD=1.54P
+ PS=5.54U PD=5.54U
* device instance $3925 r180 *1 491.51,351.02 pfet_05v0
M$3925 VDD_DEC \$180 \$I4596 VDD_DEC pfet_05v0 L=0.5U W=2U AS=1.54P AD=1.54P
+ PS=5.54U PD=5.54U
* device instance $3926 r180 *1 451.51,429.02 pfet_05v0
M$3926 VDD_DEC \$176 \$I4597 VDD_DEC pfet_05v0 L=0.5U W=2U AS=1.54P AD=1.54P
+ PS=5.54U PD=5.54U
* device instance $3927 r180 *1 411.51,429.02 pfet_05v0
M$3927 VDD_DEC \$173 \$I4598 VDD_DEC pfet_05v0 L=0.5U W=2U AS=1.54P AD=1.54P
+ PS=5.54U PD=5.54U
* device instance $3928 r180 *1 611.51,429.02 pfet_05v0
M$3928 VDD_DEC \$188 \$I4599 VDD_DEC pfet_05v0 L=0.5U W=2U AS=1.54P AD=1.54P
+ PS=5.54U PD=5.54U
* device instance $3929 r180 *1 571.51,429.02 pfet_05v0
M$3929 VDD_DEC \$185 \$I4600 VDD_DEC pfet_05v0 L=0.5U W=2U AS=1.54P AD=1.54P
+ PS=5.54U PD=5.54U
* device instance $3930 r180 *1 531.51,429.02 pfet_05v0
M$3930 VDD_DEC \$182 \$I4601 VDD_DEC pfet_05v0 L=0.5U W=2U AS=1.54P AD=1.54P
+ PS=5.54U PD=5.54U
* device instance $3931 r180 *1 531.51,585.02 pfet_05v0
M$3931 VDD_DEC \$277 \$I4602 VDD_DEC pfet_05v0 L=0.5U W=2U AS=1.54P AD=1.54P
+ PS=5.54U PD=5.54U
* device instance $3932 r180 *1 571.51,585.02 pfet_05v0
M$3932 VDD_DEC \$278 \$I4603 VDD_DEC pfet_05v0 L=0.5U W=2U AS=1.54P AD=1.54P
+ PS=5.54U PD=5.54U
* device instance $3933 r180 *1 331.51,507.02 pfet_05v0
M$3933 VDD_DEC \$166 \$I4604 VDD_DEC pfet_05v0 L=0.5U W=2U AS=1.54P AD=1.54P
+ PS=5.54U PD=5.54U
* device instance $3934 r180 *1 611.51,585.02 pfet_05v0
M$3934 VDD_DEC \$279 \$I4605 VDD_DEC pfet_05v0 L=0.5U W=2U AS=1.54P AD=1.54P
+ PS=5.54U PD=5.54U
* device instance $3935 r180 *1 211.51,39.02 pfet_05v0
M$3935 VDD_DEC \$10 \$I4606 VDD_DEC pfet_05v0 L=0.5U W=2U AS=1.54P AD=1.54P
+ PS=5.54U PD=5.54U
* device instance $3936 r180 *1 571.51,351.02 pfet_05v0
M$3936 VDD_DEC \$186 \$I4607 VDD_DEC pfet_05v0 L=0.5U W=2U AS=1.54P AD=1.54P
+ PS=5.54U PD=5.54U
* device instance $3937 r180 *1 651.51,429.02 pfet_05v0
M$3937 VDD_DEC \$191 \$I4608 VDD_DEC pfet_05v0 L=0.5U W=2U AS=1.54P AD=1.54P
+ PS=5.54U PD=5.54U
* device instance $3938 r180 *1 571.51,273.02 pfet_05v0
M$3938 VDD_DEC \$108 \$I4609 VDD_DEC pfet_05v0 L=0.5U W=2U AS=1.54P AD=1.54P
+ PS=5.54U PD=5.54U
* device instance $3939 r180 *1 611.51,273.02 pfet_05v0
M$3939 VDD_DEC \$110 \$I4610 VDD_DEC pfet_05v0 L=0.5U W=2U AS=1.54P AD=1.54P
+ PS=5.54U PD=5.54U
* device instance $3940 r180 *1 651.51,273.02 pfet_05v0
M$3940 VDD_DEC \$112 \$I4611 VDD_DEC pfet_05v0 L=0.5U W=2U AS=1.54P AD=1.54P
+ PS=5.54U PD=5.54U
* device instance $3941 r180 *1 531.51,273.02 pfet_05v0
M$3941 VDD_DEC \$106 \$I4612 VDD_DEC pfet_05v0 L=0.5U W=2U AS=1.54P AD=1.54P
+ PS=5.54U PD=5.54U
* device instance $3942 r180 *1 491.51,273.02 pfet_05v0
M$3942 VDD_DEC \$104 \$I4613 VDD_DEC pfet_05v0 L=0.5U W=2U AS=1.54P AD=1.54P
+ PS=5.54U PD=5.54U
* device instance $3943 r180 *1 651.51,351.02 pfet_05v0
M$3943 VDD_DEC \$192 \$I4614 VDD_DEC pfet_05v0 L=0.5U W=2U AS=1.54P AD=1.54P
+ PS=5.54U PD=5.54U
* device instance $3944 r180 *1 451.51,273.02 pfet_05v0
M$3944 VDD_DEC \$102 \$I4615 VDD_DEC pfet_05v0 L=0.5U W=2U AS=1.54P AD=1.54P
+ PS=5.54U PD=5.54U
* device instance $3945 r180 *1 371.51,273.02 pfet_05v0
M$3945 VDD_DEC \$98 \$I4616 VDD_DEC pfet_05v0 L=0.5U W=2U AS=1.54P AD=1.54P
+ PS=5.54U PD=5.54U
* device instance $3946 r180 *1 611.51,351.02 pfet_05v0
M$3946 VDD_DEC \$189 \$I4617 VDD_DEC pfet_05v0 L=0.5U W=2U AS=1.54P AD=1.54P
+ PS=5.54U PD=5.54U
* device instance $3947 r180 *1 411.51,273.02 pfet_05v0
M$3947 VDD_DEC \$100 \$I4618 VDD_DEC pfet_05v0 L=0.5U W=2U AS=1.54P AD=1.54P
+ PS=5.54U PD=5.54U
* device instance $3948 r180 *1 531.51,351.02 pfet_05v0
M$3948 VDD_DEC \$183 \$I4619 VDD_DEC pfet_05v0 L=0.5U W=2U AS=1.54P AD=1.54P
+ PS=5.54U PD=5.54U
* device instance $3949 r180 *1 651.51,585.02 pfet_05v0
M$3949 VDD_DEC \$280 \$I4620 VDD_DEC pfet_05v0 L=0.5U W=2U AS=1.54P AD=1.54P
+ PS=5.54U PD=5.54U
* device instance $3950 r180 *1 91.51,585.02 pfet_05v0
M$3950 VDD_DEC \$266 \$I4621 VDD_DEC pfet_05v0 L=0.5U W=2U AS=1.54P AD=1.54P
+ PS=5.54U PD=5.54U
* device instance $3951 r180 *1 91.51,429.02 pfet_05v0
M$3951 VDD_DEC \$149 \$I4622 VDD_DEC pfet_05v0 L=0.5U W=2U AS=1.54P AD=1.54P
+ PS=5.54U PD=5.54U
* device instance $3952 r180 *1 51.51,429.02 pfet_05v0
M$3952 VDD_DEC \$146 \$I4623 VDD_DEC pfet_05v0 L=0.5U W=2U AS=1.54P AD=1.54P
+ PS=5.54U PD=5.54U
* device instance $3953 r180 *1 131.51,39.02 pfet_05v0
M$3953 VDD_DEC \$8 \$I4624 VDD_DEC pfet_05v0 L=0.5U W=2U AS=1.54P AD=1.54P
+ PS=5.54U PD=5.54U
* device instance $3954 r180 *1 51.51,117.02 pfet_05v0
M$3954 VDD_DEC \$25 \$I4625 VDD_DEC pfet_05v0 L=0.5U W=2U AS=1.54P AD=1.54P
+ PS=5.54U PD=5.54U
* device instance $3955 r180 *1 91.51,117.02 pfet_05v0
M$3955 VDD_DEC \$26 \$I4626 VDD_DEC pfet_05v0 L=0.5U W=2U AS=1.54P AD=1.54P
+ PS=5.54U PD=5.54U
* device instance $3956 r180 *1 131.51,117.02 pfet_05v0
M$3956 VDD_DEC \$27 \$I4627 VDD_DEC pfet_05v0 L=0.5U W=2U AS=1.54P AD=1.54P
+ PS=5.54U PD=5.54U
* device instance $3957 r180 *1 451.51,39.02 pfet_05v0
M$3957 VDD_DEC \$16 \$I4628 VDD_DEC pfet_05v0 L=0.5U W=2U AS=1.54P AD=1.54P
+ PS=5.54U PD=5.54U
* device instance $3958 r180 *1 91.51,39.02 pfet_05v0
M$3958 VDD_DEC \$7 \$I4629 VDD_DEC pfet_05v0 L=0.5U W=2U AS=1.54P AD=1.54P
+ PS=5.54U PD=5.54U
* device instance $3959 r180 *1 51.51,195.02 pfet_05v0
M$3959 VDD_DEC \$83 \$I4630 VDD_DEC pfet_05v0 L=0.5U W=2U AS=1.54P AD=1.54P
+ PS=5.54U PD=5.54U
* device instance $3960 r180 *1 91.51,195.02 pfet_05v0
M$3960 VDD_DEC \$85 \$I4631 VDD_DEC pfet_05v0 L=0.5U W=2U AS=1.54P AD=1.54P
+ PS=5.54U PD=5.54U
* device instance $3961 r180 *1 131.51,195.02 pfet_05v0
M$3961 VDD_DEC \$87 \$I4632 VDD_DEC pfet_05v0 L=0.5U W=2U AS=1.54P AD=1.54P
+ PS=5.54U PD=5.54U
* device instance $3962 r180 *1 491.51,39.02 pfet_05v0
M$3962 VDD_DEC \$17 \$I4633 VDD_DEC pfet_05v0 L=0.5U W=2U AS=1.54P AD=1.54P
+ PS=5.54U PD=5.54U
* device instance $3963 r180 *1 291.51,39.02 pfet_05v0
M$3963 VDD_DEC \$12 \$I4634 VDD_DEC pfet_05v0 L=0.5U W=2U AS=1.54P AD=1.54P
+ PS=5.54U PD=5.54U
* device instance $3964 r180 *1 411.51,585.02 pfet_05v0
M$3964 VDD_DEC \$274 \$I4635 VDD_DEC pfet_05v0 L=0.5U W=2U AS=1.54P AD=1.54P
+ PS=5.54U PD=5.54U
* device instance $3965 r180 *1 411.51,351.02 pfet_05v0
M$3965 VDD_DEC \$174 \$I4636 VDD_DEC pfet_05v0 L=0.5U W=2U AS=1.54P AD=1.54P
+ PS=5.54U PD=5.54U
* device instance $3966 r180 *1 211.51,195.02 pfet_05v0
M$3966 VDD_DEC \$91 \$I4637 VDD_DEC pfet_05v0 L=0.5U W=2U AS=1.54P AD=1.54P
+ PS=5.54U PD=5.54U
* device instance $3967 r180 *1 291.51,195.02 pfet_05v0
M$3967 VDD_DEC \$95 \$I4638 VDD_DEC pfet_05v0 L=0.5U W=2U AS=1.54P AD=1.54P
+ PS=5.54U PD=5.54U
* device instance $3968 r180 *1 291.51,117.02 pfet_05v0
M$3968 VDD_DEC \$31 \$I4639 VDD_DEC pfet_05v0 L=0.5U W=2U AS=1.54P AD=1.54P
+ PS=5.54U PD=5.54U
* device instance $3969 r180 *1 451.51,351.02 pfet_05v0
M$3969 VDD_DEC \$177 \$I4640 VDD_DEC pfet_05v0 L=0.5U W=2U AS=1.54P AD=1.54P
+ PS=5.54U PD=5.54U
* device instance $3970 r180 *1 371.51,585.02 pfet_05v0
M$3970 VDD_DEC \$273 \$I4641 VDD_DEC pfet_05v0 L=0.5U W=2U AS=1.54P AD=1.54P
+ PS=5.54U PD=5.54U
* device instance $3971 r180 *1 211.51,117.02 pfet_05v0
M$3971 VDD_DEC \$29 \$I4642 VDD_DEC pfet_05v0 L=0.5U W=2U AS=1.54P AD=1.54P
+ PS=5.54U PD=5.54U
* device instance $3972 r180 *1 251.51,117.02 pfet_05v0
M$3972 VDD_DEC \$30 \$I4643 VDD_DEC pfet_05v0 L=0.5U W=2U AS=1.54P AD=1.54P
+ PS=5.54U PD=5.54U
* device instance $3973 r180 *1 411.51,195.02 pfet_05v0
M$3973 VDD_DEC \$101 \$I4644 VDD_DEC pfet_05v0 L=0.5U W=2U AS=1.54P AD=1.54P
+ PS=5.54U PD=5.54U
* device instance $3974 r180 *1 451.51,195.02 pfet_05v0
M$3974 VDD_DEC \$103 \$I4645 VDD_DEC pfet_05v0 L=0.5U W=2U AS=1.54P AD=1.54P
+ PS=5.54U PD=5.54U
* device instance $3975 r180 *1 491.51,195.02 pfet_05v0
M$3975 VDD_DEC \$105 \$I4646 VDD_DEC pfet_05v0 L=0.5U W=2U AS=1.54P AD=1.54P
+ PS=5.54U PD=5.54U
* device instance $3976 r180 *1 411.51,117.02 pfet_05v0
M$3976 VDD_DEC \$34 \$I4647 VDD_DEC pfet_05v0 L=0.5U W=2U AS=1.54P AD=1.54P
+ PS=5.54U PD=5.54U
* device instance $3977 r180 *1 451.51,117.02 pfet_05v0
M$3977 VDD_DEC \$35 \$I4648 VDD_DEC pfet_05v0 L=0.5U W=2U AS=1.54P AD=1.54P
+ PS=5.54U PD=5.54U
* device instance $3978 r180 *1 491.51,117.02 pfet_05v0
M$3978 VDD_DEC \$36 \$I4649 VDD_DEC pfet_05v0 L=0.5U W=2U AS=1.54P AD=1.54P
+ PS=5.54U PD=5.54U
* device instance $3979 r180 *1 171.51,585.02 pfet_05v0
M$3979 VDD_DEC \$268 \$I4650 VDD_DEC pfet_05v0 L=0.5U W=2U AS=1.54P AD=1.54P
+ PS=5.54U PD=5.54U
* device instance $3980 r180 *1 411.51,39.02 pfet_05v0
M$3980 VDD_DEC \$15 \$I4651 VDD_DEC pfet_05v0 L=0.5U W=2U AS=1.54P AD=1.54P
+ PS=5.54U PD=5.54U
* device instance $3981 r180 *1 371.51,195.02 pfet_05v0
M$3981 VDD_DEC \$99 \$I4652 VDD_DEC pfet_05v0 L=0.5U W=2U AS=1.54P AD=1.54P
+ PS=5.54U PD=5.54U
* device instance $3982 r90 *1 58.535,35.945 nfet_05v0
M$3982 \$I641 \$6 \$5 VSS nfet_05v0 L=0.6U W=2U AS=1.46P AD=1.46P PS=5.46U
+ PD=5.46U
* device instance $3983 r90 *1 178.535,113.945 nfet_05v0
M$3983 \$I640 \$28 \$5 VSS nfet_05v0 L=0.6U W=2U AS=1.46P AD=1.46P PS=5.46U
+ PD=5.46U
* device instance $3984 r90 *1 178.535,35.945 nfet_05v0
M$3984 \$I639 \$9 \$5 VSS nfet_05v0 L=0.6U W=2U AS=1.46P AD=1.46P PS=5.46U
+ PD=5.46U
* device instance $3985 r90 *1 218.535,581.945 nfet_05v0
M$3985 \$I638 \$269 \$5 VSS nfet_05v0 L=0.6U W=2U AS=1.46P AD=1.46P PS=5.46U
+ PD=5.46U
* device instance $3986 r90 *1 298.535,347.945 nfet_05v0
M$3986 \$I637 \$165 \$5 VSS nfet_05v0 L=0.6U W=2U AS=1.46P AD=1.46P PS=5.46U
+ PD=5.46U
* device instance $3987 r90 *1 538.535,35.945 nfet_05v0
M$3987 \$I636 \$18 \$5 VSS nfet_05v0 L=0.6U W=2U AS=1.46P AD=1.46P PS=5.46U
+ PD=5.46U
* device instance $3988 r90 *1 178.535,347.945 nfet_05v0
M$3988 \$I635 \$156 \$5 VSS nfet_05v0 L=0.6U W=2U AS=1.46P AD=1.46P PS=5.46U
+ PD=5.46U
* device instance $3989 r90 *1 258.535,347.945 nfet_05v0
M$3989 \$I634 \$162 \$5 VSS nfet_05v0 L=0.6U W=2U AS=1.46P AD=1.46P PS=5.46U
+ PD=5.46U
* device instance $3990 r90 *1 658.535,35.945 nfet_05v0
M$3990 \$I633 \$21 \$5 VSS nfet_05v0 L=0.6U W=2U AS=1.46P AD=1.46P PS=5.46U
+ PD=5.46U
* device instance $3991 r90 *1 298.535,425.945 nfet_05v0
M$3991 \$I632 \$164 \$5 VSS nfet_05v0 L=0.6U W=2U AS=1.46P AD=1.46P PS=5.46U
+ PD=5.46U
* device instance $3992 r90 *1 178.535,191.945 nfet_05v0
M$3992 \$I631 \$89 \$5 VSS nfet_05v0 L=0.6U W=2U AS=1.46P AD=1.46P PS=5.46U
+ PD=5.46U
* device instance $3993 r90 *1 658.535,191.945 nfet_05v0
M$3993 \$I630 \$113 \$5 VSS nfet_05v0 L=0.6U W=2U AS=1.46P AD=1.46P PS=5.46U
+ PD=5.46U
* device instance $3994 r90 *1 58.535,581.945 nfet_05v0
M$3994 \$I629 \$265 \$5 VSS nfet_05v0 L=0.6U W=2U AS=1.46P AD=1.46P PS=5.46U
+ PD=5.46U
* device instance $3995 r90 *1 618.535,191.945 nfet_05v0
M$3995 \$I628 \$111 \$5 VSS nfet_05v0 L=0.6U W=2U AS=1.46P AD=1.46P PS=5.46U
+ PD=5.46U
* device instance $3996 r90 *1 578.535,191.945 nfet_05v0
M$3996 \$I627 \$109 \$5 VSS nfet_05v0 L=0.6U W=2U AS=1.46P AD=1.46P PS=5.46U
+ PD=5.46U
* device instance $3997 r90 *1 538.535,191.945 nfet_05v0
M$3997 \$I626 \$107 \$5 VSS nfet_05v0 L=0.6U W=2U AS=1.46P AD=1.46P PS=5.46U
+ PD=5.46U
* device instance $3998 r90 *1 378.535,113.945 nfet_05v0
M$3998 \$I625 \$33 \$5 VSS nfet_05v0 L=0.6U W=2U AS=1.46P AD=1.46P PS=5.46U
+ PD=5.46U
* device instance $3999 r90 *1 98.535,347.945 nfet_05v0
M$3999 \$I624 \$150 \$5 VSS nfet_05v0 L=0.6U W=2U AS=1.46P AD=1.46P PS=5.46U
+ PD=5.46U
* device instance $4000 r90 *1 378.535,35.945 nfet_05v0
M$4000 \$I623 \$14 \$5 VSS nfet_05v0 L=0.6U W=2U AS=1.46P AD=1.46P PS=5.46U
+ PD=5.46U
* device instance $4001 r90 *1 58.535,347.945 nfet_05v0
M$4001 \$I622 \$147 \$5 VSS nfet_05v0 L=0.6U W=2U AS=1.46P AD=1.46P PS=5.46U
+ PD=5.46U
* device instance $4002 r90 *1 578.535,35.945 nfet_05v0
M$4002 \$I621 \$19 \$5 VSS nfet_05v0 L=0.6U W=2U AS=1.46P AD=1.46P PS=5.46U
+ PD=5.46U
* device instance $4003 r90 *1 618.535,35.945 nfet_05v0
M$4003 \$I620 \$20 \$5 VSS nfet_05v0 L=0.6U W=2U AS=1.46P AD=1.46P PS=5.46U
+ PD=5.46U
* device instance $4004 r90 *1 538.535,113.945 nfet_05v0
M$4004 \$I619 \$37 \$5 VSS nfet_05v0 L=0.6U W=2U AS=1.46P AD=1.46P PS=5.46U
+ PD=5.46U
* device instance $4005 r90 *1 578.535,113.945 nfet_05v0
M$4005 \$I618 \$38 \$5 VSS nfet_05v0 L=0.6U W=2U AS=1.46P AD=1.46P PS=5.46U
+ PD=5.46U
* device instance $4006 r90 *1 258.535,425.945 nfet_05v0
M$4006 \$I617 \$161 \$5 VSS nfet_05v0 L=0.6U W=2U AS=1.46P AD=1.46P PS=5.46U
+ PD=5.46U
* device instance $4007 r90 *1 618.535,113.945 nfet_05v0
M$4007 \$I616 \$39 \$5 VSS nfet_05v0 L=0.6U W=2U AS=1.46P AD=1.46P PS=5.46U
+ PD=5.46U
* device instance $4008 r90 *1 138.535,425.945 nfet_05v0
M$4008 \$I615 \$152 \$5 VSS nfet_05v0 L=0.6U W=2U AS=1.46P AD=1.46P PS=5.46U
+ PD=5.46U
* device instance $4009 r90 *1 658.535,113.945 nfet_05v0
M$4009 \$I614 \$40 \$5 VSS nfet_05v0 L=0.6U W=2U AS=1.46P AD=1.46P PS=5.46U
+ PD=5.46U
* device instance $4010 r90 *1 218.535,347.945 nfet_05v0
M$4010 \$I613 \$159 \$5 VSS nfet_05v0 L=0.6U W=2U AS=1.46P AD=1.46P PS=5.46U
+ PD=5.46U
* device instance $4011 r90 *1 218.535,425.945 nfet_05v0
M$4011 \$I612 \$158 \$5 VSS nfet_05v0 L=0.6U W=2U AS=1.46P AD=1.46P PS=5.46U
+ PD=5.46U
* device instance $4012 r90 *1 338.535,581.945 nfet_05v0
M$4012 \$I611 \$272 \$5 VSS nfet_05v0 L=0.6U W=2U AS=1.46P AD=1.46P PS=5.46U
+ PD=5.46U
* device instance $4013 r90 *1 138.535,347.945 nfet_05v0
M$4013 \$I610 \$153 \$5 VSS nfet_05v0 L=0.6U W=2U AS=1.46P AD=1.46P PS=5.46U
+ PD=5.46U
* device instance $4014 r90 *1 338.535,425.945 nfet_05v0
M$4014 \$I609 \$167 \$5 VSS nfet_05v0 L=0.6U W=2U AS=1.46P AD=1.46P PS=5.46U
+ PD=5.46U
* device instance $4015 r90 *1 338.535,347.945 nfet_05v0
M$4015 \$I608 \$168 \$5 VSS nfet_05v0 L=0.6U W=2U AS=1.46P AD=1.46P PS=5.46U
+ PD=5.46U
* device instance $4016 r90 *1 338.535,269.945 nfet_05v0
M$4016 \$I607 \$96 \$5 VSS nfet_05v0 L=0.6U W=2U AS=1.46P AD=1.46P PS=5.46U
+ PD=5.46U
* device instance $4017 r90 *1 338.535,191.945 nfet_05v0
M$4017 \$I606 \$97 \$5 VSS nfet_05v0 L=0.6U W=2U AS=1.46P AD=1.46P PS=5.46U
+ PD=5.46U
* device instance $4018 r90 *1 338.535,113.945 nfet_05v0
M$4018 \$I605 \$32 \$5 VSS nfet_05v0 L=0.6U W=2U AS=1.46P AD=1.46P PS=5.46U
+ PD=5.46U
* device instance $4019 r90 *1 338.535,35.945 nfet_05v0
M$4019 \$I604 \$13 \$5 VSS nfet_05v0 L=0.6U W=2U AS=1.46P AD=1.46P PS=5.46U
+ PD=5.46U
* device instance $4020 r90 *1 378.535,503.945 nfet_05v0
M$4020 \$I603 \$169 \$5 VSS nfet_05v0 L=0.6U W=2U AS=1.46P AD=1.46P PS=5.46U
+ PD=5.46U
* device instance $4021 r90 *1 418.535,503.945 nfet_05v0
M$4021 \$I602 \$172 \$5 VSS nfet_05v0 L=0.6U W=2U AS=1.46P AD=1.46P PS=5.46U
+ PD=5.46U
* device instance $4022 r90 *1 458.535,503.945 nfet_05v0
M$4022 \$I601 \$175 \$5 VSS nfet_05v0 L=0.6U W=2U AS=1.46P AD=1.46P PS=5.46U
+ PD=5.46U
* device instance $4023 r90 *1 498.535,503.945 nfet_05v0
M$4023 \$I600 \$178 \$5 VSS nfet_05v0 L=0.6U W=2U AS=1.46P AD=1.46P PS=5.46U
+ PD=5.46U
* device instance $4024 r90 *1 618.535,503.945 nfet_05v0
M$4024 \$I599 \$187 \$5 VSS nfet_05v0 L=0.6U W=2U AS=1.46P AD=1.46P PS=5.46U
+ PD=5.46U
* device instance $4025 r90 *1 658.535,503.945 nfet_05v0
M$4025 \$I598 \$190 \$5 VSS nfet_05v0 L=0.6U W=2U AS=1.46P AD=1.46P PS=5.46U
+ PD=5.46U
* device instance $4026 r90 *1 538.535,503.945 nfet_05v0
M$4026 \$I597 \$181 \$5 VSS nfet_05v0 L=0.6U W=2U AS=1.46P AD=1.46P PS=5.46U
+ PD=5.46U
* device instance $4027 r90 *1 578.535,503.945 nfet_05v0
M$4027 \$I596 \$184 \$5 VSS nfet_05v0 L=0.6U W=2U AS=1.46P AD=1.46P PS=5.46U
+ PD=5.46U
* device instance $4028 r90 *1 178.535,503.945 nfet_05v0
M$4028 \$I595 \$154 \$5 VSS nfet_05v0 L=0.6U W=2U AS=1.46P AD=1.46P PS=5.46U
+ PD=5.46U
* device instance $4029 r90 *1 138.535,581.945 nfet_05v0
M$4029 \$I594 \$267 \$5 VSS nfet_05v0 L=0.6U W=2U AS=1.46P AD=1.46P PS=5.46U
+ PD=5.46U
* device instance $4030 r90 *1 58.535,503.945 nfet_05v0
M$4030 \$I593 \$145 \$5 VSS nfet_05v0 L=0.6U W=2U AS=1.46P AD=1.46P PS=5.46U
+ PD=5.46U
* device instance $4031 r90 *1 98.535,503.945 nfet_05v0
M$4031 \$I592 \$148 \$5 VSS nfet_05v0 L=0.6U W=2U AS=1.46P AD=1.46P PS=5.46U
+ PD=5.46U
* device instance $4032 r90 *1 138.535,503.945 nfet_05v0
M$4032 \$I591 \$151 \$5 VSS nfet_05v0 L=0.6U W=2U AS=1.46P AD=1.46P PS=5.46U
+ PD=5.46U
* device instance $4033 r90 *1 218.535,503.945 nfet_05v0
M$4033 \$I590 \$157 \$5 VSS nfet_05v0 L=0.6U W=2U AS=1.46P AD=1.46P PS=5.46U
+ PD=5.46U
* device instance $4034 r90 *1 258.535,503.945 nfet_05v0
M$4034 \$I589 \$160 \$5 VSS nfet_05v0 L=0.6U W=2U AS=1.46P AD=1.46P PS=5.46U
+ PD=5.46U
* device instance $4035 r90 *1 298.535,503.945 nfet_05v0
M$4035 \$I588 \$163 \$5 VSS nfet_05v0 L=0.6U W=2U AS=1.46P AD=1.46P PS=5.46U
+ PD=5.46U
* device instance $4036 r90 *1 298.535,581.945 nfet_05v0
M$4036 \$I587 \$271 \$5 VSS nfet_05v0 L=0.6U W=2U AS=1.46P AD=1.46P PS=5.46U
+ PD=5.46U
* device instance $4037 r90 *1 258.535,269.945 nfet_05v0
M$4037 \$I586 \$92 \$5 VSS nfet_05v0 L=0.6U W=2U AS=1.46P AD=1.46P PS=5.46U
+ PD=5.46U
* device instance $4038 r90 *1 298.535,269.945 nfet_05v0
M$4038 \$I585 \$94 \$5 VSS nfet_05v0 L=0.6U W=2U AS=1.46P AD=1.46P PS=5.46U
+ PD=5.46U
* device instance $4039 r90 *1 138.535,269.945 nfet_05v0
M$4039 \$I584 \$86 \$5 VSS nfet_05v0 L=0.6U W=2U AS=1.46P AD=1.46P PS=5.46U
+ PD=5.46U
* device instance $4040 r90 *1 98.535,269.945 nfet_05v0
M$4040 \$I583 \$84 \$5 VSS nfet_05v0 L=0.6U W=2U AS=1.46P AD=1.46P PS=5.46U
+ PD=5.46U
* device instance $4041 r90 *1 258.535,581.945 nfet_05v0
M$4041 \$I582 \$270 \$5 VSS nfet_05v0 L=0.6U W=2U AS=1.46P AD=1.46P PS=5.46U
+ PD=5.46U
* device instance $4042 r90 *1 58.535,269.945 nfet_05v0
M$4042 \$I581 \$82 \$5 VSS nfet_05v0 L=0.6U W=2U AS=1.46P AD=1.46P PS=5.46U
+ PD=5.46U
* device instance $4043 r90 *1 178.535,425.945 nfet_05v0
M$4043 \$I580 \$155 \$5 VSS nfet_05v0 L=0.6U W=2U AS=1.46P AD=1.46P PS=5.46U
+ PD=5.46U
* device instance $4044 r90 *1 178.535,269.945 nfet_05v0
M$4044 \$I579 \$88 \$5 VSS nfet_05v0 L=0.6U W=2U AS=1.46P AD=1.46P PS=5.46U
+ PD=5.46U
* device instance $4045 r90 *1 218.535,269.945 nfet_05v0
M$4045 \$I578 \$90 \$5 VSS nfet_05v0 L=0.6U W=2U AS=1.46P AD=1.46P PS=5.46U
+ PD=5.46U
* device instance $4046 r90 *1 258.535,191.945 nfet_05v0
M$4046 \$I577 \$93 \$5 VSS nfet_05v0 L=0.6U W=2U AS=1.46P AD=1.46P PS=5.46U
+ PD=5.46U
* device instance $4047 r90 *1 458.535,581.945 nfet_05v0
M$4047 \$I576 \$275 \$5 VSS nfet_05v0 L=0.6U W=2U AS=1.46P AD=1.46P PS=5.46U
+ PD=5.46U
* device instance $4048 r90 *1 498.535,581.945 nfet_05v0
M$4048 \$I575 \$276 \$5 VSS nfet_05v0 L=0.6U W=2U AS=1.46P AD=1.46P PS=5.46U
+ PD=5.46U
* device instance $4049 r90 *1 378.535,347.945 nfet_05v0
M$4049 \$I574 \$171 \$5 VSS nfet_05v0 L=0.6U W=2U AS=1.46P AD=1.46P PS=5.46U
+ PD=5.46U
* device instance $4050 r90 *1 378.535,425.945 nfet_05v0
M$4050 \$I573 \$170 \$5 VSS nfet_05v0 L=0.6U W=2U AS=1.46P AD=1.46P PS=5.46U
+ PD=5.46U
* device instance $4051 r90 *1 498.535,425.945 nfet_05v0
M$4051 \$I572 \$179 \$5 VSS nfet_05v0 L=0.6U W=2U AS=1.46P AD=1.46P PS=5.46U
+ PD=5.46U
* device instance $4052 r90 *1 258.535,35.945 nfet_05v0
M$4052 \$I571 \$11 \$5 VSS nfet_05v0 L=0.6U W=2U AS=1.46P AD=1.46P PS=5.46U
+ PD=5.46U
* device instance $4053 r90 *1 498.535,347.945 nfet_05v0
M$4053 \$I570 \$180 \$5 VSS nfet_05v0 L=0.6U W=2U AS=1.46P AD=1.46P PS=5.46U
+ PD=5.46U
* device instance $4054 r90 *1 458.535,425.945 nfet_05v0
M$4054 \$I569 \$176 \$5 VSS nfet_05v0 L=0.6U W=2U AS=1.46P AD=1.46P PS=5.46U
+ PD=5.46U
* device instance $4055 r90 *1 418.535,425.945 nfet_05v0
M$4055 \$I568 \$173 \$5 VSS nfet_05v0 L=0.6U W=2U AS=1.46P AD=1.46P PS=5.46U
+ PD=5.46U
* device instance $4056 r90 *1 618.535,425.945 nfet_05v0
M$4056 \$I567 \$188 \$5 VSS nfet_05v0 L=0.6U W=2U AS=1.46P AD=1.46P PS=5.46U
+ PD=5.46U
* device instance $4057 r90 *1 578.535,425.945 nfet_05v0
M$4057 \$I566 \$185 \$5 VSS nfet_05v0 L=0.6U W=2U AS=1.46P AD=1.46P PS=5.46U
+ PD=5.46U
* device instance $4058 r90 *1 538.535,425.945 nfet_05v0
M$4058 \$I565 \$182 \$5 VSS nfet_05v0 L=0.6U W=2U AS=1.46P AD=1.46P PS=5.46U
+ PD=5.46U
* device instance $4059 r90 *1 538.535,581.945 nfet_05v0
M$4059 \$I564 \$277 \$5 VSS nfet_05v0 L=0.6U W=2U AS=1.46P AD=1.46P PS=5.46U
+ PD=5.46U
* device instance $4060 r90 *1 578.535,581.945 nfet_05v0
M$4060 \$I563 \$278 \$5 VSS nfet_05v0 L=0.6U W=2U AS=1.46P AD=1.46P PS=5.46U
+ PD=5.46U
* device instance $4061 r90 *1 338.535,503.945 nfet_05v0
M$4061 \$I562 \$166 \$5 VSS nfet_05v0 L=0.6U W=2U AS=1.46P AD=1.46P PS=5.46U
+ PD=5.46U
* device instance $4062 r90 *1 618.535,581.945 nfet_05v0
M$4062 \$I561 \$279 \$5 VSS nfet_05v0 L=0.6U W=2U AS=1.46P AD=1.46P PS=5.46U
+ PD=5.46U
* device instance $4063 r90 *1 218.535,35.945 nfet_05v0
M$4063 \$I560 \$10 \$5 VSS nfet_05v0 L=0.6U W=2U AS=1.46P AD=1.46P PS=5.46U
+ PD=5.46U
* device instance $4064 r90 *1 578.535,347.945 nfet_05v0
M$4064 \$I559 \$186 \$5 VSS nfet_05v0 L=0.6U W=2U AS=1.46P AD=1.46P PS=5.46U
+ PD=5.46U
* device instance $4065 r90 *1 658.535,425.945 nfet_05v0
M$4065 \$I558 \$191 \$5 VSS nfet_05v0 L=0.6U W=2U AS=1.46P AD=1.46P PS=5.46U
+ PD=5.46U
* device instance $4066 r90 *1 578.535,269.945 nfet_05v0
M$4066 \$I557 \$108 \$5 VSS nfet_05v0 L=0.6U W=2U AS=1.46P AD=1.46P PS=5.46U
+ PD=5.46U
* device instance $4067 r90 *1 618.535,269.945 nfet_05v0
M$4067 \$I556 \$110 \$5 VSS nfet_05v0 L=0.6U W=2U AS=1.46P AD=1.46P PS=5.46U
+ PD=5.46U
* device instance $4068 r90 *1 658.535,269.945 nfet_05v0
M$4068 \$I555 \$112 \$5 VSS nfet_05v0 L=0.6U W=2U AS=1.46P AD=1.46P PS=5.46U
+ PD=5.46U
* device instance $4069 r90 *1 538.535,269.945 nfet_05v0
M$4069 \$I554 \$106 \$5 VSS nfet_05v0 L=0.6U W=2U AS=1.46P AD=1.46P PS=5.46U
+ PD=5.46U
* device instance $4070 r90 *1 498.535,269.945 nfet_05v0
M$4070 \$I553 \$104 \$5 VSS nfet_05v0 L=0.6U W=2U AS=1.46P AD=1.46P PS=5.46U
+ PD=5.46U
* device instance $4071 r90 *1 658.535,347.945 nfet_05v0
M$4071 \$I552 \$192 \$5 VSS nfet_05v0 L=0.6U W=2U AS=1.46P AD=1.46P PS=5.46U
+ PD=5.46U
* device instance $4072 r90 *1 458.535,269.945 nfet_05v0
M$4072 \$I551 \$102 \$5 VSS nfet_05v0 L=0.6U W=2U AS=1.46P AD=1.46P PS=5.46U
+ PD=5.46U
* device instance $4073 r90 *1 378.535,269.945 nfet_05v0
M$4073 \$I550 \$98 \$5 VSS nfet_05v0 L=0.6U W=2U AS=1.46P AD=1.46P PS=5.46U
+ PD=5.46U
* device instance $4074 r90 *1 618.535,347.945 nfet_05v0
M$4074 \$I549 \$189 \$5 VSS nfet_05v0 L=0.6U W=2U AS=1.46P AD=1.46P PS=5.46U
+ PD=5.46U
* device instance $4075 r90 *1 418.535,269.945 nfet_05v0
M$4075 \$I548 \$100 \$5 VSS nfet_05v0 L=0.6U W=2U AS=1.46P AD=1.46P PS=5.46U
+ PD=5.46U
* device instance $4076 r90 *1 538.535,347.945 nfet_05v0
M$4076 \$I547 \$183 \$5 VSS nfet_05v0 L=0.6U W=2U AS=1.46P AD=1.46P PS=5.46U
+ PD=5.46U
* device instance $4077 r90 *1 658.535,581.945 nfet_05v0
M$4077 \$I546 \$280 \$5 VSS nfet_05v0 L=0.6U W=2U AS=1.46P AD=1.46P PS=5.46U
+ PD=5.46U
* device instance $4078 r90 *1 98.535,581.945 nfet_05v0
M$4078 \$I545 \$266 \$5 VSS nfet_05v0 L=0.6U W=2U AS=1.46P AD=1.46P PS=5.46U
+ PD=5.46U
* device instance $4079 r90 *1 98.535,425.945 nfet_05v0
M$4079 \$I544 \$149 \$5 VSS nfet_05v0 L=0.6U W=2U AS=1.46P AD=1.46P PS=5.46U
+ PD=5.46U
* device instance $4080 r90 *1 58.535,425.945 nfet_05v0
M$4080 \$I543 \$146 \$5 VSS nfet_05v0 L=0.6U W=2U AS=1.46P AD=1.46P PS=5.46U
+ PD=5.46U
* device instance $4081 r90 *1 138.535,35.945 nfet_05v0
M$4081 \$I542 \$8 \$5 VSS nfet_05v0 L=0.6U W=2U AS=1.46P AD=1.46P PS=5.46U
+ PD=5.46U
* device instance $4082 r90 *1 58.535,113.945 nfet_05v0
M$4082 \$I541 \$25 \$5 VSS nfet_05v0 L=0.6U W=2U AS=1.46P AD=1.46P PS=5.46U
+ PD=5.46U
* device instance $4083 r90 *1 98.535,113.945 nfet_05v0
M$4083 \$I540 \$26 \$5 VSS nfet_05v0 L=0.6U W=2U AS=1.46P AD=1.46P PS=5.46U
+ PD=5.46U
* device instance $4084 r90 *1 138.535,113.945 nfet_05v0
M$4084 \$I539 \$27 \$5 VSS nfet_05v0 L=0.6U W=2U AS=1.46P AD=1.46P PS=5.46U
+ PD=5.46U
* device instance $4085 r90 *1 458.535,35.945 nfet_05v0
M$4085 \$I538 \$16 \$5 VSS nfet_05v0 L=0.6U W=2U AS=1.46P AD=1.46P PS=5.46U
+ PD=5.46U
* device instance $4086 r90 *1 98.535,35.945 nfet_05v0
M$4086 \$I537 \$7 \$5 VSS nfet_05v0 L=0.6U W=2U AS=1.46P AD=1.46P PS=5.46U
+ PD=5.46U
* device instance $4087 r90 *1 58.535,191.945 nfet_05v0
M$4087 \$I536 \$83 \$5 VSS nfet_05v0 L=0.6U W=2U AS=1.46P AD=1.46P PS=5.46U
+ PD=5.46U
* device instance $4088 r90 *1 98.535,191.945 nfet_05v0
M$4088 \$I535 \$85 \$5 VSS nfet_05v0 L=0.6U W=2U AS=1.46P AD=1.46P PS=5.46U
+ PD=5.46U
* device instance $4089 r90 *1 138.535,191.945 nfet_05v0
M$4089 \$I534 \$87 \$5 VSS nfet_05v0 L=0.6U W=2U AS=1.46P AD=1.46P PS=5.46U
+ PD=5.46U
* device instance $4090 r90 *1 498.535,35.945 nfet_05v0
M$4090 \$I533 \$17 \$5 VSS nfet_05v0 L=0.6U W=2U AS=1.46P AD=1.46P PS=5.46U
+ PD=5.46U
* device instance $4091 r90 *1 298.535,35.945 nfet_05v0
M$4091 \$I532 \$12 \$5 VSS nfet_05v0 L=0.6U W=2U AS=1.46P AD=1.46P PS=5.46U
+ PD=5.46U
* device instance $4092 r90 *1 418.535,581.945 nfet_05v0
M$4092 \$I531 \$274 \$5 VSS nfet_05v0 L=0.6U W=2U AS=1.46P AD=1.46P PS=5.46U
+ PD=5.46U
* device instance $4093 r90 *1 418.535,347.945 nfet_05v0
M$4093 \$I530 \$174 \$5 VSS nfet_05v0 L=0.6U W=2U AS=1.46P AD=1.46P PS=5.46U
+ PD=5.46U
* device instance $4094 r90 *1 218.535,191.945 nfet_05v0
M$4094 \$I529 \$91 \$5 VSS nfet_05v0 L=0.6U W=2U AS=1.46P AD=1.46P PS=5.46U
+ PD=5.46U
* device instance $4095 r90 *1 298.535,191.945 nfet_05v0
M$4095 \$I528 \$95 \$5 VSS nfet_05v0 L=0.6U W=2U AS=1.46P AD=1.46P PS=5.46U
+ PD=5.46U
* device instance $4096 r90 *1 298.535,113.945 nfet_05v0
M$4096 \$I527 \$31 \$5 VSS nfet_05v0 L=0.6U W=2U AS=1.46P AD=1.46P PS=5.46U
+ PD=5.46U
* device instance $4097 r90 *1 458.535,347.945 nfet_05v0
M$4097 \$I526 \$177 \$5 VSS nfet_05v0 L=0.6U W=2U AS=1.46P AD=1.46P PS=5.46U
+ PD=5.46U
* device instance $4098 r90 *1 378.535,581.945 nfet_05v0
M$4098 \$I525 \$273 \$5 VSS nfet_05v0 L=0.6U W=2U AS=1.46P AD=1.46P PS=5.46U
+ PD=5.46U
* device instance $4099 r90 *1 218.535,113.945 nfet_05v0
M$4099 \$I524 \$29 \$5 VSS nfet_05v0 L=0.6U W=2U AS=1.46P AD=1.46P PS=5.46U
+ PD=5.46U
* device instance $4100 r90 *1 258.535,113.945 nfet_05v0
M$4100 \$I523 \$30 \$5 VSS nfet_05v0 L=0.6U W=2U AS=1.46P AD=1.46P PS=5.46U
+ PD=5.46U
* device instance $4101 r90 *1 418.535,191.945 nfet_05v0
M$4101 \$I522 \$101 \$5 VSS nfet_05v0 L=0.6U W=2U AS=1.46P AD=1.46P PS=5.46U
+ PD=5.46U
* device instance $4102 r90 *1 458.535,191.945 nfet_05v0
M$4102 \$I521 \$103 \$5 VSS nfet_05v0 L=0.6U W=2U AS=1.46P AD=1.46P PS=5.46U
+ PD=5.46U
* device instance $4103 r90 *1 498.535,191.945 nfet_05v0
M$4103 \$I520 \$105 \$5 VSS nfet_05v0 L=0.6U W=2U AS=1.46P AD=1.46P PS=5.46U
+ PD=5.46U
* device instance $4104 r90 *1 418.535,113.945 nfet_05v0
M$4104 \$I519 \$34 \$5 VSS nfet_05v0 L=0.6U W=2U AS=1.46P AD=1.46P PS=5.46U
+ PD=5.46U
* device instance $4105 r90 *1 458.535,113.945 nfet_05v0
M$4105 \$I518 \$35 \$5 VSS nfet_05v0 L=0.6U W=2U AS=1.46P AD=1.46P PS=5.46U
+ PD=5.46U
* device instance $4106 r90 *1 498.535,113.945 nfet_05v0
M$4106 \$I517 \$36 \$5 VSS nfet_05v0 L=0.6U W=2U AS=1.46P AD=1.46P PS=5.46U
+ PD=5.46U
* device instance $4107 r90 *1 178.535,581.945 nfet_05v0
M$4107 \$I516 \$268 \$5 VSS nfet_05v0 L=0.6U W=2U AS=1.46P AD=1.46P PS=5.46U
+ PD=5.46U
* device instance $4108 r90 *1 418.535,35.945 nfet_05v0
M$4108 \$I515 \$15 \$5 VSS nfet_05v0 L=0.6U W=2U AS=1.46P AD=1.46P PS=5.46U
+ PD=5.46U
* device instance $4109 r90 *1 378.535,191.945 nfet_05v0
M$4109 \$I514 \$99 \$5 VSS nfet_05v0 L=0.6U W=2U AS=1.46P AD=1.46P PS=5.46U
+ PD=5.46U
* device instance $4110 r90 *1 55.025,35.915 pfet_05v0
M$4110 \$I641 \$I4525 \$5 VDD_DEC pfet_05v0 L=0.5U W=6U AS=3.14P AD=3.14P
+ PS=11.14U PD=11.14U
* device instance $4113 r90 *1 175.025,113.915 pfet_05v0
M$4113 \$I640 \$I4526 \$5 VDD_DEC pfet_05v0 L=0.5U W=6U AS=3.14P AD=3.14P
+ PS=11.14U PD=11.14U
* device instance $4116 r90 *1 175.025,35.915 pfet_05v0
M$4116 \$I639 \$I4527 \$5 VDD_DEC pfet_05v0 L=0.5U W=6U AS=3.14P AD=3.14P
+ PS=11.14U PD=11.14U
* device instance $4119 r90 *1 215.025,581.915 pfet_05v0
M$4119 \$I638 \$I4528 \$5 VDD_DEC pfet_05v0 L=0.5U W=6U AS=3.14P AD=3.14P
+ PS=11.14U PD=11.14U
* device instance $4122 r90 *1 295.025,347.915 pfet_05v0
M$4122 \$I637 \$I4529 \$5 VDD_DEC pfet_05v0 L=0.5U W=6U AS=3.14P AD=3.14P
+ PS=11.14U PD=11.14U
* device instance $4125 r90 *1 535.025,35.915 pfet_05v0
M$4125 \$I636 \$I4530 \$5 VDD_DEC pfet_05v0 L=0.5U W=6U AS=3.14P AD=3.14P
+ PS=11.14U PD=11.14U
* device instance $4128 r90 *1 175.025,347.915 pfet_05v0
M$4128 \$I635 \$I4531 \$5 VDD_DEC pfet_05v0 L=0.5U W=6U AS=3.14P AD=3.14P
+ PS=11.14U PD=11.14U
* device instance $4131 r90 *1 255.025,347.915 pfet_05v0
M$4131 \$I634 \$I4532 \$5 VDD_DEC pfet_05v0 L=0.5U W=6U AS=3.14P AD=3.14P
+ PS=11.14U PD=11.14U
* device instance $4134 r90 *1 655.025,35.915 pfet_05v0
M$4134 \$I633 \$I4533 \$5 VDD_DEC pfet_05v0 L=0.5U W=6U AS=3.14P AD=3.14P
+ PS=11.14U PD=11.14U
* device instance $4137 r90 *1 295.025,425.915 pfet_05v0
M$4137 \$I632 \$I4534 \$5 VDD_DEC pfet_05v0 L=0.5U W=6U AS=3.14P AD=3.14P
+ PS=11.14U PD=11.14U
* device instance $4140 r90 *1 175.025,191.915 pfet_05v0
M$4140 \$I631 \$I4535 \$5 VDD_DEC pfet_05v0 L=0.5U W=6U AS=3.14P AD=3.14P
+ PS=11.14U PD=11.14U
* device instance $4143 r90 *1 655.025,191.915 pfet_05v0
M$4143 \$I630 \$I4536 \$5 VDD_DEC pfet_05v0 L=0.5U W=6U AS=3.14P AD=3.14P
+ PS=11.14U PD=11.14U
* device instance $4146 r90 *1 55.025,581.915 pfet_05v0
M$4146 \$I629 \$I4537 \$5 VDD_DEC pfet_05v0 L=0.5U W=6U AS=3.14P AD=3.14P
+ PS=11.14U PD=11.14U
* device instance $4149 r90 *1 615.025,191.915 pfet_05v0
M$4149 \$I628 \$I4538 \$5 VDD_DEC pfet_05v0 L=0.5U W=6U AS=3.14P AD=3.14P
+ PS=11.14U PD=11.14U
* device instance $4152 r90 *1 575.025,191.915 pfet_05v0
M$4152 \$I627 \$I4539 \$5 VDD_DEC pfet_05v0 L=0.5U W=6U AS=3.14P AD=3.14P
+ PS=11.14U PD=11.14U
* device instance $4155 r90 *1 535.025,191.915 pfet_05v0
M$4155 \$I626 \$I4540 \$5 VDD_DEC pfet_05v0 L=0.5U W=6U AS=3.14P AD=3.14P
+ PS=11.14U PD=11.14U
* device instance $4158 r90 *1 375.025,113.915 pfet_05v0
M$4158 \$I625 \$I4541 \$5 VDD_DEC pfet_05v0 L=0.5U W=6U AS=3.14P AD=3.14P
+ PS=11.14U PD=11.14U
* device instance $4161 r90 *1 95.025,347.915 pfet_05v0
M$4161 \$I624 \$I4542 \$5 VDD_DEC pfet_05v0 L=0.5U W=6U AS=3.14P AD=3.14P
+ PS=11.14U PD=11.14U
* device instance $4164 r90 *1 375.025,35.915 pfet_05v0
M$4164 \$I623 \$I4543 \$5 VDD_DEC pfet_05v0 L=0.5U W=6U AS=3.14P AD=3.14P
+ PS=11.14U PD=11.14U
* device instance $4167 r90 *1 55.025,347.915 pfet_05v0
M$4167 \$I622 \$I4544 \$5 VDD_DEC pfet_05v0 L=0.5U W=6U AS=3.14P AD=3.14P
+ PS=11.14U PD=11.14U
* device instance $4170 r90 *1 575.025,35.915 pfet_05v0
M$4170 \$I621 \$I4545 \$5 VDD_DEC pfet_05v0 L=0.5U W=6U AS=3.14P AD=3.14P
+ PS=11.14U PD=11.14U
* device instance $4173 r90 *1 615.025,35.915 pfet_05v0
M$4173 \$I620 \$I4546 \$5 VDD_DEC pfet_05v0 L=0.5U W=6U AS=3.14P AD=3.14P
+ PS=11.14U PD=11.14U
* device instance $4176 r90 *1 535.025,113.915 pfet_05v0
M$4176 \$I619 \$I4547 \$5 VDD_DEC pfet_05v0 L=0.5U W=6U AS=3.14P AD=3.14P
+ PS=11.14U PD=11.14U
* device instance $4179 r90 *1 575.025,113.915 pfet_05v0
M$4179 \$I618 \$I4548 \$5 VDD_DEC pfet_05v0 L=0.5U W=6U AS=3.14P AD=3.14P
+ PS=11.14U PD=11.14U
* device instance $4182 r90 *1 255.025,425.915 pfet_05v0
M$4182 \$I617 \$I4549 \$5 VDD_DEC pfet_05v0 L=0.5U W=6U AS=3.14P AD=3.14P
+ PS=11.14U PD=11.14U
* device instance $4185 r90 *1 615.025,113.915 pfet_05v0
M$4185 \$I616 \$I4550 \$5 VDD_DEC pfet_05v0 L=0.5U W=6U AS=3.14P AD=3.14P
+ PS=11.14U PD=11.14U
* device instance $4188 r90 *1 135.025,425.915 pfet_05v0
M$4188 \$I615 \$I4551 \$5 VDD_DEC pfet_05v0 L=0.5U W=6U AS=3.14P AD=3.14P
+ PS=11.14U PD=11.14U
* device instance $4191 r90 *1 655.025,113.915 pfet_05v0
M$4191 \$I614 \$I4552 \$5 VDD_DEC pfet_05v0 L=0.5U W=6U AS=3.14P AD=3.14P
+ PS=11.14U PD=11.14U
* device instance $4194 r90 *1 215.025,347.915 pfet_05v0
M$4194 \$I613 \$I4553 \$5 VDD_DEC pfet_05v0 L=0.5U W=6U AS=3.14P AD=3.14P
+ PS=11.14U PD=11.14U
* device instance $4197 r90 *1 215.025,425.915 pfet_05v0
M$4197 \$I612 \$I4554 \$5 VDD_DEC pfet_05v0 L=0.5U W=6U AS=3.14P AD=3.14P
+ PS=11.14U PD=11.14U
* device instance $4200 r90 *1 335.025,581.915 pfet_05v0
M$4200 \$I611 \$I4555 \$5 VDD_DEC pfet_05v0 L=0.5U W=6U AS=3.14P AD=3.14P
+ PS=11.14U PD=11.14U
* device instance $4203 r90 *1 135.025,347.915 pfet_05v0
M$4203 \$I610 \$I4556 \$5 VDD_DEC pfet_05v0 L=0.5U W=6U AS=3.14P AD=3.14P
+ PS=11.14U PD=11.14U
* device instance $4206 r90 *1 335.025,425.915 pfet_05v0
M$4206 \$I609 \$I4557 \$5 VDD_DEC pfet_05v0 L=0.5U W=6U AS=3.14P AD=3.14P
+ PS=11.14U PD=11.14U
* device instance $4209 r90 *1 335.025,347.915 pfet_05v0
M$4209 \$I608 \$I4558 \$5 VDD_DEC pfet_05v0 L=0.5U W=6U AS=3.14P AD=3.14P
+ PS=11.14U PD=11.14U
* device instance $4212 r90 *1 335.025,269.915 pfet_05v0
M$4212 \$I607 \$I4559 \$5 VDD_DEC pfet_05v0 L=0.5U W=6U AS=3.14P AD=3.14P
+ PS=11.14U PD=11.14U
* device instance $4215 r90 *1 335.025,191.915 pfet_05v0
M$4215 \$I606 \$I4560 \$5 VDD_DEC pfet_05v0 L=0.5U W=6U AS=3.14P AD=3.14P
+ PS=11.14U PD=11.14U
* device instance $4218 r90 *1 335.025,113.915 pfet_05v0
M$4218 \$I605 \$I4561 \$5 VDD_DEC pfet_05v0 L=0.5U W=6U AS=3.14P AD=3.14P
+ PS=11.14U PD=11.14U
* device instance $4221 r90 *1 335.025,35.915 pfet_05v0
M$4221 \$I604 \$I4562 \$5 VDD_DEC pfet_05v0 L=0.5U W=6U AS=3.14P AD=3.14P
+ PS=11.14U PD=11.14U
* device instance $4224 r90 *1 375.025,503.915 pfet_05v0
M$4224 \$I603 \$I4563 \$5 VDD_DEC pfet_05v0 L=0.5U W=6U AS=3.14P AD=3.14P
+ PS=11.14U PD=11.14U
* device instance $4227 r90 *1 415.025,503.915 pfet_05v0
M$4227 \$I602 \$I4564 \$5 VDD_DEC pfet_05v0 L=0.5U W=6U AS=3.14P AD=3.14P
+ PS=11.14U PD=11.14U
* device instance $4230 r90 *1 455.025,503.915 pfet_05v0
M$4230 \$I601 \$I4565 \$5 VDD_DEC pfet_05v0 L=0.5U W=6U AS=3.14P AD=3.14P
+ PS=11.14U PD=11.14U
* device instance $4233 r90 *1 495.025,503.915 pfet_05v0
M$4233 \$I600 \$I4566 \$5 VDD_DEC pfet_05v0 L=0.5U W=6U AS=3.14P AD=3.14P
+ PS=11.14U PD=11.14U
* device instance $4236 r90 *1 615.025,503.915 pfet_05v0
M$4236 \$I599 \$I4567 \$5 VDD_DEC pfet_05v0 L=0.5U W=6U AS=3.14P AD=3.14P
+ PS=11.14U PD=11.14U
* device instance $4239 r90 *1 655.025,503.915 pfet_05v0
M$4239 \$I598 \$I4568 \$5 VDD_DEC pfet_05v0 L=0.5U W=6U AS=3.14P AD=3.14P
+ PS=11.14U PD=11.14U
* device instance $4242 r90 *1 535.025,503.915 pfet_05v0
M$4242 \$I597 \$I4569 \$5 VDD_DEC pfet_05v0 L=0.5U W=6U AS=3.14P AD=3.14P
+ PS=11.14U PD=11.14U
* device instance $4245 r90 *1 575.025,503.915 pfet_05v0
M$4245 \$I596 \$I4570 \$5 VDD_DEC pfet_05v0 L=0.5U W=6U AS=3.14P AD=3.14P
+ PS=11.14U PD=11.14U
* device instance $4248 r90 *1 175.025,503.915 pfet_05v0
M$4248 \$I595 \$I4571 \$5 VDD_DEC pfet_05v0 L=0.5U W=6U AS=3.14P AD=3.14P
+ PS=11.14U PD=11.14U
* device instance $4251 r90 *1 135.025,581.915 pfet_05v0
M$4251 \$I594 \$I4572 \$5 VDD_DEC pfet_05v0 L=0.5U W=6U AS=3.14P AD=3.14P
+ PS=11.14U PD=11.14U
* device instance $4254 r90 *1 55.025,503.915 pfet_05v0
M$4254 \$I593 \$I4573 \$5 VDD_DEC pfet_05v0 L=0.5U W=6U AS=3.14P AD=3.14P
+ PS=11.14U PD=11.14U
* device instance $4257 r90 *1 95.025,503.915 pfet_05v0
M$4257 \$I592 \$I4574 \$5 VDD_DEC pfet_05v0 L=0.5U W=6U AS=3.14P AD=3.14P
+ PS=11.14U PD=11.14U
* device instance $4260 r90 *1 135.025,503.915 pfet_05v0
M$4260 \$I591 \$I4575 \$5 VDD_DEC pfet_05v0 L=0.5U W=6U AS=3.14P AD=3.14P
+ PS=11.14U PD=11.14U
* device instance $4263 r90 *1 215.025,503.915 pfet_05v0
M$4263 \$I590 \$I4576 \$5 VDD_DEC pfet_05v0 L=0.5U W=6U AS=3.14P AD=3.14P
+ PS=11.14U PD=11.14U
* device instance $4266 r90 *1 255.025,503.915 pfet_05v0
M$4266 \$I589 \$I4577 \$5 VDD_DEC pfet_05v0 L=0.5U W=6U AS=3.14P AD=3.14P
+ PS=11.14U PD=11.14U
* device instance $4269 r90 *1 295.025,503.915 pfet_05v0
M$4269 \$I588 \$I4578 \$5 VDD_DEC pfet_05v0 L=0.5U W=6U AS=3.14P AD=3.14P
+ PS=11.14U PD=11.14U
* device instance $4272 r90 *1 295.025,581.915 pfet_05v0
M$4272 \$I587 \$I4579 \$5 VDD_DEC pfet_05v0 L=0.5U W=6U AS=3.14P AD=3.14P
+ PS=11.14U PD=11.14U
* device instance $4275 r90 *1 255.025,269.915 pfet_05v0
M$4275 \$I586 \$I4580 \$5 VDD_DEC pfet_05v0 L=0.5U W=6U AS=3.14P AD=3.14P
+ PS=11.14U PD=11.14U
* device instance $4278 r90 *1 295.025,269.915 pfet_05v0
M$4278 \$I585 \$I4581 \$5 VDD_DEC pfet_05v0 L=0.5U W=6U AS=3.14P AD=3.14P
+ PS=11.14U PD=11.14U
* device instance $4281 r90 *1 135.025,269.915 pfet_05v0
M$4281 \$I584 \$I4582 \$5 VDD_DEC pfet_05v0 L=0.5U W=6U AS=3.14P AD=3.14P
+ PS=11.14U PD=11.14U
* device instance $4284 r90 *1 95.025,269.915 pfet_05v0
M$4284 \$I583 \$I4583 \$5 VDD_DEC pfet_05v0 L=0.5U W=6U AS=3.14P AD=3.14P
+ PS=11.14U PD=11.14U
* device instance $4287 r90 *1 255.025,581.915 pfet_05v0
M$4287 \$I582 \$I4584 \$5 VDD_DEC pfet_05v0 L=0.5U W=6U AS=3.14P AD=3.14P
+ PS=11.14U PD=11.14U
* device instance $4290 r90 *1 55.025,269.915 pfet_05v0
M$4290 \$I581 \$I4585 \$5 VDD_DEC pfet_05v0 L=0.5U W=6U AS=3.14P AD=3.14P
+ PS=11.14U PD=11.14U
* device instance $4293 r90 *1 175.025,425.915 pfet_05v0
M$4293 \$I580 \$I4586 \$5 VDD_DEC pfet_05v0 L=0.5U W=6U AS=3.14P AD=3.14P
+ PS=11.14U PD=11.14U
* device instance $4296 r90 *1 175.025,269.915 pfet_05v0
M$4296 \$I579 \$I4587 \$5 VDD_DEC pfet_05v0 L=0.5U W=6U AS=3.14P AD=3.14P
+ PS=11.14U PD=11.14U
* device instance $4299 r90 *1 215.025,269.915 pfet_05v0
M$4299 \$I578 \$I4588 \$5 VDD_DEC pfet_05v0 L=0.5U W=6U AS=3.14P AD=3.14P
+ PS=11.14U PD=11.14U
* device instance $4302 r90 *1 255.025,191.915 pfet_05v0
M$4302 \$I577 \$I4589 \$5 VDD_DEC pfet_05v0 L=0.5U W=6U AS=3.14P AD=3.14P
+ PS=11.14U PD=11.14U
* device instance $4305 r90 *1 455.025,581.915 pfet_05v0
M$4305 \$I576 \$I4590 \$5 VDD_DEC pfet_05v0 L=0.5U W=6U AS=3.14P AD=3.14P
+ PS=11.14U PD=11.14U
* device instance $4308 r90 *1 495.025,581.915 pfet_05v0
M$4308 \$I575 \$I4591 \$5 VDD_DEC pfet_05v0 L=0.5U W=6U AS=3.14P AD=3.14P
+ PS=11.14U PD=11.14U
* device instance $4311 r90 *1 375.025,347.915 pfet_05v0
M$4311 \$I574 \$I4592 \$5 VDD_DEC pfet_05v0 L=0.5U W=6U AS=3.14P AD=3.14P
+ PS=11.14U PD=11.14U
* device instance $4314 r90 *1 375.025,425.915 pfet_05v0
M$4314 \$I573 \$I4593 \$5 VDD_DEC pfet_05v0 L=0.5U W=6U AS=3.14P AD=3.14P
+ PS=11.14U PD=11.14U
* device instance $4317 r90 *1 495.025,425.915 pfet_05v0
M$4317 \$I572 \$I4594 \$5 VDD_DEC pfet_05v0 L=0.5U W=6U AS=3.14P AD=3.14P
+ PS=11.14U PD=11.14U
* device instance $4320 r90 *1 255.025,35.915 pfet_05v0
M$4320 \$I571 \$I4595 \$5 VDD_DEC pfet_05v0 L=0.5U W=6U AS=3.14P AD=3.14P
+ PS=11.14U PD=11.14U
* device instance $4323 r90 *1 495.025,347.915 pfet_05v0
M$4323 \$I570 \$I4596 \$5 VDD_DEC pfet_05v0 L=0.5U W=6U AS=3.14P AD=3.14P
+ PS=11.14U PD=11.14U
* device instance $4326 r90 *1 455.025,425.915 pfet_05v0
M$4326 \$I569 \$I4597 \$5 VDD_DEC pfet_05v0 L=0.5U W=6U AS=3.14P AD=3.14P
+ PS=11.14U PD=11.14U
* device instance $4329 r90 *1 415.025,425.915 pfet_05v0
M$4329 \$I568 \$I4598 \$5 VDD_DEC pfet_05v0 L=0.5U W=6U AS=3.14P AD=3.14P
+ PS=11.14U PD=11.14U
* device instance $4332 r90 *1 615.025,425.915 pfet_05v0
M$4332 \$I567 \$I4599 \$5 VDD_DEC pfet_05v0 L=0.5U W=6U AS=3.14P AD=3.14P
+ PS=11.14U PD=11.14U
* device instance $4335 r90 *1 575.025,425.915 pfet_05v0
M$4335 \$I566 \$I4600 \$5 VDD_DEC pfet_05v0 L=0.5U W=6U AS=3.14P AD=3.14P
+ PS=11.14U PD=11.14U
* device instance $4338 r90 *1 535.025,425.915 pfet_05v0
M$4338 \$I565 \$I4601 \$5 VDD_DEC pfet_05v0 L=0.5U W=6U AS=3.14P AD=3.14P
+ PS=11.14U PD=11.14U
* device instance $4341 r90 *1 535.025,581.915 pfet_05v0
M$4341 \$I564 \$I4602 \$5 VDD_DEC pfet_05v0 L=0.5U W=6U AS=3.14P AD=3.14P
+ PS=11.14U PD=11.14U
* device instance $4344 r90 *1 575.025,581.915 pfet_05v0
M$4344 \$I563 \$I4603 \$5 VDD_DEC pfet_05v0 L=0.5U W=6U AS=3.14P AD=3.14P
+ PS=11.14U PD=11.14U
* device instance $4347 r90 *1 335.025,503.915 pfet_05v0
M$4347 \$I562 \$I4604 \$5 VDD_DEC pfet_05v0 L=0.5U W=6U AS=3.14P AD=3.14P
+ PS=11.14U PD=11.14U
* device instance $4350 r90 *1 615.025,581.915 pfet_05v0
M$4350 \$I561 \$I4605 \$5 VDD_DEC pfet_05v0 L=0.5U W=6U AS=3.14P AD=3.14P
+ PS=11.14U PD=11.14U
* device instance $4353 r90 *1 215.025,35.915 pfet_05v0
M$4353 \$I560 \$I4606 \$5 VDD_DEC pfet_05v0 L=0.5U W=6U AS=3.14P AD=3.14P
+ PS=11.14U PD=11.14U
* device instance $4356 r90 *1 575.025,347.915 pfet_05v0
M$4356 \$I559 \$I4607 \$5 VDD_DEC pfet_05v0 L=0.5U W=6U AS=3.14P AD=3.14P
+ PS=11.14U PD=11.14U
* device instance $4359 r90 *1 655.025,425.915 pfet_05v0
M$4359 \$I558 \$I4608 \$5 VDD_DEC pfet_05v0 L=0.5U W=6U AS=3.14P AD=3.14P
+ PS=11.14U PD=11.14U
* device instance $4362 r90 *1 575.025,269.915 pfet_05v0
M$4362 \$I557 \$I4609 \$5 VDD_DEC pfet_05v0 L=0.5U W=6U AS=3.14P AD=3.14P
+ PS=11.14U PD=11.14U
* device instance $4365 r90 *1 615.025,269.915 pfet_05v0
M$4365 \$I556 \$I4610 \$5 VDD_DEC pfet_05v0 L=0.5U W=6U AS=3.14P AD=3.14P
+ PS=11.14U PD=11.14U
* device instance $4368 r90 *1 655.025,269.915 pfet_05v0
M$4368 \$I555 \$I4611 \$5 VDD_DEC pfet_05v0 L=0.5U W=6U AS=3.14P AD=3.14P
+ PS=11.14U PD=11.14U
* device instance $4371 r90 *1 535.025,269.915 pfet_05v0
M$4371 \$I554 \$I4612 \$5 VDD_DEC pfet_05v0 L=0.5U W=6U AS=3.14P AD=3.14P
+ PS=11.14U PD=11.14U
* device instance $4374 r90 *1 495.025,269.915 pfet_05v0
M$4374 \$I553 \$I4613 \$5 VDD_DEC pfet_05v0 L=0.5U W=6U AS=3.14P AD=3.14P
+ PS=11.14U PD=11.14U
* device instance $4377 r90 *1 655.025,347.915 pfet_05v0
M$4377 \$I552 \$I4614 \$5 VDD_DEC pfet_05v0 L=0.5U W=6U AS=3.14P AD=3.14P
+ PS=11.14U PD=11.14U
* device instance $4380 r90 *1 455.025,269.915 pfet_05v0
M$4380 \$I551 \$I4615 \$5 VDD_DEC pfet_05v0 L=0.5U W=6U AS=3.14P AD=3.14P
+ PS=11.14U PD=11.14U
* device instance $4383 r90 *1 375.025,269.915 pfet_05v0
M$4383 \$I550 \$I4616 \$5 VDD_DEC pfet_05v0 L=0.5U W=6U AS=3.14P AD=3.14P
+ PS=11.14U PD=11.14U
* device instance $4386 r90 *1 615.025,347.915 pfet_05v0
M$4386 \$I549 \$I4617 \$5 VDD_DEC pfet_05v0 L=0.5U W=6U AS=3.14P AD=3.14P
+ PS=11.14U PD=11.14U
* device instance $4389 r90 *1 415.025,269.915 pfet_05v0
M$4389 \$I548 \$I4618 \$5 VDD_DEC pfet_05v0 L=0.5U W=6U AS=3.14P AD=3.14P
+ PS=11.14U PD=11.14U
* device instance $4392 r90 *1 535.025,347.915 pfet_05v0
M$4392 \$I547 \$I4619 \$5 VDD_DEC pfet_05v0 L=0.5U W=6U AS=3.14P AD=3.14P
+ PS=11.14U PD=11.14U
* device instance $4395 r90 *1 655.025,581.915 pfet_05v0
M$4395 \$I546 \$I4620 \$5 VDD_DEC pfet_05v0 L=0.5U W=6U AS=3.14P AD=3.14P
+ PS=11.14U PD=11.14U
* device instance $4398 r90 *1 95.025,581.915 pfet_05v0
M$4398 \$I545 \$I4621 \$5 VDD_DEC pfet_05v0 L=0.5U W=6U AS=3.14P AD=3.14P
+ PS=11.14U PD=11.14U
* device instance $4401 r90 *1 95.025,425.915 pfet_05v0
M$4401 \$I544 \$I4622 \$5 VDD_DEC pfet_05v0 L=0.5U W=6U AS=3.14P AD=3.14P
+ PS=11.14U PD=11.14U
* device instance $4404 r90 *1 55.025,425.915 pfet_05v0
M$4404 \$I543 \$I4623 \$5 VDD_DEC pfet_05v0 L=0.5U W=6U AS=3.14P AD=3.14P
+ PS=11.14U PD=11.14U
* device instance $4407 r90 *1 135.025,35.915 pfet_05v0
M$4407 \$I542 \$I4624 \$5 VDD_DEC pfet_05v0 L=0.5U W=6U AS=3.14P AD=3.14P
+ PS=11.14U PD=11.14U
* device instance $4410 r90 *1 55.025,113.915 pfet_05v0
M$4410 \$I541 \$I4625 \$5 VDD_DEC pfet_05v0 L=0.5U W=6U AS=3.14P AD=3.14P
+ PS=11.14U PD=11.14U
* device instance $4413 r90 *1 95.025,113.915 pfet_05v0
M$4413 \$I540 \$I4626 \$5 VDD_DEC pfet_05v0 L=0.5U W=6U AS=3.14P AD=3.14P
+ PS=11.14U PD=11.14U
* device instance $4416 r90 *1 135.025,113.915 pfet_05v0
M$4416 \$I539 \$I4627 \$5 VDD_DEC pfet_05v0 L=0.5U W=6U AS=3.14P AD=3.14P
+ PS=11.14U PD=11.14U
* device instance $4419 r90 *1 455.025,35.915 pfet_05v0
M$4419 \$I538 \$I4628 \$5 VDD_DEC pfet_05v0 L=0.5U W=6U AS=3.14P AD=3.14P
+ PS=11.14U PD=11.14U
* device instance $4422 r90 *1 95.025,35.915 pfet_05v0
M$4422 \$I537 \$I4629 \$5 VDD_DEC pfet_05v0 L=0.5U W=6U AS=3.14P AD=3.14P
+ PS=11.14U PD=11.14U
* device instance $4425 r90 *1 55.025,191.915 pfet_05v0
M$4425 \$I536 \$I4630 \$5 VDD_DEC pfet_05v0 L=0.5U W=6U AS=3.14P AD=3.14P
+ PS=11.14U PD=11.14U
* device instance $4428 r90 *1 95.025,191.915 pfet_05v0
M$4428 \$I535 \$I4631 \$5 VDD_DEC pfet_05v0 L=0.5U W=6U AS=3.14P AD=3.14P
+ PS=11.14U PD=11.14U
* device instance $4431 r90 *1 135.025,191.915 pfet_05v0
M$4431 \$I534 \$I4632 \$5 VDD_DEC pfet_05v0 L=0.5U W=6U AS=3.14P AD=3.14P
+ PS=11.14U PD=11.14U
* device instance $4434 r90 *1 495.025,35.915 pfet_05v0
M$4434 \$I533 \$I4633 \$5 VDD_DEC pfet_05v0 L=0.5U W=6U AS=3.14P AD=3.14P
+ PS=11.14U PD=11.14U
* device instance $4437 r90 *1 295.025,35.915 pfet_05v0
M$4437 \$I532 \$I4634 \$5 VDD_DEC pfet_05v0 L=0.5U W=6U AS=3.14P AD=3.14P
+ PS=11.14U PD=11.14U
* device instance $4440 r90 *1 415.025,581.915 pfet_05v0
M$4440 \$I531 \$I4635 \$5 VDD_DEC pfet_05v0 L=0.5U W=6U AS=3.14P AD=3.14P
+ PS=11.14U PD=11.14U
* device instance $4443 r90 *1 415.025,347.915 pfet_05v0
M$4443 \$I530 \$I4636 \$5 VDD_DEC pfet_05v0 L=0.5U W=6U AS=3.14P AD=3.14P
+ PS=11.14U PD=11.14U
* device instance $4446 r90 *1 215.025,191.915 pfet_05v0
M$4446 \$I529 \$I4637 \$5 VDD_DEC pfet_05v0 L=0.5U W=6U AS=3.14P AD=3.14P
+ PS=11.14U PD=11.14U
* device instance $4449 r90 *1 295.025,191.915 pfet_05v0
M$4449 \$I528 \$I4638 \$5 VDD_DEC pfet_05v0 L=0.5U W=6U AS=3.14P AD=3.14P
+ PS=11.14U PD=11.14U
* device instance $4452 r90 *1 295.025,113.915 pfet_05v0
M$4452 \$I527 \$I4639 \$5 VDD_DEC pfet_05v0 L=0.5U W=6U AS=3.14P AD=3.14P
+ PS=11.14U PD=11.14U
* device instance $4455 r90 *1 455.025,347.915 pfet_05v0
M$4455 \$I526 \$I4640 \$5 VDD_DEC pfet_05v0 L=0.5U W=6U AS=3.14P AD=3.14P
+ PS=11.14U PD=11.14U
* device instance $4458 r90 *1 375.025,581.915 pfet_05v0
M$4458 \$I525 \$I4641 \$5 VDD_DEC pfet_05v0 L=0.5U W=6U AS=3.14P AD=3.14P
+ PS=11.14U PD=11.14U
* device instance $4461 r90 *1 215.025,113.915 pfet_05v0
M$4461 \$I524 \$I4642 \$5 VDD_DEC pfet_05v0 L=0.5U W=6U AS=3.14P AD=3.14P
+ PS=11.14U PD=11.14U
* device instance $4464 r90 *1 255.025,113.915 pfet_05v0
M$4464 \$I523 \$I4643 \$5 VDD_DEC pfet_05v0 L=0.5U W=6U AS=3.14P AD=3.14P
+ PS=11.14U PD=11.14U
* device instance $4467 r90 *1 415.025,191.915 pfet_05v0
M$4467 \$I522 \$I4644 \$5 VDD_DEC pfet_05v0 L=0.5U W=6U AS=3.14P AD=3.14P
+ PS=11.14U PD=11.14U
* device instance $4470 r90 *1 455.025,191.915 pfet_05v0
M$4470 \$I521 \$I4645 \$5 VDD_DEC pfet_05v0 L=0.5U W=6U AS=3.14P AD=3.14P
+ PS=11.14U PD=11.14U
* device instance $4473 r90 *1 495.025,191.915 pfet_05v0
M$4473 \$I520 \$I4646 \$5 VDD_DEC pfet_05v0 L=0.5U W=6U AS=3.14P AD=3.14P
+ PS=11.14U PD=11.14U
* device instance $4476 r90 *1 415.025,113.915 pfet_05v0
M$4476 \$I519 \$I4647 \$5 VDD_DEC pfet_05v0 L=0.5U W=6U AS=3.14P AD=3.14P
+ PS=11.14U PD=11.14U
* device instance $4479 r90 *1 455.025,113.915 pfet_05v0
M$4479 \$I518 \$I4648 \$5 VDD_DEC pfet_05v0 L=0.5U W=6U AS=3.14P AD=3.14P
+ PS=11.14U PD=11.14U
* device instance $4482 r90 *1 495.025,113.915 pfet_05v0
M$4482 \$I517 \$I4649 \$5 VDD_DEC pfet_05v0 L=0.5U W=6U AS=3.14P AD=3.14P
+ PS=11.14U PD=11.14U
* device instance $4485 r90 *1 175.025,581.915 pfet_05v0
M$4485 \$I516 \$I4650 \$5 VDD_DEC pfet_05v0 L=0.5U W=6U AS=3.14P AD=3.14P
+ PS=11.14U PD=11.14U
* device instance $4488 r90 *1 415.025,35.915 pfet_05v0
M$4488 \$I515 \$I4651 \$5 VDD_DEC pfet_05v0 L=0.5U W=6U AS=3.14P AD=3.14P
+ PS=11.14U PD=11.14U
* device instance $4491 r90 *1 375.025,191.915 pfet_05v0
M$4491 \$I514 \$I4652 \$5 VDD_DEC pfet_05v0 L=0.5U W=6U AS=3.14P AD=3.14P
+ PS=11.14U PD=11.14U
* device instance $4494 r0 *1 58.565,39.94 nfet_05v0
M$4494 VSS \$6 \$I4525 VSS nfet_05v0 L=0.6U W=1U AS=0.73P AD=0.73P PS=3.46U
+ PD=3.46U
* device instance $4495 r0 *1 178.565,117.94 nfet_05v0
M$4495 VSS \$28 \$I4526 VSS nfet_05v0 L=0.6U W=1U AS=0.73P AD=0.73P PS=3.46U
+ PD=3.46U
* device instance $4496 r0 *1 178.565,39.94 nfet_05v0
M$4496 VSS \$9 \$I4527 VSS nfet_05v0 L=0.6U W=1U AS=0.73P AD=0.73P PS=3.46U
+ PD=3.46U
* device instance $4497 r0 *1 218.565,585.94 nfet_05v0
M$4497 VSS \$269 \$I4528 VSS nfet_05v0 L=0.6U W=1U AS=0.73P AD=0.73P PS=3.46U
+ PD=3.46U
* device instance $4498 r0 *1 298.565,351.94 nfet_05v0
M$4498 VSS \$165 \$I4529 VSS nfet_05v0 L=0.6U W=1U AS=0.73P AD=0.73P PS=3.46U
+ PD=3.46U
* device instance $4499 r0 *1 538.565,39.94 nfet_05v0
M$4499 VSS \$18 \$I4530 VSS nfet_05v0 L=0.6U W=1U AS=0.73P AD=0.73P PS=3.46U
+ PD=3.46U
* device instance $4500 r0 *1 178.565,351.94 nfet_05v0
M$4500 VSS \$156 \$I4531 VSS nfet_05v0 L=0.6U W=1U AS=0.73P AD=0.73P PS=3.46U
+ PD=3.46U
* device instance $4501 r0 *1 258.565,351.94 nfet_05v0
M$4501 VSS \$162 \$I4532 VSS nfet_05v0 L=0.6U W=1U AS=0.73P AD=0.73P PS=3.46U
+ PD=3.46U
* device instance $4502 r0 *1 658.565,39.94 nfet_05v0
M$4502 VSS \$21 \$I4533 VSS nfet_05v0 L=0.6U W=1U AS=0.73P AD=0.73P PS=3.46U
+ PD=3.46U
* device instance $4503 r0 *1 298.565,429.94 nfet_05v0
M$4503 VSS \$164 \$I4534 VSS nfet_05v0 L=0.6U W=1U AS=0.73P AD=0.73P PS=3.46U
+ PD=3.46U
* device instance $4504 r0 *1 178.565,195.94 nfet_05v0
M$4504 VSS \$89 \$I4535 VSS nfet_05v0 L=0.6U W=1U AS=0.73P AD=0.73P PS=3.46U
+ PD=3.46U
* device instance $4505 r0 *1 658.565,195.94 nfet_05v0
M$4505 VSS \$113 \$I4536 VSS nfet_05v0 L=0.6U W=1U AS=0.73P AD=0.73P PS=3.46U
+ PD=3.46U
* device instance $4506 r0 *1 58.565,585.94 nfet_05v0
M$4506 VSS \$265 \$I4537 VSS nfet_05v0 L=0.6U W=1U AS=0.73P AD=0.73P PS=3.46U
+ PD=3.46U
* device instance $4507 r0 *1 618.565,195.94 nfet_05v0
M$4507 VSS \$111 \$I4538 VSS nfet_05v0 L=0.6U W=1U AS=0.73P AD=0.73P PS=3.46U
+ PD=3.46U
* device instance $4508 r0 *1 578.565,195.94 nfet_05v0
M$4508 VSS \$109 \$I4539 VSS nfet_05v0 L=0.6U W=1U AS=0.73P AD=0.73P PS=3.46U
+ PD=3.46U
* device instance $4509 r0 *1 538.565,195.94 nfet_05v0
M$4509 VSS \$107 \$I4540 VSS nfet_05v0 L=0.6U W=1U AS=0.73P AD=0.73P PS=3.46U
+ PD=3.46U
* device instance $4510 r0 *1 378.565,117.94 nfet_05v0
M$4510 VSS \$33 \$I4541 VSS nfet_05v0 L=0.6U W=1U AS=0.73P AD=0.73P PS=3.46U
+ PD=3.46U
* device instance $4511 r0 *1 98.565,351.94 nfet_05v0
M$4511 VSS \$150 \$I4542 VSS nfet_05v0 L=0.6U W=1U AS=0.73P AD=0.73P PS=3.46U
+ PD=3.46U
* device instance $4512 r0 *1 378.565,39.94 nfet_05v0
M$4512 VSS \$14 \$I4543 VSS nfet_05v0 L=0.6U W=1U AS=0.73P AD=0.73P PS=3.46U
+ PD=3.46U
* device instance $4513 r0 *1 58.565,351.94 nfet_05v0
M$4513 VSS \$147 \$I4544 VSS nfet_05v0 L=0.6U W=1U AS=0.73P AD=0.73P PS=3.46U
+ PD=3.46U
* device instance $4514 r0 *1 578.565,39.94 nfet_05v0
M$4514 VSS \$19 \$I4545 VSS nfet_05v0 L=0.6U W=1U AS=0.73P AD=0.73P PS=3.46U
+ PD=3.46U
* device instance $4515 r0 *1 618.565,39.94 nfet_05v0
M$4515 VSS \$20 \$I4546 VSS nfet_05v0 L=0.6U W=1U AS=0.73P AD=0.73P PS=3.46U
+ PD=3.46U
* device instance $4516 r0 *1 538.565,117.94 nfet_05v0
M$4516 VSS \$37 \$I4547 VSS nfet_05v0 L=0.6U W=1U AS=0.73P AD=0.73P PS=3.46U
+ PD=3.46U
* device instance $4517 r0 *1 578.565,117.94 nfet_05v0
M$4517 VSS \$38 \$I4548 VSS nfet_05v0 L=0.6U W=1U AS=0.73P AD=0.73P PS=3.46U
+ PD=3.46U
* device instance $4518 r0 *1 258.565,429.94 nfet_05v0
M$4518 VSS \$161 \$I4549 VSS nfet_05v0 L=0.6U W=1U AS=0.73P AD=0.73P PS=3.46U
+ PD=3.46U
* device instance $4519 r0 *1 618.565,117.94 nfet_05v0
M$4519 VSS \$39 \$I4550 VSS nfet_05v0 L=0.6U W=1U AS=0.73P AD=0.73P PS=3.46U
+ PD=3.46U
* device instance $4520 r0 *1 138.565,429.94 nfet_05v0
M$4520 VSS \$152 \$I4551 VSS nfet_05v0 L=0.6U W=1U AS=0.73P AD=0.73P PS=3.46U
+ PD=3.46U
* device instance $4521 r0 *1 658.565,117.94 nfet_05v0
M$4521 VSS \$40 \$I4552 VSS nfet_05v0 L=0.6U W=1U AS=0.73P AD=0.73P PS=3.46U
+ PD=3.46U
* device instance $4522 r0 *1 218.565,351.94 nfet_05v0
M$4522 VSS \$159 \$I4553 VSS nfet_05v0 L=0.6U W=1U AS=0.73P AD=0.73P PS=3.46U
+ PD=3.46U
* device instance $4523 r0 *1 218.565,429.94 nfet_05v0
M$4523 VSS \$158 \$I4554 VSS nfet_05v0 L=0.6U W=1U AS=0.73P AD=0.73P PS=3.46U
+ PD=3.46U
* device instance $4524 r0 *1 338.565,585.94 nfet_05v0
M$4524 VSS \$272 \$I4555 VSS nfet_05v0 L=0.6U W=1U AS=0.73P AD=0.73P PS=3.46U
+ PD=3.46U
* device instance $4525 r0 *1 138.565,351.94 nfet_05v0
M$4525 VSS \$153 \$I4556 VSS nfet_05v0 L=0.6U W=1U AS=0.73P AD=0.73P PS=3.46U
+ PD=3.46U
* device instance $4526 r0 *1 338.565,429.94 nfet_05v0
M$4526 VSS \$167 \$I4557 VSS nfet_05v0 L=0.6U W=1U AS=0.73P AD=0.73P PS=3.46U
+ PD=3.46U
* device instance $4527 r0 *1 338.565,351.94 nfet_05v0
M$4527 VSS \$168 \$I4558 VSS nfet_05v0 L=0.6U W=1U AS=0.73P AD=0.73P PS=3.46U
+ PD=3.46U
* device instance $4528 r0 *1 338.565,273.94 nfet_05v0
M$4528 VSS \$96 \$I4559 VSS nfet_05v0 L=0.6U W=1U AS=0.73P AD=0.73P PS=3.46U
+ PD=3.46U
* device instance $4529 r0 *1 338.565,195.94 nfet_05v0
M$4529 VSS \$97 \$I4560 VSS nfet_05v0 L=0.6U W=1U AS=0.73P AD=0.73P PS=3.46U
+ PD=3.46U
* device instance $4530 r0 *1 338.565,117.94 nfet_05v0
M$4530 VSS \$32 \$I4561 VSS nfet_05v0 L=0.6U W=1U AS=0.73P AD=0.73P PS=3.46U
+ PD=3.46U
* device instance $4531 r0 *1 338.565,39.94 nfet_05v0
M$4531 VSS \$13 \$I4562 VSS nfet_05v0 L=0.6U W=1U AS=0.73P AD=0.73P PS=3.46U
+ PD=3.46U
* device instance $4532 r0 *1 378.565,507.94 nfet_05v0
M$4532 VSS \$169 \$I4563 VSS nfet_05v0 L=0.6U W=1U AS=0.73P AD=0.73P PS=3.46U
+ PD=3.46U
* device instance $4533 r0 *1 418.565,507.94 nfet_05v0
M$4533 VSS \$172 \$I4564 VSS nfet_05v0 L=0.6U W=1U AS=0.73P AD=0.73P PS=3.46U
+ PD=3.46U
* device instance $4534 r0 *1 458.565,507.94 nfet_05v0
M$4534 VSS \$175 \$I4565 VSS nfet_05v0 L=0.6U W=1U AS=0.73P AD=0.73P PS=3.46U
+ PD=3.46U
* device instance $4535 r0 *1 498.565,507.94 nfet_05v0
M$4535 VSS \$178 \$I4566 VSS nfet_05v0 L=0.6U W=1U AS=0.73P AD=0.73P PS=3.46U
+ PD=3.46U
* device instance $4536 r0 *1 618.565,507.94 nfet_05v0
M$4536 VSS \$187 \$I4567 VSS nfet_05v0 L=0.6U W=1U AS=0.73P AD=0.73P PS=3.46U
+ PD=3.46U
* device instance $4537 r0 *1 658.565,507.94 nfet_05v0
M$4537 VSS \$190 \$I4568 VSS nfet_05v0 L=0.6U W=1U AS=0.73P AD=0.73P PS=3.46U
+ PD=3.46U
* device instance $4538 r0 *1 538.565,507.94 nfet_05v0
M$4538 VSS \$181 \$I4569 VSS nfet_05v0 L=0.6U W=1U AS=0.73P AD=0.73P PS=3.46U
+ PD=3.46U
* device instance $4539 r0 *1 578.565,507.94 nfet_05v0
M$4539 VSS \$184 \$I4570 VSS nfet_05v0 L=0.6U W=1U AS=0.73P AD=0.73P PS=3.46U
+ PD=3.46U
* device instance $4540 r0 *1 178.565,507.94 nfet_05v0
M$4540 VSS \$154 \$I4571 VSS nfet_05v0 L=0.6U W=1U AS=0.73P AD=0.73P PS=3.46U
+ PD=3.46U
* device instance $4541 r0 *1 138.565,585.94 nfet_05v0
M$4541 VSS \$267 \$I4572 VSS nfet_05v0 L=0.6U W=1U AS=0.73P AD=0.73P PS=3.46U
+ PD=3.46U
* device instance $4542 r0 *1 58.565,507.94 nfet_05v0
M$4542 VSS \$145 \$I4573 VSS nfet_05v0 L=0.6U W=1U AS=0.73P AD=0.73P PS=3.46U
+ PD=3.46U
* device instance $4543 r0 *1 98.565,507.94 nfet_05v0
M$4543 VSS \$148 \$I4574 VSS nfet_05v0 L=0.6U W=1U AS=0.73P AD=0.73P PS=3.46U
+ PD=3.46U
* device instance $4544 r0 *1 138.565,507.94 nfet_05v0
M$4544 VSS \$151 \$I4575 VSS nfet_05v0 L=0.6U W=1U AS=0.73P AD=0.73P PS=3.46U
+ PD=3.46U
* device instance $4545 r0 *1 218.565,507.94 nfet_05v0
M$4545 VSS \$157 \$I4576 VSS nfet_05v0 L=0.6U W=1U AS=0.73P AD=0.73P PS=3.46U
+ PD=3.46U
* device instance $4546 r0 *1 258.565,507.94 nfet_05v0
M$4546 VSS \$160 \$I4577 VSS nfet_05v0 L=0.6U W=1U AS=0.73P AD=0.73P PS=3.46U
+ PD=3.46U
* device instance $4547 r0 *1 298.565,507.94 nfet_05v0
M$4547 VSS \$163 \$I4578 VSS nfet_05v0 L=0.6U W=1U AS=0.73P AD=0.73P PS=3.46U
+ PD=3.46U
* device instance $4548 r0 *1 298.565,585.94 nfet_05v0
M$4548 VSS \$271 \$I4579 VSS nfet_05v0 L=0.6U W=1U AS=0.73P AD=0.73P PS=3.46U
+ PD=3.46U
* device instance $4549 r0 *1 258.565,273.94 nfet_05v0
M$4549 VSS \$92 \$I4580 VSS nfet_05v0 L=0.6U W=1U AS=0.73P AD=0.73P PS=3.46U
+ PD=3.46U
* device instance $4550 r0 *1 298.565,273.94 nfet_05v0
M$4550 VSS \$94 \$I4581 VSS nfet_05v0 L=0.6U W=1U AS=0.73P AD=0.73P PS=3.46U
+ PD=3.46U
* device instance $4551 r0 *1 138.565,273.94 nfet_05v0
M$4551 VSS \$86 \$I4582 VSS nfet_05v0 L=0.6U W=1U AS=0.73P AD=0.73P PS=3.46U
+ PD=3.46U
* device instance $4552 r0 *1 98.565,273.94 nfet_05v0
M$4552 VSS \$84 \$I4583 VSS nfet_05v0 L=0.6U W=1U AS=0.73P AD=0.73P PS=3.46U
+ PD=3.46U
* device instance $4553 r0 *1 258.565,585.94 nfet_05v0
M$4553 VSS \$270 \$I4584 VSS nfet_05v0 L=0.6U W=1U AS=0.73P AD=0.73P PS=3.46U
+ PD=3.46U
* device instance $4554 r0 *1 58.565,273.94 nfet_05v0
M$4554 VSS \$82 \$I4585 VSS nfet_05v0 L=0.6U W=1U AS=0.73P AD=0.73P PS=3.46U
+ PD=3.46U
* device instance $4555 r0 *1 178.565,429.94 nfet_05v0
M$4555 VSS \$155 \$I4586 VSS nfet_05v0 L=0.6U W=1U AS=0.73P AD=0.73P PS=3.46U
+ PD=3.46U
* device instance $4556 r0 *1 178.565,273.94 nfet_05v0
M$4556 VSS \$88 \$I4587 VSS nfet_05v0 L=0.6U W=1U AS=0.73P AD=0.73P PS=3.46U
+ PD=3.46U
* device instance $4557 r0 *1 218.565,273.94 nfet_05v0
M$4557 VSS \$90 \$I4588 VSS nfet_05v0 L=0.6U W=1U AS=0.73P AD=0.73P PS=3.46U
+ PD=3.46U
* device instance $4558 r0 *1 258.565,195.94 nfet_05v0
M$4558 VSS \$93 \$I4589 VSS nfet_05v0 L=0.6U W=1U AS=0.73P AD=0.73P PS=3.46U
+ PD=3.46U
* device instance $4559 r0 *1 458.565,585.94 nfet_05v0
M$4559 VSS \$275 \$I4590 VSS nfet_05v0 L=0.6U W=1U AS=0.73P AD=0.73P PS=3.46U
+ PD=3.46U
* device instance $4560 r0 *1 498.565,585.94 nfet_05v0
M$4560 VSS \$276 \$I4591 VSS nfet_05v0 L=0.6U W=1U AS=0.73P AD=0.73P PS=3.46U
+ PD=3.46U
* device instance $4561 r0 *1 378.565,351.94 nfet_05v0
M$4561 VSS \$171 \$I4592 VSS nfet_05v0 L=0.6U W=1U AS=0.73P AD=0.73P PS=3.46U
+ PD=3.46U
* device instance $4562 r0 *1 378.565,429.94 nfet_05v0
M$4562 VSS \$170 \$I4593 VSS nfet_05v0 L=0.6U W=1U AS=0.73P AD=0.73P PS=3.46U
+ PD=3.46U
* device instance $4563 r0 *1 498.565,429.94 nfet_05v0
M$4563 VSS \$179 \$I4594 VSS nfet_05v0 L=0.6U W=1U AS=0.73P AD=0.73P PS=3.46U
+ PD=3.46U
* device instance $4564 r0 *1 258.565,39.94 nfet_05v0
M$4564 VSS \$11 \$I4595 VSS nfet_05v0 L=0.6U W=1U AS=0.73P AD=0.73P PS=3.46U
+ PD=3.46U
* device instance $4565 r0 *1 498.565,351.94 nfet_05v0
M$4565 VSS \$180 \$I4596 VSS nfet_05v0 L=0.6U W=1U AS=0.73P AD=0.73P PS=3.46U
+ PD=3.46U
* device instance $4566 r0 *1 458.565,429.94 nfet_05v0
M$4566 VSS \$176 \$I4597 VSS nfet_05v0 L=0.6U W=1U AS=0.73P AD=0.73P PS=3.46U
+ PD=3.46U
* device instance $4567 r0 *1 418.565,429.94 nfet_05v0
M$4567 VSS \$173 \$I4598 VSS nfet_05v0 L=0.6U W=1U AS=0.73P AD=0.73P PS=3.46U
+ PD=3.46U
* device instance $4568 r0 *1 618.565,429.94 nfet_05v0
M$4568 VSS \$188 \$I4599 VSS nfet_05v0 L=0.6U W=1U AS=0.73P AD=0.73P PS=3.46U
+ PD=3.46U
* device instance $4569 r0 *1 578.565,429.94 nfet_05v0
M$4569 VSS \$185 \$I4600 VSS nfet_05v0 L=0.6U W=1U AS=0.73P AD=0.73P PS=3.46U
+ PD=3.46U
* device instance $4570 r0 *1 538.565,429.94 nfet_05v0
M$4570 VSS \$182 \$I4601 VSS nfet_05v0 L=0.6U W=1U AS=0.73P AD=0.73P PS=3.46U
+ PD=3.46U
* device instance $4571 r0 *1 538.565,585.94 nfet_05v0
M$4571 VSS \$277 \$I4602 VSS nfet_05v0 L=0.6U W=1U AS=0.73P AD=0.73P PS=3.46U
+ PD=3.46U
* device instance $4572 r0 *1 578.565,585.94 nfet_05v0
M$4572 VSS \$278 \$I4603 VSS nfet_05v0 L=0.6U W=1U AS=0.73P AD=0.73P PS=3.46U
+ PD=3.46U
* device instance $4573 r0 *1 338.565,507.94 nfet_05v0
M$4573 VSS \$166 \$I4604 VSS nfet_05v0 L=0.6U W=1U AS=0.73P AD=0.73P PS=3.46U
+ PD=3.46U
* device instance $4574 r0 *1 618.565,585.94 nfet_05v0
M$4574 VSS \$279 \$I4605 VSS nfet_05v0 L=0.6U W=1U AS=0.73P AD=0.73P PS=3.46U
+ PD=3.46U
* device instance $4575 r0 *1 218.565,39.94 nfet_05v0
M$4575 VSS \$10 \$I4606 VSS nfet_05v0 L=0.6U W=1U AS=0.73P AD=0.73P PS=3.46U
+ PD=3.46U
* device instance $4576 r0 *1 578.565,351.94 nfet_05v0
M$4576 VSS \$186 \$I4607 VSS nfet_05v0 L=0.6U W=1U AS=0.73P AD=0.73P PS=3.46U
+ PD=3.46U
* device instance $4577 r0 *1 658.565,429.94 nfet_05v0
M$4577 VSS \$191 \$I4608 VSS nfet_05v0 L=0.6U W=1U AS=0.73P AD=0.73P PS=3.46U
+ PD=3.46U
* device instance $4578 r0 *1 578.565,273.94 nfet_05v0
M$4578 VSS \$108 \$I4609 VSS nfet_05v0 L=0.6U W=1U AS=0.73P AD=0.73P PS=3.46U
+ PD=3.46U
* device instance $4579 r0 *1 618.565,273.94 nfet_05v0
M$4579 VSS \$110 \$I4610 VSS nfet_05v0 L=0.6U W=1U AS=0.73P AD=0.73P PS=3.46U
+ PD=3.46U
* device instance $4580 r0 *1 658.565,273.94 nfet_05v0
M$4580 VSS \$112 \$I4611 VSS nfet_05v0 L=0.6U W=1U AS=0.73P AD=0.73P PS=3.46U
+ PD=3.46U
* device instance $4581 r0 *1 538.565,273.94 nfet_05v0
M$4581 VSS \$106 \$I4612 VSS nfet_05v0 L=0.6U W=1U AS=0.73P AD=0.73P PS=3.46U
+ PD=3.46U
* device instance $4582 r0 *1 498.565,273.94 nfet_05v0
M$4582 VSS \$104 \$I4613 VSS nfet_05v0 L=0.6U W=1U AS=0.73P AD=0.73P PS=3.46U
+ PD=3.46U
* device instance $4583 r0 *1 658.565,351.94 nfet_05v0
M$4583 VSS \$192 \$I4614 VSS nfet_05v0 L=0.6U W=1U AS=0.73P AD=0.73P PS=3.46U
+ PD=3.46U
* device instance $4584 r0 *1 458.565,273.94 nfet_05v0
M$4584 VSS \$102 \$I4615 VSS nfet_05v0 L=0.6U W=1U AS=0.73P AD=0.73P PS=3.46U
+ PD=3.46U
* device instance $4585 r0 *1 378.565,273.94 nfet_05v0
M$4585 VSS \$98 \$I4616 VSS nfet_05v0 L=0.6U W=1U AS=0.73P AD=0.73P PS=3.46U
+ PD=3.46U
* device instance $4586 r0 *1 618.565,351.94 nfet_05v0
M$4586 VSS \$189 \$I4617 VSS nfet_05v0 L=0.6U W=1U AS=0.73P AD=0.73P PS=3.46U
+ PD=3.46U
* device instance $4587 r0 *1 418.565,273.94 nfet_05v0
M$4587 VSS \$100 \$I4618 VSS nfet_05v0 L=0.6U W=1U AS=0.73P AD=0.73P PS=3.46U
+ PD=3.46U
* device instance $4588 r0 *1 538.565,351.94 nfet_05v0
M$4588 VSS \$183 \$I4619 VSS nfet_05v0 L=0.6U W=1U AS=0.73P AD=0.73P PS=3.46U
+ PD=3.46U
* device instance $4589 r0 *1 658.565,585.94 nfet_05v0
M$4589 VSS \$280 \$I4620 VSS nfet_05v0 L=0.6U W=1U AS=0.73P AD=0.73P PS=3.46U
+ PD=3.46U
* device instance $4590 r0 *1 98.565,585.94 nfet_05v0
M$4590 VSS \$266 \$I4621 VSS nfet_05v0 L=0.6U W=1U AS=0.73P AD=0.73P PS=3.46U
+ PD=3.46U
* device instance $4591 r0 *1 98.565,429.94 nfet_05v0
M$4591 VSS \$149 \$I4622 VSS nfet_05v0 L=0.6U W=1U AS=0.73P AD=0.73P PS=3.46U
+ PD=3.46U
* device instance $4592 r0 *1 58.565,429.94 nfet_05v0
M$4592 VSS \$146 \$I4623 VSS nfet_05v0 L=0.6U W=1U AS=0.73P AD=0.73P PS=3.46U
+ PD=3.46U
* device instance $4593 r0 *1 138.565,39.94 nfet_05v0
M$4593 VSS \$8 \$I4624 VSS nfet_05v0 L=0.6U W=1U AS=0.73P AD=0.73P PS=3.46U
+ PD=3.46U
* device instance $4594 r0 *1 58.565,117.94 nfet_05v0
M$4594 VSS \$25 \$I4625 VSS nfet_05v0 L=0.6U W=1U AS=0.73P AD=0.73P PS=3.46U
+ PD=3.46U
* device instance $4595 r0 *1 98.565,117.94 nfet_05v0
M$4595 VSS \$26 \$I4626 VSS nfet_05v0 L=0.6U W=1U AS=0.73P AD=0.73P PS=3.46U
+ PD=3.46U
* device instance $4596 r0 *1 138.565,117.94 nfet_05v0
M$4596 VSS \$27 \$I4627 VSS nfet_05v0 L=0.6U W=1U AS=0.73P AD=0.73P PS=3.46U
+ PD=3.46U
* device instance $4597 r0 *1 458.565,39.94 nfet_05v0
M$4597 VSS \$16 \$I4628 VSS nfet_05v0 L=0.6U W=1U AS=0.73P AD=0.73P PS=3.46U
+ PD=3.46U
* device instance $4598 r0 *1 98.565,39.94 nfet_05v0
M$4598 VSS \$7 \$I4629 VSS nfet_05v0 L=0.6U W=1U AS=0.73P AD=0.73P PS=3.46U
+ PD=3.46U
* device instance $4599 r0 *1 58.565,195.94 nfet_05v0
M$4599 VSS \$83 \$I4630 VSS nfet_05v0 L=0.6U W=1U AS=0.73P AD=0.73P PS=3.46U
+ PD=3.46U
* device instance $4600 r0 *1 98.565,195.94 nfet_05v0
M$4600 VSS \$85 \$I4631 VSS nfet_05v0 L=0.6U W=1U AS=0.73P AD=0.73P PS=3.46U
+ PD=3.46U
* device instance $4601 r0 *1 138.565,195.94 nfet_05v0
M$4601 VSS \$87 \$I4632 VSS nfet_05v0 L=0.6U W=1U AS=0.73P AD=0.73P PS=3.46U
+ PD=3.46U
* device instance $4602 r0 *1 498.565,39.94 nfet_05v0
M$4602 VSS \$17 \$I4633 VSS nfet_05v0 L=0.6U W=1U AS=0.73P AD=0.73P PS=3.46U
+ PD=3.46U
* device instance $4603 r0 *1 298.565,39.94 nfet_05v0
M$4603 VSS \$12 \$I4634 VSS nfet_05v0 L=0.6U W=1U AS=0.73P AD=0.73P PS=3.46U
+ PD=3.46U
* device instance $4604 r0 *1 418.565,585.94 nfet_05v0
M$4604 VSS \$274 \$I4635 VSS nfet_05v0 L=0.6U W=1U AS=0.73P AD=0.73P PS=3.46U
+ PD=3.46U
* device instance $4605 r0 *1 418.565,351.94 nfet_05v0
M$4605 VSS \$174 \$I4636 VSS nfet_05v0 L=0.6U W=1U AS=0.73P AD=0.73P PS=3.46U
+ PD=3.46U
* device instance $4606 r0 *1 218.565,195.94 nfet_05v0
M$4606 VSS \$91 \$I4637 VSS nfet_05v0 L=0.6U W=1U AS=0.73P AD=0.73P PS=3.46U
+ PD=3.46U
* device instance $4607 r0 *1 298.565,195.94 nfet_05v0
M$4607 VSS \$95 \$I4638 VSS nfet_05v0 L=0.6U W=1U AS=0.73P AD=0.73P PS=3.46U
+ PD=3.46U
* device instance $4608 r0 *1 298.565,117.94 nfet_05v0
M$4608 VSS \$31 \$I4639 VSS nfet_05v0 L=0.6U W=1U AS=0.73P AD=0.73P PS=3.46U
+ PD=3.46U
* device instance $4609 r0 *1 458.565,351.94 nfet_05v0
M$4609 VSS \$177 \$I4640 VSS nfet_05v0 L=0.6U W=1U AS=0.73P AD=0.73P PS=3.46U
+ PD=3.46U
* device instance $4610 r0 *1 378.565,585.94 nfet_05v0
M$4610 VSS \$273 \$I4641 VSS nfet_05v0 L=0.6U W=1U AS=0.73P AD=0.73P PS=3.46U
+ PD=3.46U
* device instance $4611 r0 *1 218.565,117.94 nfet_05v0
M$4611 VSS \$29 \$I4642 VSS nfet_05v0 L=0.6U W=1U AS=0.73P AD=0.73P PS=3.46U
+ PD=3.46U
* device instance $4612 r0 *1 258.565,117.94 nfet_05v0
M$4612 VSS \$30 \$I4643 VSS nfet_05v0 L=0.6U W=1U AS=0.73P AD=0.73P PS=3.46U
+ PD=3.46U
* device instance $4613 r0 *1 418.565,195.94 nfet_05v0
M$4613 VSS \$101 \$I4644 VSS nfet_05v0 L=0.6U W=1U AS=0.73P AD=0.73P PS=3.46U
+ PD=3.46U
* device instance $4614 r0 *1 458.565,195.94 nfet_05v0
M$4614 VSS \$103 \$I4645 VSS nfet_05v0 L=0.6U W=1U AS=0.73P AD=0.73P PS=3.46U
+ PD=3.46U
* device instance $4615 r0 *1 498.565,195.94 nfet_05v0
M$4615 VSS \$105 \$I4646 VSS nfet_05v0 L=0.6U W=1U AS=0.73P AD=0.73P PS=3.46U
+ PD=3.46U
* device instance $4616 r0 *1 418.565,117.94 nfet_05v0
M$4616 VSS \$34 \$I4647 VSS nfet_05v0 L=0.6U W=1U AS=0.73P AD=0.73P PS=3.46U
+ PD=3.46U
* device instance $4617 r0 *1 458.565,117.94 nfet_05v0
M$4617 VSS \$35 \$I4648 VSS nfet_05v0 L=0.6U W=1U AS=0.73P AD=0.73P PS=3.46U
+ PD=3.46U
* device instance $4618 r0 *1 498.565,117.94 nfet_05v0
M$4618 VSS \$36 \$I4649 VSS nfet_05v0 L=0.6U W=1U AS=0.73P AD=0.73P PS=3.46U
+ PD=3.46U
* device instance $4619 r0 *1 178.565,585.94 nfet_05v0
M$4619 VSS \$268 \$I4650 VSS nfet_05v0 L=0.6U W=1U AS=0.73P AD=0.73P PS=3.46U
+ PD=3.46U
* device instance $4620 r0 *1 418.565,39.94 nfet_05v0
M$4620 VSS \$15 \$I4651 VSS nfet_05v0 L=0.6U W=1U AS=0.73P AD=0.73P PS=3.46U
+ PD=3.46U
* device instance $4621 r0 *1 378.565,195.94 nfet_05v0
M$4621 VSS \$99 \$I4652 VSS nfet_05v0 L=0.6U W=1U AS=0.73P AD=0.73P PS=3.46U
+ PD=3.46U
* device instance $4622 r0 *1 48.825,34.46 diode_nw2ps_06v0
D$4622 VSS \$6 diode_nw2ps_06v0 A=0.864P P=6.24U
* device instance $4623 r0 *1 168.825,112.46 diode_nw2ps_06v0
D$4623 VSS \$28 diode_nw2ps_06v0 A=0.864P P=6.24U
* device instance $4624 r0 *1 168.825,34.46 diode_nw2ps_06v0
D$4624 VSS \$9 diode_nw2ps_06v0 A=0.864P P=6.24U
* device instance $4625 r0 *1 208.825,580.46 diode_nw2ps_06v0
D$4625 VSS \$269 diode_nw2ps_06v0 A=0.864P P=6.24U
* device instance $4626 r0 *1 288.825,346.46 diode_nw2ps_06v0
D$4626 VSS \$165 diode_nw2ps_06v0 A=0.864P P=6.24U
* device instance $4627 r0 *1 528.825,34.46 diode_nw2ps_06v0
D$4627 VSS \$18 diode_nw2ps_06v0 A=0.864P P=6.24U
* device instance $4628 r0 *1 168.825,346.46 diode_nw2ps_06v0
D$4628 VSS \$156 diode_nw2ps_06v0 A=0.864P P=6.24U
* device instance $4629 r0 *1 248.825,346.46 diode_nw2ps_06v0
D$4629 VSS \$162 diode_nw2ps_06v0 A=0.864P P=6.24U
* device instance $4630 r0 *1 648.825,34.46 diode_nw2ps_06v0
D$4630 VSS \$21 diode_nw2ps_06v0 A=0.864P P=6.24U
* device instance $4631 r0 *1 288.825,424.46 diode_nw2ps_06v0
D$4631 VSS \$164 diode_nw2ps_06v0 A=0.864P P=6.24U
* device instance $4632 r0 *1 168.825,190.46 diode_nw2ps_06v0
D$4632 VSS \$89 diode_nw2ps_06v0 A=0.864P P=6.24U
* device instance $4633 r0 *1 648.825,190.46 diode_nw2ps_06v0
D$4633 VSS \$113 diode_nw2ps_06v0 A=0.864P P=6.24U
* device instance $4634 r0 *1 48.825,580.46 diode_nw2ps_06v0
D$4634 VSS \$265 diode_nw2ps_06v0 A=0.864P P=6.24U
* device instance $4635 r0 *1 608.825,190.46 diode_nw2ps_06v0
D$4635 VSS \$111 diode_nw2ps_06v0 A=0.864P P=6.24U
* device instance $4636 r0 *1 568.825,190.46 diode_nw2ps_06v0
D$4636 VSS \$109 diode_nw2ps_06v0 A=0.864P P=6.24U
* device instance $4637 r0 *1 528.825,190.46 diode_nw2ps_06v0
D$4637 VSS \$107 diode_nw2ps_06v0 A=0.864P P=6.24U
* device instance $4638 r0 *1 368.825,112.46 diode_nw2ps_06v0
D$4638 VSS \$33 diode_nw2ps_06v0 A=0.864P P=6.24U
* device instance $4639 r0 *1 88.825,346.46 diode_nw2ps_06v0
D$4639 VSS \$150 diode_nw2ps_06v0 A=0.864P P=6.24U
* device instance $4640 r0 *1 368.825,34.46 diode_nw2ps_06v0
D$4640 VSS \$14 diode_nw2ps_06v0 A=0.864P P=6.24U
* device instance $4641 r0 *1 48.825,346.46 diode_nw2ps_06v0
D$4641 VSS \$147 diode_nw2ps_06v0 A=0.864P P=6.24U
* device instance $4642 r0 *1 568.825,34.46 diode_nw2ps_06v0
D$4642 VSS \$19 diode_nw2ps_06v0 A=0.864P P=6.24U
* device instance $4643 r0 *1 608.825,34.46 diode_nw2ps_06v0
D$4643 VSS \$20 diode_nw2ps_06v0 A=0.864P P=6.24U
* device instance $4644 r0 *1 528.825,112.46 diode_nw2ps_06v0
D$4644 VSS \$37 diode_nw2ps_06v0 A=0.864P P=6.24U
* device instance $4645 r0 *1 568.825,112.46 diode_nw2ps_06v0
D$4645 VSS \$38 diode_nw2ps_06v0 A=0.864P P=6.24U
* device instance $4646 r0 *1 248.825,424.46 diode_nw2ps_06v0
D$4646 VSS \$161 diode_nw2ps_06v0 A=0.864P P=6.24U
* device instance $4647 r0 *1 608.825,112.46 diode_nw2ps_06v0
D$4647 VSS \$39 diode_nw2ps_06v0 A=0.864P P=6.24U
* device instance $4648 r0 *1 128.825,424.46 diode_nw2ps_06v0
D$4648 VSS \$152 diode_nw2ps_06v0 A=0.864P P=6.24U
* device instance $4649 r0 *1 648.825,112.46 diode_nw2ps_06v0
D$4649 VSS \$40 diode_nw2ps_06v0 A=0.864P P=6.24U
* device instance $4650 r0 *1 208.825,346.46 diode_nw2ps_06v0
D$4650 VSS \$159 diode_nw2ps_06v0 A=0.864P P=6.24U
* device instance $4651 r0 *1 208.825,424.46 diode_nw2ps_06v0
D$4651 VSS \$158 diode_nw2ps_06v0 A=0.864P P=6.24U
* device instance $4652 r0 *1 328.825,580.46 diode_nw2ps_06v0
D$4652 VSS \$272 diode_nw2ps_06v0 A=0.864P P=6.24U
* device instance $4653 r0 *1 128.825,346.46 diode_nw2ps_06v0
D$4653 VSS \$153 diode_nw2ps_06v0 A=0.864P P=6.24U
* device instance $4654 r0 *1 328.825,424.46 diode_nw2ps_06v0
D$4654 VSS \$167 diode_nw2ps_06v0 A=0.864P P=6.24U
* device instance $4655 r0 *1 328.825,346.46 diode_nw2ps_06v0
D$4655 VSS \$168 diode_nw2ps_06v0 A=0.864P P=6.24U
* device instance $4656 r0 *1 328.825,268.46 diode_nw2ps_06v0
D$4656 VSS \$96 diode_nw2ps_06v0 A=0.864P P=6.24U
* device instance $4657 r0 *1 328.825,190.46 diode_nw2ps_06v0
D$4657 VSS \$97 diode_nw2ps_06v0 A=0.864P P=6.24U
* device instance $4658 r0 *1 328.825,112.46 diode_nw2ps_06v0
D$4658 VSS \$32 diode_nw2ps_06v0 A=0.864P P=6.24U
* device instance $4659 r0 *1 328.825,34.46 diode_nw2ps_06v0
D$4659 VSS \$13 diode_nw2ps_06v0 A=0.864P P=6.24U
* device instance $4660 r0 *1 368.825,502.46 diode_nw2ps_06v0
D$4660 VSS \$169 diode_nw2ps_06v0 A=0.864P P=6.24U
* device instance $4661 r0 *1 408.825,502.46 diode_nw2ps_06v0
D$4661 VSS \$172 diode_nw2ps_06v0 A=0.864P P=6.24U
* device instance $4662 r0 *1 448.825,502.46 diode_nw2ps_06v0
D$4662 VSS \$175 diode_nw2ps_06v0 A=0.864P P=6.24U
* device instance $4663 r0 *1 488.825,502.46 diode_nw2ps_06v0
D$4663 VSS \$178 diode_nw2ps_06v0 A=0.864P P=6.24U
* device instance $4664 r0 *1 608.825,502.46 diode_nw2ps_06v0
D$4664 VSS \$187 diode_nw2ps_06v0 A=0.864P P=6.24U
* device instance $4665 r0 *1 648.825,502.46 diode_nw2ps_06v0
D$4665 VSS \$190 diode_nw2ps_06v0 A=0.864P P=6.24U
* device instance $4666 r0 *1 528.825,502.46 diode_nw2ps_06v0
D$4666 VSS \$181 diode_nw2ps_06v0 A=0.864P P=6.24U
* device instance $4667 r0 *1 568.825,502.46 diode_nw2ps_06v0
D$4667 VSS \$184 diode_nw2ps_06v0 A=0.864P P=6.24U
* device instance $4668 r0 *1 168.825,502.46 diode_nw2ps_06v0
D$4668 VSS \$154 diode_nw2ps_06v0 A=0.864P P=6.24U
* device instance $4669 r0 *1 128.825,580.46 diode_nw2ps_06v0
D$4669 VSS \$267 diode_nw2ps_06v0 A=0.864P P=6.24U
* device instance $4670 r0 *1 48.825,502.46 diode_nw2ps_06v0
D$4670 VSS \$145 diode_nw2ps_06v0 A=0.864P P=6.24U
* device instance $4671 r0 *1 88.825,502.46 diode_nw2ps_06v0
D$4671 VSS \$148 diode_nw2ps_06v0 A=0.864P P=6.24U
* device instance $4672 r0 *1 128.825,502.46 diode_nw2ps_06v0
D$4672 VSS \$151 diode_nw2ps_06v0 A=0.864P P=6.24U
* device instance $4673 r0 *1 208.825,502.46 diode_nw2ps_06v0
D$4673 VSS \$157 diode_nw2ps_06v0 A=0.864P P=6.24U
* device instance $4674 r0 *1 248.825,502.46 diode_nw2ps_06v0
D$4674 VSS \$160 diode_nw2ps_06v0 A=0.864P P=6.24U
* device instance $4675 r0 *1 288.825,502.46 diode_nw2ps_06v0
D$4675 VSS \$163 diode_nw2ps_06v0 A=0.864P P=6.24U
* device instance $4676 r0 *1 288.825,580.46 diode_nw2ps_06v0
D$4676 VSS \$271 diode_nw2ps_06v0 A=0.864P P=6.24U
* device instance $4677 r0 *1 248.825,268.46 diode_nw2ps_06v0
D$4677 VSS \$92 diode_nw2ps_06v0 A=0.864P P=6.24U
* device instance $4678 r0 *1 288.825,268.46 diode_nw2ps_06v0
D$4678 VSS \$94 diode_nw2ps_06v0 A=0.864P P=6.24U
* device instance $4679 r0 *1 128.825,268.46 diode_nw2ps_06v0
D$4679 VSS \$86 diode_nw2ps_06v0 A=0.864P P=6.24U
* device instance $4680 r0 *1 88.825,268.46 diode_nw2ps_06v0
D$4680 VSS \$84 diode_nw2ps_06v0 A=0.864P P=6.24U
* device instance $4681 r0 *1 248.825,580.46 diode_nw2ps_06v0
D$4681 VSS \$270 diode_nw2ps_06v0 A=0.864P P=6.24U
* device instance $4682 r0 *1 48.825,268.46 diode_nw2ps_06v0
D$4682 VSS \$82 diode_nw2ps_06v0 A=0.864P P=6.24U
* device instance $4683 r0 *1 168.825,424.46 diode_nw2ps_06v0
D$4683 VSS \$155 diode_nw2ps_06v0 A=0.864P P=6.24U
* device instance $4684 r0 *1 168.825,268.46 diode_nw2ps_06v0
D$4684 VSS \$88 diode_nw2ps_06v0 A=0.864P P=6.24U
* device instance $4685 r0 *1 208.825,268.46 diode_nw2ps_06v0
D$4685 VSS \$90 diode_nw2ps_06v0 A=0.864P P=6.24U
* device instance $4686 r0 *1 248.825,190.46 diode_nw2ps_06v0
D$4686 VSS \$93 diode_nw2ps_06v0 A=0.864P P=6.24U
* device instance $4687 r0 *1 448.825,580.46 diode_nw2ps_06v0
D$4687 VSS \$275 diode_nw2ps_06v0 A=0.864P P=6.24U
* device instance $4688 r0 *1 488.825,580.46 diode_nw2ps_06v0
D$4688 VSS \$276 diode_nw2ps_06v0 A=0.864P P=6.24U
* device instance $4689 r0 *1 368.825,346.46 diode_nw2ps_06v0
D$4689 VSS \$171 diode_nw2ps_06v0 A=0.864P P=6.24U
* device instance $4690 r0 *1 368.825,424.46 diode_nw2ps_06v0
D$4690 VSS \$170 diode_nw2ps_06v0 A=0.864P P=6.24U
* device instance $4691 r0 *1 488.825,424.46 diode_nw2ps_06v0
D$4691 VSS \$179 diode_nw2ps_06v0 A=0.864P P=6.24U
* device instance $4692 r0 *1 248.825,34.46 diode_nw2ps_06v0
D$4692 VSS \$11 diode_nw2ps_06v0 A=0.864P P=6.24U
* device instance $4693 r0 *1 488.825,346.46 diode_nw2ps_06v0
D$4693 VSS \$180 diode_nw2ps_06v0 A=0.864P P=6.24U
* device instance $4694 r0 *1 448.825,424.46 diode_nw2ps_06v0
D$4694 VSS \$176 diode_nw2ps_06v0 A=0.864P P=6.24U
* device instance $4695 r0 *1 408.825,424.46 diode_nw2ps_06v0
D$4695 VSS \$173 diode_nw2ps_06v0 A=0.864P P=6.24U
* device instance $4696 r0 *1 608.825,424.46 diode_nw2ps_06v0
D$4696 VSS \$188 diode_nw2ps_06v0 A=0.864P P=6.24U
* device instance $4697 r0 *1 568.825,424.46 diode_nw2ps_06v0
D$4697 VSS \$185 diode_nw2ps_06v0 A=0.864P P=6.24U
* device instance $4698 r0 *1 528.825,424.46 diode_nw2ps_06v0
D$4698 VSS \$182 diode_nw2ps_06v0 A=0.864P P=6.24U
* device instance $4699 r0 *1 528.825,580.46 diode_nw2ps_06v0
D$4699 VSS \$277 diode_nw2ps_06v0 A=0.864P P=6.24U
* device instance $4700 r0 *1 568.825,580.46 diode_nw2ps_06v0
D$4700 VSS \$278 diode_nw2ps_06v0 A=0.864P P=6.24U
* device instance $4701 r0 *1 328.825,502.46 diode_nw2ps_06v0
D$4701 VSS \$166 diode_nw2ps_06v0 A=0.864P P=6.24U
* device instance $4702 r0 *1 608.825,580.46 diode_nw2ps_06v0
D$4702 VSS \$279 diode_nw2ps_06v0 A=0.864P P=6.24U
* device instance $4703 r0 *1 208.825,34.46 diode_nw2ps_06v0
D$4703 VSS \$10 diode_nw2ps_06v0 A=0.864P P=6.24U
* device instance $4704 r0 *1 568.825,346.46 diode_nw2ps_06v0
D$4704 VSS \$186 diode_nw2ps_06v0 A=0.864P P=6.24U
* device instance $4705 r0 *1 648.825,424.46 diode_nw2ps_06v0
D$4705 VSS \$191 diode_nw2ps_06v0 A=0.864P P=6.24U
* device instance $4706 r0 *1 568.825,268.46 diode_nw2ps_06v0
D$4706 VSS \$108 diode_nw2ps_06v0 A=0.864P P=6.24U
* device instance $4707 r0 *1 608.825,268.46 diode_nw2ps_06v0
D$4707 VSS \$110 diode_nw2ps_06v0 A=0.864P P=6.24U
* device instance $4708 r0 *1 648.825,268.46 diode_nw2ps_06v0
D$4708 VSS \$112 diode_nw2ps_06v0 A=0.864P P=6.24U
* device instance $4709 r0 *1 528.825,268.46 diode_nw2ps_06v0
D$4709 VSS \$106 diode_nw2ps_06v0 A=0.864P P=6.24U
* device instance $4710 r0 *1 488.825,268.46 diode_nw2ps_06v0
D$4710 VSS \$104 diode_nw2ps_06v0 A=0.864P P=6.24U
* device instance $4711 r0 *1 648.825,346.46 diode_nw2ps_06v0
D$4711 VSS \$192 diode_nw2ps_06v0 A=0.864P P=6.24U
* device instance $4712 r0 *1 448.825,268.46 diode_nw2ps_06v0
D$4712 VSS \$102 diode_nw2ps_06v0 A=0.864P P=6.24U
* device instance $4713 r0 *1 368.825,268.46 diode_nw2ps_06v0
D$4713 VSS \$98 diode_nw2ps_06v0 A=0.864P P=6.24U
* device instance $4714 r0 *1 608.825,346.46 diode_nw2ps_06v0
D$4714 VSS \$189 diode_nw2ps_06v0 A=0.864P P=6.24U
* device instance $4715 r0 *1 408.825,268.46 diode_nw2ps_06v0
D$4715 VSS \$100 diode_nw2ps_06v0 A=0.864P P=6.24U
* device instance $4716 r0 *1 528.825,346.46 diode_nw2ps_06v0
D$4716 VSS \$183 diode_nw2ps_06v0 A=0.864P P=6.24U
* device instance $4717 r0 *1 648.825,580.46 diode_nw2ps_06v0
D$4717 VSS \$280 diode_nw2ps_06v0 A=0.864P P=6.24U
* device instance $4718 r0 *1 88.825,580.46 diode_nw2ps_06v0
D$4718 VSS \$266 diode_nw2ps_06v0 A=0.864P P=6.24U
* device instance $4719 r0 *1 88.825,424.46 diode_nw2ps_06v0
D$4719 VSS \$149 diode_nw2ps_06v0 A=0.864P P=6.24U
* device instance $4720 r0 *1 48.825,424.46 diode_nw2ps_06v0
D$4720 VSS \$146 diode_nw2ps_06v0 A=0.864P P=6.24U
* device instance $4721 r0 *1 128.825,34.46 diode_nw2ps_06v0
D$4721 VSS \$8 diode_nw2ps_06v0 A=0.864P P=6.24U
* device instance $4722 r0 *1 48.825,112.46 diode_nw2ps_06v0
D$4722 VSS \$25 diode_nw2ps_06v0 A=0.864P P=6.24U
* device instance $4723 r0 *1 88.825,112.46 diode_nw2ps_06v0
D$4723 VSS \$26 diode_nw2ps_06v0 A=0.864P P=6.24U
* device instance $4724 r0 *1 128.825,112.46 diode_nw2ps_06v0
D$4724 VSS \$27 diode_nw2ps_06v0 A=0.864P P=6.24U
* device instance $4725 r0 *1 448.825,34.46 diode_nw2ps_06v0
D$4725 VSS \$16 diode_nw2ps_06v0 A=0.864P P=6.24U
* device instance $4726 r0 *1 88.825,34.46 diode_nw2ps_06v0
D$4726 VSS \$7 diode_nw2ps_06v0 A=0.864P P=6.24U
* device instance $4727 r0 *1 48.825,190.46 diode_nw2ps_06v0
D$4727 VSS \$83 diode_nw2ps_06v0 A=0.864P P=6.24U
* device instance $4728 r0 *1 88.825,190.46 diode_nw2ps_06v0
D$4728 VSS \$85 diode_nw2ps_06v0 A=0.864P P=6.24U
* device instance $4729 r0 *1 128.825,190.46 diode_nw2ps_06v0
D$4729 VSS \$87 diode_nw2ps_06v0 A=0.864P P=6.24U
* device instance $4730 r0 *1 488.825,34.46 diode_nw2ps_06v0
D$4730 VSS \$17 diode_nw2ps_06v0 A=0.864P P=6.24U
* device instance $4731 r0 *1 288.825,34.46 diode_nw2ps_06v0
D$4731 VSS \$12 diode_nw2ps_06v0 A=0.864P P=6.24U
* device instance $4732 r0 *1 408.825,580.46 diode_nw2ps_06v0
D$4732 VSS \$274 diode_nw2ps_06v0 A=0.864P P=6.24U
* device instance $4733 r0 *1 408.825,346.46 diode_nw2ps_06v0
D$4733 VSS \$174 diode_nw2ps_06v0 A=0.864P P=6.24U
* device instance $4734 r0 *1 208.825,190.46 diode_nw2ps_06v0
D$4734 VSS \$91 diode_nw2ps_06v0 A=0.864P P=6.24U
* device instance $4735 r0 *1 288.825,190.46 diode_nw2ps_06v0
D$4735 VSS \$95 diode_nw2ps_06v0 A=0.864P P=6.24U
* device instance $4736 r0 *1 288.825,112.46 diode_nw2ps_06v0
D$4736 VSS \$31 diode_nw2ps_06v0 A=0.864P P=6.24U
* device instance $4737 r0 *1 448.825,346.46 diode_nw2ps_06v0
D$4737 VSS \$177 diode_nw2ps_06v0 A=0.864P P=6.24U
* device instance $4738 r0 *1 368.825,580.46 diode_nw2ps_06v0
D$4738 VSS \$273 diode_nw2ps_06v0 A=0.864P P=6.24U
* device instance $4739 r0 *1 208.825,112.46 diode_nw2ps_06v0
D$4739 VSS \$29 diode_nw2ps_06v0 A=0.864P P=6.24U
* device instance $4740 r0 *1 248.825,112.46 diode_nw2ps_06v0
D$4740 VSS \$30 diode_nw2ps_06v0 A=0.864P P=6.24U
* device instance $4741 r0 *1 408.825,190.46 diode_nw2ps_06v0
D$4741 VSS \$101 diode_nw2ps_06v0 A=0.864P P=6.24U
* device instance $4742 r0 *1 448.825,190.46 diode_nw2ps_06v0
D$4742 VSS \$103 diode_nw2ps_06v0 A=0.864P P=6.24U
* device instance $4743 r0 *1 488.825,190.46 diode_nw2ps_06v0
D$4743 VSS \$105 diode_nw2ps_06v0 A=0.864P P=6.24U
* device instance $4744 r0 *1 408.825,112.46 diode_nw2ps_06v0
D$4744 VSS \$34 diode_nw2ps_06v0 A=0.864P P=6.24U
* device instance $4745 r0 *1 448.825,112.46 diode_nw2ps_06v0
D$4745 VSS \$35 diode_nw2ps_06v0 A=0.864P P=6.24U
* device instance $4746 r0 *1 488.825,112.46 diode_nw2ps_06v0
D$4746 VSS \$36 diode_nw2ps_06v0 A=0.864P P=6.24U
* device instance $4747 r0 *1 168.825,580.46 diode_nw2ps_06v0
D$4747 VSS \$268 diode_nw2ps_06v0 A=0.864P P=6.24U
* device instance $4748 r0 *1 408.825,34.46 diode_nw2ps_06v0
D$4748 VSS \$15 diode_nw2ps_06v0 A=0.864P P=6.24U
* device instance $4749 r0 *1 368.825,190.46 diode_nw2ps_06v0
D$4749 VSS \$99 diode_nw2ps_06v0 A=0.864P P=6.24U
* device instance $4750 r0 *1 58.565,26.825 nfet_05v0
M$4750 VSS \$I4653 \$I513 VSS nfet_05v0 L=0.6U W=0.42U AS=0.315P AD=0.315P
+ PS=2.34U PD=2.34U
* device instance $4751 r0 *1 178.565,104.825 nfet_05v0
M$4751 VSS \$I4654 \$I512 VSS nfet_05v0 L=0.6U W=0.42U AS=0.315P AD=0.315P
+ PS=2.34U PD=2.34U
* device instance $4752 r0 *1 178.565,26.825 nfet_05v0
M$4752 VSS \$I4655 \$I511 VSS nfet_05v0 L=0.6U W=0.42U AS=0.315P AD=0.315P
+ PS=2.34U PD=2.34U
* device instance $4753 r0 *1 218.565,572.825 nfet_05v0
M$4753 VSS \$I4656 \$I510 VSS nfet_05v0 L=0.6U W=0.42U AS=0.315P AD=0.315P
+ PS=2.34U PD=2.34U
* device instance $4754 r0 *1 298.565,338.825 nfet_05v0
M$4754 VSS \$I4657 \$I509 VSS nfet_05v0 L=0.6U W=0.42U AS=0.315P AD=0.315P
+ PS=2.34U PD=2.34U
* device instance $4755 r0 *1 538.565,26.825 nfet_05v0
M$4755 VSS \$I4658 \$I508 VSS nfet_05v0 L=0.6U W=0.42U AS=0.315P AD=0.315P
+ PS=2.34U PD=2.34U
* device instance $4756 r0 *1 178.565,338.825 nfet_05v0
M$4756 VSS \$I4659 \$I507 VSS nfet_05v0 L=0.6U W=0.42U AS=0.315P AD=0.315P
+ PS=2.34U PD=2.34U
* device instance $4757 r0 *1 258.565,338.825 nfet_05v0
M$4757 VSS \$I4660 \$I506 VSS nfet_05v0 L=0.6U W=0.42U AS=0.315P AD=0.315P
+ PS=2.34U PD=2.34U
* device instance $4758 r0 *1 658.565,26.825 nfet_05v0
M$4758 VSS \$I4661 \$I505 VSS nfet_05v0 L=0.6U W=0.42U AS=0.315P AD=0.315P
+ PS=2.34U PD=2.34U
* device instance $4759 r0 *1 298.565,416.825 nfet_05v0
M$4759 VSS \$I4662 \$I504 VSS nfet_05v0 L=0.6U W=0.42U AS=0.315P AD=0.315P
+ PS=2.34U PD=2.34U
* device instance $4760 r0 *1 178.565,182.825 nfet_05v0
M$4760 VSS \$I4663 \$I503 VSS nfet_05v0 L=0.6U W=0.42U AS=0.315P AD=0.315P
+ PS=2.34U PD=2.34U
* device instance $4761 r0 *1 658.565,182.825 nfet_05v0
M$4761 VSS \$I4664 \$I502 VSS nfet_05v0 L=0.6U W=0.42U AS=0.315P AD=0.315P
+ PS=2.34U PD=2.34U
* device instance $4762 r0 *1 58.565,572.825 nfet_05v0
M$4762 VSS \$I4665 \$I501 VSS nfet_05v0 L=0.6U W=0.42U AS=0.315P AD=0.315P
+ PS=2.34U PD=2.34U
* device instance $4763 r0 *1 618.565,182.825 nfet_05v0
M$4763 VSS \$I4666 \$I500 VSS nfet_05v0 L=0.6U W=0.42U AS=0.315P AD=0.315P
+ PS=2.34U PD=2.34U
* device instance $4764 r0 *1 578.565,182.825 nfet_05v0
M$4764 VSS \$I4667 \$I499 VSS nfet_05v0 L=0.6U W=0.42U AS=0.315P AD=0.315P
+ PS=2.34U PD=2.34U
* device instance $4765 r0 *1 538.565,182.825 nfet_05v0
M$4765 VSS \$I4668 \$I498 VSS nfet_05v0 L=0.6U W=0.42U AS=0.315P AD=0.315P
+ PS=2.34U PD=2.34U
* device instance $4766 r0 *1 378.565,104.825 nfet_05v0
M$4766 VSS \$I4669 \$I497 VSS nfet_05v0 L=0.6U W=0.42U AS=0.315P AD=0.315P
+ PS=2.34U PD=2.34U
* device instance $4767 r0 *1 98.565,338.825 nfet_05v0
M$4767 VSS \$I4670 \$I496 VSS nfet_05v0 L=0.6U W=0.42U AS=0.315P AD=0.315P
+ PS=2.34U PD=2.34U
* device instance $4768 r0 *1 378.565,26.825 nfet_05v0
M$4768 VSS \$I4671 \$I495 VSS nfet_05v0 L=0.6U W=0.42U AS=0.315P AD=0.315P
+ PS=2.34U PD=2.34U
* device instance $4769 r0 *1 58.565,338.825 nfet_05v0
M$4769 VSS \$I4672 \$I494 VSS nfet_05v0 L=0.6U W=0.42U AS=0.315P AD=0.315P
+ PS=2.34U PD=2.34U
* device instance $4770 r0 *1 578.565,26.825 nfet_05v0
M$4770 VSS \$I4673 \$I493 VSS nfet_05v0 L=0.6U W=0.42U AS=0.315P AD=0.315P
+ PS=2.34U PD=2.34U
* device instance $4771 r0 *1 618.565,26.825 nfet_05v0
M$4771 VSS \$I4674 \$I492 VSS nfet_05v0 L=0.6U W=0.42U AS=0.315P AD=0.315P
+ PS=2.34U PD=2.34U
* device instance $4772 r0 *1 538.565,104.825 nfet_05v0
M$4772 VSS \$I4675 \$I491 VSS nfet_05v0 L=0.6U W=0.42U AS=0.315P AD=0.315P
+ PS=2.34U PD=2.34U
* device instance $4773 r0 *1 578.565,104.825 nfet_05v0
M$4773 VSS \$I4676 \$I490 VSS nfet_05v0 L=0.6U W=0.42U AS=0.315P AD=0.315P
+ PS=2.34U PD=2.34U
* device instance $4774 r0 *1 258.565,416.825 nfet_05v0
M$4774 VSS \$I4677 \$I489 VSS nfet_05v0 L=0.6U W=0.42U AS=0.315P AD=0.315P
+ PS=2.34U PD=2.34U
* device instance $4775 r0 *1 618.565,104.825 nfet_05v0
M$4775 VSS \$I4678 \$I488 VSS nfet_05v0 L=0.6U W=0.42U AS=0.315P AD=0.315P
+ PS=2.34U PD=2.34U
* device instance $4776 r0 *1 138.565,416.825 nfet_05v0
M$4776 VSS \$I4679 \$I487 VSS nfet_05v0 L=0.6U W=0.42U AS=0.315P AD=0.315P
+ PS=2.34U PD=2.34U
* device instance $4777 r0 *1 658.565,104.825 nfet_05v0
M$4777 VSS \$I4680 \$I486 VSS nfet_05v0 L=0.6U W=0.42U AS=0.315P AD=0.315P
+ PS=2.34U PD=2.34U
* device instance $4778 r0 *1 218.565,338.825 nfet_05v0
M$4778 VSS \$I4681 \$I485 VSS nfet_05v0 L=0.6U W=0.42U AS=0.315P AD=0.315P
+ PS=2.34U PD=2.34U
* device instance $4779 r0 *1 218.565,416.825 nfet_05v0
M$4779 VSS \$I4682 \$I484 VSS nfet_05v0 L=0.6U W=0.42U AS=0.315P AD=0.315P
+ PS=2.34U PD=2.34U
* device instance $4780 r0 *1 338.565,572.825 nfet_05v0
M$4780 VSS \$I4683 \$I483 VSS nfet_05v0 L=0.6U W=0.42U AS=0.315P AD=0.315P
+ PS=2.34U PD=2.34U
* device instance $4781 r0 *1 138.565,338.825 nfet_05v0
M$4781 VSS \$I4684 \$I482 VSS nfet_05v0 L=0.6U W=0.42U AS=0.315P AD=0.315P
+ PS=2.34U PD=2.34U
* device instance $4782 r0 *1 338.565,416.825 nfet_05v0
M$4782 VSS \$I4685 \$I481 VSS nfet_05v0 L=0.6U W=0.42U AS=0.315P AD=0.315P
+ PS=2.34U PD=2.34U
* device instance $4783 r0 *1 338.565,338.825 nfet_05v0
M$4783 VSS \$I4686 \$I480 VSS nfet_05v0 L=0.6U W=0.42U AS=0.315P AD=0.315P
+ PS=2.34U PD=2.34U
* device instance $4784 r0 *1 338.565,260.825 nfet_05v0
M$4784 VSS \$I4687 \$I479 VSS nfet_05v0 L=0.6U W=0.42U AS=0.315P AD=0.315P
+ PS=2.34U PD=2.34U
* device instance $4785 r0 *1 338.565,182.825 nfet_05v0
M$4785 VSS \$I4688 \$I478 VSS nfet_05v0 L=0.6U W=0.42U AS=0.315P AD=0.315P
+ PS=2.34U PD=2.34U
* device instance $4786 r0 *1 338.565,104.825 nfet_05v0
M$4786 VSS \$I4689 \$I477 VSS nfet_05v0 L=0.6U W=0.42U AS=0.315P AD=0.315P
+ PS=2.34U PD=2.34U
* device instance $4787 r0 *1 338.565,26.825 nfet_05v0
M$4787 VSS \$I4690 \$I476 VSS nfet_05v0 L=0.6U W=0.42U AS=0.315P AD=0.315P
+ PS=2.34U PD=2.34U
* device instance $4788 r0 *1 378.565,494.825 nfet_05v0
M$4788 VSS \$I4691 \$I475 VSS nfet_05v0 L=0.6U W=0.42U AS=0.315P AD=0.315P
+ PS=2.34U PD=2.34U
* device instance $4789 r0 *1 418.565,494.825 nfet_05v0
M$4789 VSS \$I4692 \$I474 VSS nfet_05v0 L=0.6U W=0.42U AS=0.315P AD=0.315P
+ PS=2.34U PD=2.34U
* device instance $4790 r0 *1 458.565,494.825 nfet_05v0
M$4790 VSS \$I4693 \$I473 VSS nfet_05v0 L=0.6U W=0.42U AS=0.315P AD=0.315P
+ PS=2.34U PD=2.34U
* device instance $4791 r0 *1 498.565,494.825 nfet_05v0
M$4791 VSS \$I4694 \$I472 VSS nfet_05v0 L=0.6U W=0.42U AS=0.315P AD=0.315P
+ PS=2.34U PD=2.34U
* device instance $4792 r0 *1 618.565,494.825 nfet_05v0
M$4792 VSS \$I4695 \$I471 VSS nfet_05v0 L=0.6U W=0.42U AS=0.315P AD=0.315P
+ PS=2.34U PD=2.34U
* device instance $4793 r0 *1 658.565,494.825 nfet_05v0
M$4793 VSS \$I4696 \$I470 VSS nfet_05v0 L=0.6U W=0.42U AS=0.315P AD=0.315P
+ PS=2.34U PD=2.34U
* device instance $4794 r0 *1 538.565,494.825 nfet_05v0
M$4794 VSS \$I4697 \$I469 VSS nfet_05v0 L=0.6U W=0.42U AS=0.315P AD=0.315P
+ PS=2.34U PD=2.34U
* device instance $4795 r0 *1 578.565,494.825 nfet_05v0
M$4795 VSS \$I4698 \$I468 VSS nfet_05v0 L=0.6U W=0.42U AS=0.315P AD=0.315P
+ PS=2.34U PD=2.34U
* device instance $4796 r0 *1 178.565,494.825 nfet_05v0
M$4796 VSS \$I4699 \$I467 VSS nfet_05v0 L=0.6U W=0.42U AS=0.315P AD=0.315P
+ PS=2.34U PD=2.34U
* device instance $4797 r0 *1 138.565,572.825 nfet_05v0
M$4797 VSS \$I4700 \$I466 VSS nfet_05v0 L=0.6U W=0.42U AS=0.315P AD=0.315P
+ PS=2.34U PD=2.34U
* device instance $4798 r0 *1 58.565,494.825 nfet_05v0
M$4798 VSS \$I4701 \$I465 VSS nfet_05v0 L=0.6U W=0.42U AS=0.315P AD=0.315P
+ PS=2.34U PD=2.34U
* device instance $4799 r0 *1 98.565,494.825 nfet_05v0
M$4799 VSS \$I4702 \$I464 VSS nfet_05v0 L=0.6U W=0.42U AS=0.315P AD=0.315P
+ PS=2.34U PD=2.34U
* device instance $4800 r0 *1 138.565,494.825 nfet_05v0
M$4800 VSS \$I4703 \$I463 VSS nfet_05v0 L=0.6U W=0.42U AS=0.315P AD=0.315P
+ PS=2.34U PD=2.34U
* device instance $4801 r0 *1 218.565,494.825 nfet_05v0
M$4801 VSS \$I4704 \$I462 VSS nfet_05v0 L=0.6U W=0.42U AS=0.315P AD=0.315P
+ PS=2.34U PD=2.34U
* device instance $4802 r0 *1 258.565,494.825 nfet_05v0
M$4802 VSS \$I4705 \$I461 VSS nfet_05v0 L=0.6U W=0.42U AS=0.315P AD=0.315P
+ PS=2.34U PD=2.34U
* device instance $4803 r0 *1 298.565,494.825 nfet_05v0
M$4803 VSS \$I4706 \$I460 VSS nfet_05v0 L=0.6U W=0.42U AS=0.315P AD=0.315P
+ PS=2.34U PD=2.34U
* device instance $4804 r0 *1 298.565,572.825 nfet_05v0
M$4804 VSS \$I4707 \$I459 VSS nfet_05v0 L=0.6U W=0.42U AS=0.315P AD=0.315P
+ PS=2.34U PD=2.34U
* device instance $4805 r0 *1 258.565,260.825 nfet_05v0
M$4805 VSS \$I4708 \$I458 VSS nfet_05v0 L=0.6U W=0.42U AS=0.315P AD=0.315P
+ PS=2.34U PD=2.34U
* device instance $4806 r0 *1 298.565,260.825 nfet_05v0
M$4806 VSS \$I4709 \$I457 VSS nfet_05v0 L=0.6U W=0.42U AS=0.315P AD=0.315P
+ PS=2.34U PD=2.34U
* device instance $4807 r0 *1 138.565,260.825 nfet_05v0
M$4807 VSS \$I4710 \$I456 VSS nfet_05v0 L=0.6U W=0.42U AS=0.315P AD=0.315P
+ PS=2.34U PD=2.34U
* device instance $4808 r0 *1 98.565,260.825 nfet_05v0
M$4808 VSS \$I4711 \$I455 VSS nfet_05v0 L=0.6U W=0.42U AS=0.315P AD=0.315P
+ PS=2.34U PD=2.34U
* device instance $4809 r0 *1 258.565,572.825 nfet_05v0
M$4809 VSS \$I4712 \$I454 VSS nfet_05v0 L=0.6U W=0.42U AS=0.315P AD=0.315P
+ PS=2.34U PD=2.34U
* device instance $4810 r0 *1 58.565,260.825 nfet_05v0
M$4810 VSS \$I4713 \$I453 VSS nfet_05v0 L=0.6U W=0.42U AS=0.315P AD=0.315P
+ PS=2.34U PD=2.34U
* device instance $4811 r0 *1 178.565,416.825 nfet_05v0
M$4811 VSS \$I4714 \$I452 VSS nfet_05v0 L=0.6U W=0.42U AS=0.315P AD=0.315P
+ PS=2.34U PD=2.34U
* device instance $4812 r0 *1 178.565,260.825 nfet_05v0
M$4812 VSS \$I4715 \$I451 VSS nfet_05v0 L=0.6U W=0.42U AS=0.315P AD=0.315P
+ PS=2.34U PD=2.34U
* device instance $4813 r0 *1 218.565,260.825 nfet_05v0
M$4813 VSS \$I4716 \$I450 VSS nfet_05v0 L=0.6U W=0.42U AS=0.315P AD=0.315P
+ PS=2.34U PD=2.34U
* device instance $4814 r0 *1 258.565,182.825 nfet_05v0
M$4814 VSS \$I4717 \$I449 VSS nfet_05v0 L=0.6U W=0.42U AS=0.315P AD=0.315P
+ PS=2.34U PD=2.34U
* device instance $4815 r0 *1 458.565,572.825 nfet_05v0
M$4815 VSS \$I4718 \$I448 VSS nfet_05v0 L=0.6U W=0.42U AS=0.315P AD=0.315P
+ PS=2.34U PD=2.34U
* device instance $4816 r0 *1 498.565,572.825 nfet_05v0
M$4816 VSS \$I4719 \$I447 VSS nfet_05v0 L=0.6U W=0.42U AS=0.315P AD=0.315P
+ PS=2.34U PD=2.34U
* device instance $4817 r0 *1 378.565,338.825 nfet_05v0
M$4817 VSS \$I4720 \$I446 VSS nfet_05v0 L=0.6U W=0.42U AS=0.315P AD=0.315P
+ PS=2.34U PD=2.34U
* device instance $4818 r0 *1 378.565,416.825 nfet_05v0
M$4818 VSS \$I4721 \$I445 VSS nfet_05v0 L=0.6U W=0.42U AS=0.315P AD=0.315P
+ PS=2.34U PD=2.34U
* device instance $4819 r0 *1 498.565,416.825 nfet_05v0
M$4819 VSS \$I4722 \$I444 VSS nfet_05v0 L=0.6U W=0.42U AS=0.315P AD=0.315P
+ PS=2.34U PD=2.34U
* device instance $4820 r0 *1 258.565,26.825 nfet_05v0
M$4820 VSS \$I4723 \$I443 VSS nfet_05v0 L=0.6U W=0.42U AS=0.315P AD=0.315P
+ PS=2.34U PD=2.34U
* device instance $4821 r0 *1 498.565,338.825 nfet_05v0
M$4821 VSS \$I4724 \$I442 VSS nfet_05v0 L=0.6U W=0.42U AS=0.315P AD=0.315P
+ PS=2.34U PD=2.34U
* device instance $4822 r0 *1 458.565,416.825 nfet_05v0
M$4822 VSS \$I4725 \$I441 VSS nfet_05v0 L=0.6U W=0.42U AS=0.315P AD=0.315P
+ PS=2.34U PD=2.34U
* device instance $4823 r0 *1 418.565,416.825 nfet_05v0
M$4823 VSS \$I4726 \$I440 VSS nfet_05v0 L=0.6U W=0.42U AS=0.315P AD=0.315P
+ PS=2.34U PD=2.34U
* device instance $4824 r0 *1 618.565,416.825 nfet_05v0
M$4824 VSS \$I4727 \$I439 VSS nfet_05v0 L=0.6U W=0.42U AS=0.315P AD=0.315P
+ PS=2.34U PD=2.34U
* device instance $4825 r0 *1 578.565,416.825 nfet_05v0
M$4825 VSS \$I4728 \$I438 VSS nfet_05v0 L=0.6U W=0.42U AS=0.315P AD=0.315P
+ PS=2.34U PD=2.34U
* device instance $4826 r0 *1 538.565,416.825 nfet_05v0
M$4826 VSS \$I4729 \$I437 VSS nfet_05v0 L=0.6U W=0.42U AS=0.315P AD=0.315P
+ PS=2.34U PD=2.34U
* device instance $4827 r0 *1 538.565,572.825 nfet_05v0
M$4827 VSS \$I4730 \$I436 VSS nfet_05v0 L=0.6U W=0.42U AS=0.315P AD=0.315P
+ PS=2.34U PD=2.34U
* device instance $4828 r0 *1 578.565,572.825 nfet_05v0
M$4828 VSS \$I4731 \$I435 VSS nfet_05v0 L=0.6U W=0.42U AS=0.315P AD=0.315P
+ PS=2.34U PD=2.34U
* device instance $4829 r0 *1 338.565,494.825 nfet_05v0
M$4829 VSS \$I4732 \$I434 VSS nfet_05v0 L=0.6U W=0.42U AS=0.315P AD=0.315P
+ PS=2.34U PD=2.34U
* device instance $4830 r0 *1 618.565,572.825 nfet_05v0
M$4830 VSS \$I4733 \$I433 VSS nfet_05v0 L=0.6U W=0.42U AS=0.315P AD=0.315P
+ PS=2.34U PD=2.34U
* device instance $4831 r0 *1 218.565,26.825 nfet_05v0
M$4831 VSS \$I4734 \$I432 VSS nfet_05v0 L=0.6U W=0.42U AS=0.315P AD=0.315P
+ PS=2.34U PD=2.34U
* device instance $4832 r0 *1 578.565,338.825 nfet_05v0
M$4832 VSS \$I4735 \$I431 VSS nfet_05v0 L=0.6U W=0.42U AS=0.315P AD=0.315P
+ PS=2.34U PD=2.34U
* device instance $4833 r0 *1 658.565,416.825 nfet_05v0
M$4833 VSS \$I4736 \$I430 VSS nfet_05v0 L=0.6U W=0.42U AS=0.315P AD=0.315P
+ PS=2.34U PD=2.34U
* device instance $4834 r0 *1 578.565,260.825 nfet_05v0
M$4834 VSS \$I4737 \$I429 VSS nfet_05v0 L=0.6U W=0.42U AS=0.315P AD=0.315P
+ PS=2.34U PD=2.34U
* device instance $4835 r0 *1 618.565,260.825 nfet_05v0
M$4835 VSS \$I4738 \$I428 VSS nfet_05v0 L=0.6U W=0.42U AS=0.315P AD=0.315P
+ PS=2.34U PD=2.34U
* device instance $4836 r0 *1 658.565,260.825 nfet_05v0
M$4836 VSS \$I4739 \$I427 VSS nfet_05v0 L=0.6U W=0.42U AS=0.315P AD=0.315P
+ PS=2.34U PD=2.34U
* device instance $4837 r0 *1 538.565,260.825 nfet_05v0
M$4837 VSS \$I4740 \$I426 VSS nfet_05v0 L=0.6U W=0.42U AS=0.315P AD=0.315P
+ PS=2.34U PD=2.34U
* device instance $4838 r0 *1 498.565,260.825 nfet_05v0
M$4838 VSS \$I4741 \$I425 VSS nfet_05v0 L=0.6U W=0.42U AS=0.315P AD=0.315P
+ PS=2.34U PD=2.34U
* device instance $4839 r0 *1 658.565,338.825 nfet_05v0
M$4839 VSS \$I4742 \$I424 VSS nfet_05v0 L=0.6U W=0.42U AS=0.315P AD=0.315P
+ PS=2.34U PD=2.34U
* device instance $4840 r0 *1 458.565,260.825 nfet_05v0
M$4840 VSS \$I4743 \$I423 VSS nfet_05v0 L=0.6U W=0.42U AS=0.315P AD=0.315P
+ PS=2.34U PD=2.34U
* device instance $4841 r0 *1 378.565,260.825 nfet_05v0
M$4841 VSS \$I4744 \$I422 VSS nfet_05v0 L=0.6U W=0.42U AS=0.315P AD=0.315P
+ PS=2.34U PD=2.34U
* device instance $4842 r0 *1 618.565,338.825 nfet_05v0
M$4842 VSS \$I4745 \$I421 VSS nfet_05v0 L=0.6U W=0.42U AS=0.315P AD=0.315P
+ PS=2.34U PD=2.34U
* device instance $4843 r0 *1 418.565,260.825 nfet_05v0
M$4843 VSS \$I4746 \$I420 VSS nfet_05v0 L=0.6U W=0.42U AS=0.315P AD=0.315P
+ PS=2.34U PD=2.34U
* device instance $4844 r0 *1 538.565,338.825 nfet_05v0
M$4844 VSS \$I4747 \$I419 VSS nfet_05v0 L=0.6U W=0.42U AS=0.315P AD=0.315P
+ PS=2.34U PD=2.34U
* device instance $4845 r0 *1 658.565,572.825 nfet_05v0
M$4845 VSS \$I4748 \$I418 VSS nfet_05v0 L=0.6U W=0.42U AS=0.315P AD=0.315P
+ PS=2.34U PD=2.34U
* device instance $4846 r0 *1 98.565,572.825 nfet_05v0
M$4846 VSS \$I4749 \$I417 VSS nfet_05v0 L=0.6U W=0.42U AS=0.315P AD=0.315P
+ PS=2.34U PD=2.34U
* device instance $4847 r0 *1 98.565,416.825 nfet_05v0
M$4847 VSS \$I4750 \$I416 VSS nfet_05v0 L=0.6U W=0.42U AS=0.315P AD=0.315P
+ PS=2.34U PD=2.34U
* device instance $4848 r0 *1 58.565,416.825 nfet_05v0
M$4848 VSS \$I4751 \$I415 VSS nfet_05v0 L=0.6U W=0.42U AS=0.315P AD=0.315P
+ PS=2.34U PD=2.34U
* device instance $4849 r0 *1 138.565,26.825 nfet_05v0
M$4849 VSS \$I4752 \$I414 VSS nfet_05v0 L=0.6U W=0.42U AS=0.315P AD=0.315P
+ PS=2.34U PD=2.34U
* device instance $4850 r0 *1 58.565,104.825 nfet_05v0
M$4850 VSS \$I4753 \$I413 VSS nfet_05v0 L=0.6U W=0.42U AS=0.315P AD=0.315P
+ PS=2.34U PD=2.34U
* device instance $4851 r0 *1 98.565,104.825 nfet_05v0
M$4851 VSS \$I4754 \$I412 VSS nfet_05v0 L=0.6U W=0.42U AS=0.315P AD=0.315P
+ PS=2.34U PD=2.34U
* device instance $4852 r0 *1 138.565,104.825 nfet_05v0
M$4852 VSS \$I4755 \$I411 VSS nfet_05v0 L=0.6U W=0.42U AS=0.315P AD=0.315P
+ PS=2.34U PD=2.34U
* device instance $4853 r0 *1 458.565,26.825 nfet_05v0
M$4853 VSS \$I4756 \$I410 VSS nfet_05v0 L=0.6U W=0.42U AS=0.315P AD=0.315P
+ PS=2.34U PD=2.34U
* device instance $4854 r0 *1 98.565,26.825 nfet_05v0
M$4854 VSS \$I4757 \$I409 VSS nfet_05v0 L=0.6U W=0.42U AS=0.315P AD=0.315P
+ PS=2.34U PD=2.34U
* device instance $4855 r0 *1 58.565,182.825 nfet_05v0
M$4855 VSS \$I4758 \$I408 VSS nfet_05v0 L=0.6U W=0.42U AS=0.315P AD=0.315P
+ PS=2.34U PD=2.34U
* device instance $4856 r0 *1 98.565,182.825 nfet_05v0
M$4856 VSS \$I4759 \$I407 VSS nfet_05v0 L=0.6U W=0.42U AS=0.315P AD=0.315P
+ PS=2.34U PD=2.34U
* device instance $4857 r0 *1 138.565,182.825 nfet_05v0
M$4857 VSS \$I4760 \$I406 VSS nfet_05v0 L=0.6U W=0.42U AS=0.315P AD=0.315P
+ PS=2.34U PD=2.34U
* device instance $4858 r0 *1 498.565,26.825 nfet_05v0
M$4858 VSS \$I4761 \$I405 VSS nfet_05v0 L=0.6U W=0.42U AS=0.315P AD=0.315P
+ PS=2.34U PD=2.34U
* device instance $4859 r0 *1 298.565,26.825 nfet_05v0
M$4859 VSS \$I4762 \$I404 VSS nfet_05v0 L=0.6U W=0.42U AS=0.315P AD=0.315P
+ PS=2.34U PD=2.34U
* device instance $4860 r0 *1 418.565,572.825 nfet_05v0
M$4860 VSS \$I4763 \$I403 VSS nfet_05v0 L=0.6U W=0.42U AS=0.315P AD=0.315P
+ PS=2.34U PD=2.34U
* device instance $4861 r0 *1 418.565,338.825 nfet_05v0
M$4861 VSS \$I4764 \$I402 VSS nfet_05v0 L=0.6U W=0.42U AS=0.315P AD=0.315P
+ PS=2.34U PD=2.34U
* device instance $4862 r0 *1 218.565,182.825 nfet_05v0
M$4862 VSS \$I4765 \$I401 VSS nfet_05v0 L=0.6U W=0.42U AS=0.315P AD=0.315P
+ PS=2.34U PD=2.34U
* device instance $4863 r0 *1 298.565,182.825 nfet_05v0
M$4863 VSS \$I4766 \$I400 VSS nfet_05v0 L=0.6U W=0.42U AS=0.315P AD=0.315P
+ PS=2.34U PD=2.34U
* device instance $4864 r0 *1 298.565,104.825 nfet_05v0
M$4864 VSS \$I4767 \$I399 VSS nfet_05v0 L=0.6U W=0.42U AS=0.315P AD=0.315P
+ PS=2.34U PD=2.34U
* device instance $4865 r0 *1 458.565,338.825 nfet_05v0
M$4865 VSS \$I4768 \$I398 VSS nfet_05v0 L=0.6U W=0.42U AS=0.315P AD=0.315P
+ PS=2.34U PD=2.34U
* device instance $4866 r0 *1 378.565,572.825 nfet_05v0
M$4866 VSS \$I4769 \$I397 VSS nfet_05v0 L=0.6U W=0.42U AS=0.315P AD=0.315P
+ PS=2.34U PD=2.34U
* device instance $4867 r0 *1 218.565,104.825 nfet_05v0
M$4867 VSS \$I4770 \$I396 VSS nfet_05v0 L=0.6U W=0.42U AS=0.315P AD=0.315P
+ PS=2.34U PD=2.34U
* device instance $4868 r0 *1 258.565,104.825 nfet_05v0
M$4868 VSS \$I4771 \$I395 VSS nfet_05v0 L=0.6U W=0.42U AS=0.315P AD=0.315P
+ PS=2.34U PD=2.34U
* device instance $4869 r0 *1 418.565,182.825 nfet_05v0
M$4869 VSS \$I4772 \$I394 VSS nfet_05v0 L=0.6U W=0.42U AS=0.315P AD=0.315P
+ PS=2.34U PD=2.34U
* device instance $4870 r0 *1 458.565,182.825 nfet_05v0
M$4870 VSS \$I4773 \$I393 VSS nfet_05v0 L=0.6U W=0.42U AS=0.315P AD=0.315P
+ PS=2.34U PD=2.34U
* device instance $4871 r0 *1 498.565,182.825 nfet_05v0
M$4871 VSS \$I4774 \$I392 VSS nfet_05v0 L=0.6U W=0.42U AS=0.315P AD=0.315P
+ PS=2.34U PD=2.34U
* device instance $4872 r0 *1 418.565,104.825 nfet_05v0
M$4872 VSS \$I4775 \$I391 VSS nfet_05v0 L=0.6U W=0.42U AS=0.315P AD=0.315P
+ PS=2.34U PD=2.34U
* device instance $4873 r0 *1 458.565,104.825 nfet_05v0
M$4873 VSS \$I4776 \$I390 VSS nfet_05v0 L=0.6U W=0.42U AS=0.315P AD=0.315P
+ PS=2.34U PD=2.34U
* device instance $4874 r0 *1 498.565,104.825 nfet_05v0
M$4874 VSS \$I4777 \$I389 VSS nfet_05v0 L=0.6U W=0.42U AS=0.315P AD=0.315P
+ PS=2.34U PD=2.34U
* device instance $4875 r0 *1 178.565,572.825 nfet_05v0
M$4875 VSS \$I4778 \$I388 VSS nfet_05v0 L=0.6U W=0.42U AS=0.315P AD=0.315P
+ PS=2.34U PD=2.34U
* device instance $4876 r0 *1 418.565,26.825 nfet_05v0
M$4876 VSS \$I4779 \$I387 VSS nfet_05v0 L=0.6U W=0.42U AS=0.315P AD=0.315P
+ PS=2.34U PD=2.34U
* device instance $4877 r0 *1 378.565,182.825 nfet_05v0
M$4877 VSS \$I4780 \$I386 VSS nfet_05v0 L=0.6U W=0.42U AS=0.315P AD=0.315P
+ PS=2.34U PD=2.34U
* device instance $5006 r0 *1 58.565,28.74 nfet_05v0
M$5006 VSS \$6 \$I4653 VSS nfet_05v0 L=0.6U W=1U AS=0.73P AD=0.73P PS=3.46U
+ PD=3.46U
* device instance $5007 r0 *1 178.565,106.74 nfet_05v0
M$5007 VSS \$28 \$I4654 VSS nfet_05v0 L=0.6U W=1U AS=0.73P AD=0.73P PS=3.46U
+ PD=3.46U
* device instance $5008 r0 *1 178.565,28.74 nfet_05v0
M$5008 VSS \$9 \$I4655 VSS nfet_05v0 L=0.6U W=1U AS=0.73P AD=0.73P PS=3.46U
+ PD=3.46U
* device instance $5009 r0 *1 218.565,574.74 nfet_05v0
M$5009 VSS \$269 \$I4656 VSS nfet_05v0 L=0.6U W=1U AS=0.73P AD=0.73P PS=3.46U
+ PD=3.46U
* device instance $5010 r0 *1 298.565,340.74 nfet_05v0
M$5010 VSS \$165 \$I4657 VSS nfet_05v0 L=0.6U W=1U AS=0.73P AD=0.73P PS=3.46U
+ PD=3.46U
* device instance $5011 r0 *1 538.565,28.74 nfet_05v0
M$5011 VSS \$18 \$I4658 VSS nfet_05v0 L=0.6U W=1U AS=0.73P AD=0.73P PS=3.46U
+ PD=3.46U
* device instance $5012 r0 *1 178.565,340.74 nfet_05v0
M$5012 VSS \$156 \$I4659 VSS nfet_05v0 L=0.6U W=1U AS=0.73P AD=0.73P PS=3.46U
+ PD=3.46U
* device instance $5013 r0 *1 258.565,340.74 nfet_05v0
M$5013 VSS \$162 \$I4660 VSS nfet_05v0 L=0.6U W=1U AS=0.73P AD=0.73P PS=3.46U
+ PD=3.46U
* device instance $5014 r0 *1 658.565,28.74 nfet_05v0
M$5014 VSS \$21 \$I4661 VSS nfet_05v0 L=0.6U W=1U AS=0.73P AD=0.73P PS=3.46U
+ PD=3.46U
* device instance $5015 r0 *1 298.565,418.74 nfet_05v0
M$5015 VSS \$164 \$I4662 VSS nfet_05v0 L=0.6U W=1U AS=0.73P AD=0.73P PS=3.46U
+ PD=3.46U
* device instance $5016 r0 *1 178.565,184.74 nfet_05v0
M$5016 VSS \$89 \$I4663 VSS nfet_05v0 L=0.6U W=1U AS=0.73P AD=0.73P PS=3.46U
+ PD=3.46U
* device instance $5017 r0 *1 658.565,184.74 nfet_05v0
M$5017 VSS \$113 \$I4664 VSS nfet_05v0 L=0.6U W=1U AS=0.73P AD=0.73P PS=3.46U
+ PD=3.46U
* device instance $5018 r0 *1 58.565,574.74 nfet_05v0
M$5018 VSS \$265 \$I4665 VSS nfet_05v0 L=0.6U W=1U AS=0.73P AD=0.73P PS=3.46U
+ PD=3.46U
* device instance $5019 r0 *1 618.565,184.74 nfet_05v0
M$5019 VSS \$111 \$I4666 VSS nfet_05v0 L=0.6U W=1U AS=0.73P AD=0.73P PS=3.46U
+ PD=3.46U
* device instance $5020 r0 *1 578.565,184.74 nfet_05v0
M$5020 VSS \$109 \$I4667 VSS nfet_05v0 L=0.6U W=1U AS=0.73P AD=0.73P PS=3.46U
+ PD=3.46U
* device instance $5021 r0 *1 538.565,184.74 nfet_05v0
M$5021 VSS \$107 \$I4668 VSS nfet_05v0 L=0.6U W=1U AS=0.73P AD=0.73P PS=3.46U
+ PD=3.46U
* device instance $5022 r0 *1 378.565,106.74 nfet_05v0
M$5022 VSS \$33 \$I4669 VSS nfet_05v0 L=0.6U W=1U AS=0.73P AD=0.73P PS=3.46U
+ PD=3.46U
* device instance $5023 r0 *1 98.565,340.74 nfet_05v0
M$5023 VSS \$150 \$I4670 VSS nfet_05v0 L=0.6U W=1U AS=0.73P AD=0.73P PS=3.46U
+ PD=3.46U
* device instance $5024 r0 *1 378.565,28.74 nfet_05v0
M$5024 VSS \$14 \$I4671 VSS nfet_05v0 L=0.6U W=1U AS=0.73P AD=0.73P PS=3.46U
+ PD=3.46U
* device instance $5025 r0 *1 58.565,340.74 nfet_05v0
M$5025 VSS \$147 \$I4672 VSS nfet_05v0 L=0.6U W=1U AS=0.73P AD=0.73P PS=3.46U
+ PD=3.46U
* device instance $5026 r0 *1 578.565,28.74 nfet_05v0
M$5026 VSS \$19 \$I4673 VSS nfet_05v0 L=0.6U W=1U AS=0.73P AD=0.73P PS=3.46U
+ PD=3.46U
* device instance $5027 r0 *1 618.565,28.74 nfet_05v0
M$5027 VSS \$20 \$I4674 VSS nfet_05v0 L=0.6U W=1U AS=0.73P AD=0.73P PS=3.46U
+ PD=3.46U
* device instance $5028 r0 *1 538.565,106.74 nfet_05v0
M$5028 VSS \$37 \$I4675 VSS nfet_05v0 L=0.6U W=1U AS=0.73P AD=0.73P PS=3.46U
+ PD=3.46U
* device instance $5029 r0 *1 578.565,106.74 nfet_05v0
M$5029 VSS \$38 \$I4676 VSS nfet_05v0 L=0.6U W=1U AS=0.73P AD=0.73P PS=3.46U
+ PD=3.46U
* device instance $5030 r0 *1 258.565,418.74 nfet_05v0
M$5030 VSS \$161 \$I4677 VSS nfet_05v0 L=0.6U W=1U AS=0.73P AD=0.73P PS=3.46U
+ PD=3.46U
* device instance $5031 r0 *1 618.565,106.74 nfet_05v0
M$5031 VSS \$39 \$I4678 VSS nfet_05v0 L=0.6U W=1U AS=0.73P AD=0.73P PS=3.46U
+ PD=3.46U
* device instance $5032 r0 *1 138.565,418.74 nfet_05v0
M$5032 VSS \$152 \$I4679 VSS nfet_05v0 L=0.6U W=1U AS=0.73P AD=0.73P PS=3.46U
+ PD=3.46U
* device instance $5033 r0 *1 658.565,106.74 nfet_05v0
M$5033 VSS \$40 \$I4680 VSS nfet_05v0 L=0.6U W=1U AS=0.73P AD=0.73P PS=3.46U
+ PD=3.46U
* device instance $5034 r0 *1 218.565,340.74 nfet_05v0
M$5034 VSS \$159 \$I4681 VSS nfet_05v0 L=0.6U W=1U AS=0.73P AD=0.73P PS=3.46U
+ PD=3.46U
* device instance $5035 r0 *1 218.565,418.74 nfet_05v0
M$5035 VSS \$158 \$I4682 VSS nfet_05v0 L=0.6U W=1U AS=0.73P AD=0.73P PS=3.46U
+ PD=3.46U
* device instance $5036 r0 *1 338.565,574.74 nfet_05v0
M$5036 VSS \$272 \$I4683 VSS nfet_05v0 L=0.6U W=1U AS=0.73P AD=0.73P PS=3.46U
+ PD=3.46U
* device instance $5037 r0 *1 138.565,340.74 nfet_05v0
M$5037 VSS \$153 \$I4684 VSS nfet_05v0 L=0.6U W=1U AS=0.73P AD=0.73P PS=3.46U
+ PD=3.46U
* device instance $5038 r0 *1 338.565,418.74 nfet_05v0
M$5038 VSS \$167 \$I4685 VSS nfet_05v0 L=0.6U W=1U AS=0.73P AD=0.73P PS=3.46U
+ PD=3.46U
* device instance $5039 r0 *1 338.565,340.74 nfet_05v0
M$5039 VSS \$168 \$I4686 VSS nfet_05v0 L=0.6U W=1U AS=0.73P AD=0.73P PS=3.46U
+ PD=3.46U
* device instance $5040 r0 *1 338.565,262.74 nfet_05v0
M$5040 VSS \$96 \$I4687 VSS nfet_05v0 L=0.6U W=1U AS=0.73P AD=0.73P PS=3.46U
+ PD=3.46U
* device instance $5041 r0 *1 338.565,184.74 nfet_05v0
M$5041 VSS \$97 \$I4688 VSS nfet_05v0 L=0.6U W=1U AS=0.73P AD=0.73P PS=3.46U
+ PD=3.46U
* device instance $5042 r0 *1 338.565,106.74 nfet_05v0
M$5042 VSS \$32 \$I4689 VSS nfet_05v0 L=0.6U W=1U AS=0.73P AD=0.73P PS=3.46U
+ PD=3.46U
* device instance $5043 r0 *1 338.565,28.74 nfet_05v0
M$5043 VSS \$13 \$I4690 VSS nfet_05v0 L=0.6U W=1U AS=0.73P AD=0.73P PS=3.46U
+ PD=3.46U
* device instance $5044 r0 *1 378.565,496.74 nfet_05v0
M$5044 VSS \$169 \$I4691 VSS nfet_05v0 L=0.6U W=1U AS=0.73P AD=0.73P PS=3.46U
+ PD=3.46U
* device instance $5045 r0 *1 418.565,496.74 nfet_05v0
M$5045 VSS \$172 \$I4692 VSS nfet_05v0 L=0.6U W=1U AS=0.73P AD=0.73P PS=3.46U
+ PD=3.46U
* device instance $5046 r0 *1 458.565,496.74 nfet_05v0
M$5046 VSS \$175 \$I4693 VSS nfet_05v0 L=0.6U W=1U AS=0.73P AD=0.73P PS=3.46U
+ PD=3.46U
* device instance $5047 r0 *1 498.565,496.74 nfet_05v0
M$5047 VSS \$178 \$I4694 VSS nfet_05v0 L=0.6U W=1U AS=0.73P AD=0.73P PS=3.46U
+ PD=3.46U
* device instance $5048 r0 *1 618.565,496.74 nfet_05v0
M$5048 VSS \$187 \$I4695 VSS nfet_05v0 L=0.6U W=1U AS=0.73P AD=0.73P PS=3.46U
+ PD=3.46U
* device instance $5049 r0 *1 658.565,496.74 nfet_05v0
M$5049 VSS \$190 \$I4696 VSS nfet_05v0 L=0.6U W=1U AS=0.73P AD=0.73P PS=3.46U
+ PD=3.46U
* device instance $5050 r0 *1 538.565,496.74 nfet_05v0
M$5050 VSS \$181 \$I4697 VSS nfet_05v0 L=0.6U W=1U AS=0.73P AD=0.73P PS=3.46U
+ PD=3.46U
* device instance $5051 r0 *1 578.565,496.74 nfet_05v0
M$5051 VSS \$184 \$I4698 VSS nfet_05v0 L=0.6U W=1U AS=0.73P AD=0.73P PS=3.46U
+ PD=3.46U
* device instance $5052 r0 *1 178.565,496.74 nfet_05v0
M$5052 VSS \$154 \$I4699 VSS nfet_05v0 L=0.6U W=1U AS=0.73P AD=0.73P PS=3.46U
+ PD=3.46U
* device instance $5053 r0 *1 138.565,574.74 nfet_05v0
M$5053 VSS \$267 \$I4700 VSS nfet_05v0 L=0.6U W=1U AS=0.73P AD=0.73P PS=3.46U
+ PD=3.46U
* device instance $5054 r0 *1 58.565,496.74 nfet_05v0
M$5054 VSS \$145 \$I4701 VSS nfet_05v0 L=0.6U W=1U AS=0.73P AD=0.73P PS=3.46U
+ PD=3.46U
* device instance $5055 r0 *1 98.565,496.74 nfet_05v0
M$5055 VSS \$148 \$I4702 VSS nfet_05v0 L=0.6U W=1U AS=0.73P AD=0.73P PS=3.46U
+ PD=3.46U
* device instance $5056 r0 *1 138.565,496.74 nfet_05v0
M$5056 VSS \$151 \$I4703 VSS nfet_05v0 L=0.6U W=1U AS=0.73P AD=0.73P PS=3.46U
+ PD=3.46U
* device instance $5057 r0 *1 218.565,496.74 nfet_05v0
M$5057 VSS \$157 \$I4704 VSS nfet_05v0 L=0.6U W=1U AS=0.73P AD=0.73P PS=3.46U
+ PD=3.46U
* device instance $5058 r0 *1 258.565,496.74 nfet_05v0
M$5058 VSS \$160 \$I4705 VSS nfet_05v0 L=0.6U W=1U AS=0.73P AD=0.73P PS=3.46U
+ PD=3.46U
* device instance $5059 r0 *1 298.565,496.74 nfet_05v0
M$5059 VSS \$163 \$I4706 VSS nfet_05v0 L=0.6U W=1U AS=0.73P AD=0.73P PS=3.46U
+ PD=3.46U
* device instance $5060 r0 *1 298.565,574.74 nfet_05v0
M$5060 VSS \$271 \$I4707 VSS nfet_05v0 L=0.6U W=1U AS=0.73P AD=0.73P PS=3.46U
+ PD=3.46U
* device instance $5061 r0 *1 258.565,262.74 nfet_05v0
M$5061 VSS \$92 \$I4708 VSS nfet_05v0 L=0.6U W=1U AS=0.73P AD=0.73P PS=3.46U
+ PD=3.46U
* device instance $5062 r0 *1 298.565,262.74 nfet_05v0
M$5062 VSS \$94 \$I4709 VSS nfet_05v0 L=0.6U W=1U AS=0.73P AD=0.73P PS=3.46U
+ PD=3.46U
* device instance $5063 r0 *1 138.565,262.74 nfet_05v0
M$5063 VSS \$86 \$I4710 VSS nfet_05v0 L=0.6U W=1U AS=0.73P AD=0.73P PS=3.46U
+ PD=3.46U
* device instance $5064 r0 *1 98.565,262.74 nfet_05v0
M$5064 VSS \$84 \$I4711 VSS nfet_05v0 L=0.6U W=1U AS=0.73P AD=0.73P PS=3.46U
+ PD=3.46U
* device instance $5065 r0 *1 258.565,574.74 nfet_05v0
M$5065 VSS \$270 \$I4712 VSS nfet_05v0 L=0.6U W=1U AS=0.73P AD=0.73P PS=3.46U
+ PD=3.46U
* device instance $5066 r0 *1 58.565,262.74 nfet_05v0
M$5066 VSS \$82 \$I4713 VSS nfet_05v0 L=0.6U W=1U AS=0.73P AD=0.73P PS=3.46U
+ PD=3.46U
* device instance $5067 r0 *1 178.565,418.74 nfet_05v0
M$5067 VSS \$155 \$I4714 VSS nfet_05v0 L=0.6U W=1U AS=0.73P AD=0.73P PS=3.46U
+ PD=3.46U
* device instance $5068 r0 *1 178.565,262.74 nfet_05v0
M$5068 VSS \$88 \$I4715 VSS nfet_05v0 L=0.6U W=1U AS=0.73P AD=0.73P PS=3.46U
+ PD=3.46U
* device instance $5069 r0 *1 218.565,262.74 nfet_05v0
M$5069 VSS \$90 \$I4716 VSS nfet_05v0 L=0.6U W=1U AS=0.73P AD=0.73P PS=3.46U
+ PD=3.46U
* device instance $5070 r0 *1 258.565,184.74 nfet_05v0
M$5070 VSS \$93 \$I4717 VSS nfet_05v0 L=0.6U W=1U AS=0.73P AD=0.73P PS=3.46U
+ PD=3.46U
* device instance $5071 r0 *1 458.565,574.74 nfet_05v0
M$5071 VSS \$275 \$I4718 VSS nfet_05v0 L=0.6U W=1U AS=0.73P AD=0.73P PS=3.46U
+ PD=3.46U
* device instance $5072 r0 *1 498.565,574.74 nfet_05v0
M$5072 VSS \$276 \$I4719 VSS nfet_05v0 L=0.6U W=1U AS=0.73P AD=0.73P PS=3.46U
+ PD=3.46U
* device instance $5073 r0 *1 378.565,340.74 nfet_05v0
M$5073 VSS \$171 \$I4720 VSS nfet_05v0 L=0.6U W=1U AS=0.73P AD=0.73P PS=3.46U
+ PD=3.46U
* device instance $5074 r0 *1 378.565,418.74 nfet_05v0
M$5074 VSS \$170 \$I4721 VSS nfet_05v0 L=0.6U W=1U AS=0.73P AD=0.73P PS=3.46U
+ PD=3.46U
* device instance $5075 r0 *1 498.565,418.74 nfet_05v0
M$5075 VSS \$179 \$I4722 VSS nfet_05v0 L=0.6U W=1U AS=0.73P AD=0.73P PS=3.46U
+ PD=3.46U
* device instance $5076 r0 *1 258.565,28.74 nfet_05v0
M$5076 VSS \$11 \$I4723 VSS nfet_05v0 L=0.6U W=1U AS=0.73P AD=0.73P PS=3.46U
+ PD=3.46U
* device instance $5077 r0 *1 498.565,340.74 nfet_05v0
M$5077 VSS \$180 \$I4724 VSS nfet_05v0 L=0.6U W=1U AS=0.73P AD=0.73P PS=3.46U
+ PD=3.46U
* device instance $5078 r0 *1 458.565,418.74 nfet_05v0
M$5078 VSS \$176 \$I4725 VSS nfet_05v0 L=0.6U W=1U AS=0.73P AD=0.73P PS=3.46U
+ PD=3.46U
* device instance $5079 r0 *1 418.565,418.74 nfet_05v0
M$5079 VSS \$173 \$I4726 VSS nfet_05v0 L=0.6U W=1U AS=0.73P AD=0.73P PS=3.46U
+ PD=3.46U
* device instance $5080 r0 *1 618.565,418.74 nfet_05v0
M$5080 VSS \$188 \$I4727 VSS nfet_05v0 L=0.6U W=1U AS=0.73P AD=0.73P PS=3.46U
+ PD=3.46U
* device instance $5081 r0 *1 578.565,418.74 nfet_05v0
M$5081 VSS \$185 \$I4728 VSS nfet_05v0 L=0.6U W=1U AS=0.73P AD=0.73P PS=3.46U
+ PD=3.46U
* device instance $5082 r0 *1 538.565,418.74 nfet_05v0
M$5082 VSS \$182 \$I4729 VSS nfet_05v0 L=0.6U W=1U AS=0.73P AD=0.73P PS=3.46U
+ PD=3.46U
* device instance $5083 r0 *1 538.565,574.74 nfet_05v0
M$5083 VSS \$277 \$I4730 VSS nfet_05v0 L=0.6U W=1U AS=0.73P AD=0.73P PS=3.46U
+ PD=3.46U
* device instance $5084 r0 *1 578.565,574.74 nfet_05v0
M$5084 VSS \$278 \$I4731 VSS nfet_05v0 L=0.6U W=1U AS=0.73P AD=0.73P PS=3.46U
+ PD=3.46U
* device instance $5085 r0 *1 338.565,496.74 nfet_05v0
M$5085 VSS \$166 \$I4732 VSS nfet_05v0 L=0.6U W=1U AS=0.73P AD=0.73P PS=3.46U
+ PD=3.46U
* device instance $5086 r0 *1 618.565,574.74 nfet_05v0
M$5086 VSS \$279 \$I4733 VSS nfet_05v0 L=0.6U W=1U AS=0.73P AD=0.73P PS=3.46U
+ PD=3.46U
* device instance $5087 r0 *1 218.565,28.74 nfet_05v0
M$5087 VSS \$10 \$I4734 VSS nfet_05v0 L=0.6U W=1U AS=0.73P AD=0.73P PS=3.46U
+ PD=3.46U
* device instance $5088 r0 *1 578.565,340.74 nfet_05v0
M$5088 VSS \$186 \$I4735 VSS nfet_05v0 L=0.6U W=1U AS=0.73P AD=0.73P PS=3.46U
+ PD=3.46U
* device instance $5089 r0 *1 658.565,418.74 nfet_05v0
M$5089 VSS \$191 \$I4736 VSS nfet_05v0 L=0.6U W=1U AS=0.73P AD=0.73P PS=3.46U
+ PD=3.46U
* device instance $5090 r0 *1 578.565,262.74 nfet_05v0
M$5090 VSS \$108 \$I4737 VSS nfet_05v0 L=0.6U W=1U AS=0.73P AD=0.73P PS=3.46U
+ PD=3.46U
* device instance $5091 r0 *1 618.565,262.74 nfet_05v0
M$5091 VSS \$110 \$I4738 VSS nfet_05v0 L=0.6U W=1U AS=0.73P AD=0.73P PS=3.46U
+ PD=3.46U
* device instance $5092 r0 *1 658.565,262.74 nfet_05v0
M$5092 VSS \$112 \$I4739 VSS nfet_05v0 L=0.6U W=1U AS=0.73P AD=0.73P PS=3.46U
+ PD=3.46U
* device instance $5093 r0 *1 538.565,262.74 nfet_05v0
M$5093 VSS \$106 \$I4740 VSS nfet_05v0 L=0.6U W=1U AS=0.73P AD=0.73P PS=3.46U
+ PD=3.46U
* device instance $5094 r0 *1 498.565,262.74 nfet_05v0
M$5094 VSS \$104 \$I4741 VSS nfet_05v0 L=0.6U W=1U AS=0.73P AD=0.73P PS=3.46U
+ PD=3.46U
* device instance $5095 r0 *1 658.565,340.74 nfet_05v0
M$5095 VSS \$192 \$I4742 VSS nfet_05v0 L=0.6U W=1U AS=0.73P AD=0.73P PS=3.46U
+ PD=3.46U
* device instance $5096 r0 *1 458.565,262.74 nfet_05v0
M$5096 VSS \$102 \$I4743 VSS nfet_05v0 L=0.6U W=1U AS=0.73P AD=0.73P PS=3.46U
+ PD=3.46U
* device instance $5097 r0 *1 378.565,262.74 nfet_05v0
M$5097 VSS \$98 \$I4744 VSS nfet_05v0 L=0.6U W=1U AS=0.73P AD=0.73P PS=3.46U
+ PD=3.46U
* device instance $5098 r0 *1 618.565,340.74 nfet_05v0
M$5098 VSS \$189 \$I4745 VSS nfet_05v0 L=0.6U W=1U AS=0.73P AD=0.73P PS=3.46U
+ PD=3.46U
* device instance $5099 r0 *1 418.565,262.74 nfet_05v0
M$5099 VSS \$100 \$I4746 VSS nfet_05v0 L=0.6U W=1U AS=0.73P AD=0.73P PS=3.46U
+ PD=3.46U
* device instance $5100 r0 *1 538.565,340.74 nfet_05v0
M$5100 VSS \$183 \$I4747 VSS nfet_05v0 L=0.6U W=1U AS=0.73P AD=0.73P PS=3.46U
+ PD=3.46U
* device instance $5101 r0 *1 658.565,574.74 nfet_05v0
M$5101 VSS \$280 \$I4748 VSS nfet_05v0 L=0.6U W=1U AS=0.73P AD=0.73P PS=3.46U
+ PD=3.46U
* device instance $5102 r0 *1 98.565,574.74 nfet_05v0
M$5102 VSS \$266 \$I4749 VSS nfet_05v0 L=0.6U W=1U AS=0.73P AD=0.73P PS=3.46U
+ PD=3.46U
* device instance $5103 r0 *1 98.565,418.74 nfet_05v0
M$5103 VSS \$149 \$I4750 VSS nfet_05v0 L=0.6U W=1U AS=0.73P AD=0.73P PS=3.46U
+ PD=3.46U
* device instance $5104 r0 *1 58.565,418.74 nfet_05v0
M$5104 VSS \$146 \$I4751 VSS nfet_05v0 L=0.6U W=1U AS=0.73P AD=0.73P PS=3.46U
+ PD=3.46U
* device instance $5105 r0 *1 138.565,28.74 nfet_05v0
M$5105 VSS \$8 \$I4752 VSS nfet_05v0 L=0.6U W=1U AS=0.73P AD=0.73P PS=3.46U
+ PD=3.46U
* device instance $5106 r0 *1 58.565,106.74 nfet_05v0
M$5106 VSS \$25 \$I4753 VSS nfet_05v0 L=0.6U W=1U AS=0.73P AD=0.73P PS=3.46U
+ PD=3.46U
* device instance $5107 r0 *1 98.565,106.74 nfet_05v0
M$5107 VSS \$26 \$I4754 VSS nfet_05v0 L=0.6U W=1U AS=0.73P AD=0.73P PS=3.46U
+ PD=3.46U
* device instance $5108 r0 *1 138.565,106.74 nfet_05v0
M$5108 VSS \$27 \$I4755 VSS nfet_05v0 L=0.6U W=1U AS=0.73P AD=0.73P PS=3.46U
+ PD=3.46U
* device instance $5109 r0 *1 458.565,28.74 nfet_05v0
M$5109 VSS \$16 \$I4756 VSS nfet_05v0 L=0.6U W=1U AS=0.73P AD=0.73P PS=3.46U
+ PD=3.46U
* device instance $5110 r0 *1 98.565,28.74 nfet_05v0
M$5110 VSS \$7 \$I4757 VSS nfet_05v0 L=0.6U W=1U AS=0.73P AD=0.73P PS=3.46U
+ PD=3.46U
* device instance $5111 r0 *1 58.565,184.74 nfet_05v0
M$5111 VSS \$83 \$I4758 VSS nfet_05v0 L=0.6U W=1U AS=0.73P AD=0.73P PS=3.46U
+ PD=3.46U
* device instance $5112 r0 *1 98.565,184.74 nfet_05v0
M$5112 VSS \$85 \$I4759 VSS nfet_05v0 L=0.6U W=1U AS=0.73P AD=0.73P PS=3.46U
+ PD=3.46U
* device instance $5113 r0 *1 138.565,184.74 nfet_05v0
M$5113 VSS \$87 \$I4760 VSS nfet_05v0 L=0.6U W=1U AS=0.73P AD=0.73P PS=3.46U
+ PD=3.46U
* device instance $5114 r0 *1 498.565,28.74 nfet_05v0
M$5114 VSS \$17 \$I4761 VSS nfet_05v0 L=0.6U W=1U AS=0.73P AD=0.73P PS=3.46U
+ PD=3.46U
* device instance $5115 r0 *1 298.565,28.74 nfet_05v0
M$5115 VSS \$12 \$I4762 VSS nfet_05v0 L=0.6U W=1U AS=0.73P AD=0.73P PS=3.46U
+ PD=3.46U
* device instance $5116 r0 *1 418.565,574.74 nfet_05v0
M$5116 VSS \$274 \$I4763 VSS nfet_05v0 L=0.6U W=1U AS=0.73P AD=0.73P PS=3.46U
+ PD=3.46U
* device instance $5117 r0 *1 418.565,340.74 nfet_05v0
M$5117 VSS \$174 \$I4764 VSS nfet_05v0 L=0.6U W=1U AS=0.73P AD=0.73P PS=3.46U
+ PD=3.46U
* device instance $5118 r0 *1 218.565,184.74 nfet_05v0
M$5118 VSS \$91 \$I4765 VSS nfet_05v0 L=0.6U W=1U AS=0.73P AD=0.73P PS=3.46U
+ PD=3.46U
* device instance $5119 r0 *1 298.565,184.74 nfet_05v0
M$5119 VSS \$95 \$I4766 VSS nfet_05v0 L=0.6U W=1U AS=0.73P AD=0.73P PS=3.46U
+ PD=3.46U
* device instance $5120 r0 *1 298.565,106.74 nfet_05v0
M$5120 VSS \$31 \$I4767 VSS nfet_05v0 L=0.6U W=1U AS=0.73P AD=0.73P PS=3.46U
+ PD=3.46U
* device instance $5121 r0 *1 458.565,340.74 nfet_05v0
M$5121 VSS \$177 \$I4768 VSS nfet_05v0 L=0.6U W=1U AS=0.73P AD=0.73P PS=3.46U
+ PD=3.46U
* device instance $5122 r0 *1 378.565,574.74 nfet_05v0
M$5122 VSS \$273 \$I4769 VSS nfet_05v0 L=0.6U W=1U AS=0.73P AD=0.73P PS=3.46U
+ PD=3.46U
* device instance $5123 r0 *1 218.565,106.74 nfet_05v0
M$5123 VSS \$29 \$I4770 VSS nfet_05v0 L=0.6U W=1U AS=0.73P AD=0.73P PS=3.46U
+ PD=3.46U
* device instance $5124 r0 *1 258.565,106.74 nfet_05v0
M$5124 VSS \$30 \$I4771 VSS nfet_05v0 L=0.6U W=1U AS=0.73P AD=0.73P PS=3.46U
+ PD=3.46U
* device instance $5125 r0 *1 418.565,184.74 nfet_05v0
M$5125 VSS \$101 \$I4772 VSS nfet_05v0 L=0.6U W=1U AS=0.73P AD=0.73P PS=3.46U
+ PD=3.46U
* device instance $5126 r0 *1 458.565,184.74 nfet_05v0
M$5126 VSS \$103 \$I4773 VSS nfet_05v0 L=0.6U W=1U AS=0.73P AD=0.73P PS=3.46U
+ PD=3.46U
* device instance $5127 r0 *1 498.565,184.74 nfet_05v0
M$5127 VSS \$105 \$I4774 VSS nfet_05v0 L=0.6U W=1U AS=0.73P AD=0.73P PS=3.46U
+ PD=3.46U
* device instance $5128 r0 *1 418.565,106.74 nfet_05v0
M$5128 VSS \$34 \$I4775 VSS nfet_05v0 L=0.6U W=1U AS=0.73P AD=0.73P PS=3.46U
+ PD=3.46U
* device instance $5129 r0 *1 458.565,106.74 nfet_05v0
M$5129 VSS \$35 \$I4776 VSS nfet_05v0 L=0.6U W=1U AS=0.73P AD=0.73P PS=3.46U
+ PD=3.46U
* device instance $5130 r0 *1 498.565,106.74 nfet_05v0
M$5130 VSS \$36 \$I4777 VSS nfet_05v0 L=0.6U W=1U AS=0.73P AD=0.73P PS=3.46U
+ PD=3.46U
* device instance $5131 r0 *1 178.565,574.74 nfet_05v0
M$5131 VSS \$268 \$I4778 VSS nfet_05v0 L=0.6U W=1U AS=0.73P AD=0.73P PS=3.46U
+ PD=3.46U
* device instance $5132 r0 *1 418.565,28.74 nfet_05v0
M$5132 VSS \$15 \$I4779 VSS nfet_05v0 L=0.6U W=1U AS=0.73P AD=0.73P PS=3.46U
+ PD=3.46U
* device instance $5133 r0 *1 378.565,184.74 nfet_05v0
M$5133 VSS \$99 \$I4780 VSS nfet_05v0 L=0.6U W=1U AS=0.73P AD=0.73P PS=3.46U
+ PD=3.46U
* device instance $5134 r90 *1 55.025,24.715 pfet_05v0
M$5134 \$4 \$I4653 \$I513 VDD_DEC pfet_05v0 L=0.5U W=6U AS=3.14P AD=3.14P
+ PS=11.14U PD=11.14U
* device instance $5137 r90 *1 175.025,102.715 pfet_05v0
M$5137 \$4 \$I4654 \$I512 VDD_DEC pfet_05v0 L=0.5U W=6U AS=3.14P AD=3.14P
+ PS=11.14U PD=11.14U
* device instance $5140 r90 *1 175.025,24.715 pfet_05v0
M$5140 \$4 \$I4655 \$I511 VDD_DEC pfet_05v0 L=0.5U W=6U AS=3.14P AD=3.14P
+ PS=11.14U PD=11.14U
* device instance $5143 r90 *1 215.025,570.715 pfet_05v0
M$5143 \$4 \$I4656 \$I510 VDD_DEC pfet_05v0 L=0.5U W=6U AS=3.14P AD=3.14P
+ PS=11.14U PD=11.14U
* device instance $5146 r90 *1 295.025,336.715 pfet_05v0
M$5146 \$4 \$I4657 \$I509 VDD_DEC pfet_05v0 L=0.5U W=6U AS=3.14P AD=3.14P
+ PS=11.14U PD=11.14U
* device instance $5149 r90 *1 535.025,24.715 pfet_05v0
M$5149 \$4 \$I4658 \$I508 VDD_DEC pfet_05v0 L=0.5U W=6U AS=3.14P AD=3.14P
+ PS=11.14U PD=11.14U
* device instance $5152 r90 *1 175.025,336.715 pfet_05v0
M$5152 \$4 \$I4659 \$I507 VDD_DEC pfet_05v0 L=0.5U W=6U AS=3.14P AD=3.14P
+ PS=11.14U PD=11.14U
* device instance $5155 r90 *1 255.025,336.715 pfet_05v0
M$5155 \$4 \$I4660 \$I506 VDD_DEC pfet_05v0 L=0.5U W=6U AS=3.14P AD=3.14P
+ PS=11.14U PD=11.14U
* device instance $5158 r90 *1 655.025,24.715 pfet_05v0
M$5158 \$4 \$I4661 \$I505 VDD_DEC pfet_05v0 L=0.5U W=6U AS=3.14P AD=3.14P
+ PS=11.14U PD=11.14U
* device instance $5161 r90 *1 295.025,414.715 pfet_05v0
M$5161 \$4 \$I4662 \$I504 VDD_DEC pfet_05v0 L=0.5U W=6U AS=3.14P AD=3.14P
+ PS=11.14U PD=11.14U
* device instance $5164 r90 *1 175.025,180.715 pfet_05v0
M$5164 \$4 \$I4663 \$I503 VDD_DEC pfet_05v0 L=0.5U W=6U AS=3.14P AD=3.14P
+ PS=11.14U PD=11.14U
* device instance $5167 r90 *1 655.025,180.715 pfet_05v0
M$5167 \$4 \$I4664 \$I502 VDD_DEC pfet_05v0 L=0.5U W=6U AS=3.14P AD=3.14P
+ PS=11.14U PD=11.14U
* device instance $5170 r90 *1 55.025,570.715 pfet_05v0
M$5170 \$4 \$I4665 \$I501 VDD_DEC pfet_05v0 L=0.5U W=6U AS=3.14P AD=3.14P
+ PS=11.14U PD=11.14U
* device instance $5173 r90 *1 615.025,180.715 pfet_05v0
M$5173 \$4 \$I4666 \$I500 VDD_DEC pfet_05v0 L=0.5U W=6U AS=3.14P AD=3.14P
+ PS=11.14U PD=11.14U
* device instance $5176 r90 *1 575.025,180.715 pfet_05v0
M$5176 \$4 \$I4667 \$I499 VDD_DEC pfet_05v0 L=0.5U W=6U AS=3.14P AD=3.14P
+ PS=11.14U PD=11.14U
* device instance $5179 r90 *1 535.025,180.715 pfet_05v0
M$5179 \$4 \$I4668 \$I498 VDD_DEC pfet_05v0 L=0.5U W=6U AS=3.14P AD=3.14P
+ PS=11.14U PD=11.14U
* device instance $5182 r90 *1 375.025,102.715 pfet_05v0
M$5182 \$4 \$I4669 \$I497 VDD_DEC pfet_05v0 L=0.5U W=6U AS=3.14P AD=3.14P
+ PS=11.14U PD=11.14U
* device instance $5185 r90 *1 95.025,336.715 pfet_05v0
M$5185 \$4 \$I4670 \$I496 VDD_DEC pfet_05v0 L=0.5U W=6U AS=3.14P AD=3.14P
+ PS=11.14U PD=11.14U
* device instance $5188 r90 *1 375.025,24.715 pfet_05v0
M$5188 \$4 \$I4671 \$I495 VDD_DEC pfet_05v0 L=0.5U W=6U AS=3.14P AD=3.14P
+ PS=11.14U PD=11.14U
* device instance $5191 r90 *1 55.025,336.715 pfet_05v0
M$5191 \$4 \$I4672 \$I494 VDD_DEC pfet_05v0 L=0.5U W=6U AS=3.14P AD=3.14P
+ PS=11.14U PD=11.14U
* device instance $5194 r90 *1 575.025,24.715 pfet_05v0
M$5194 \$4 \$I4673 \$I493 VDD_DEC pfet_05v0 L=0.5U W=6U AS=3.14P AD=3.14P
+ PS=11.14U PD=11.14U
* device instance $5197 r90 *1 615.025,24.715 pfet_05v0
M$5197 \$4 \$I4674 \$I492 VDD_DEC pfet_05v0 L=0.5U W=6U AS=3.14P AD=3.14P
+ PS=11.14U PD=11.14U
* device instance $5200 r90 *1 535.025,102.715 pfet_05v0
M$5200 \$4 \$I4675 \$I491 VDD_DEC pfet_05v0 L=0.5U W=6U AS=3.14P AD=3.14P
+ PS=11.14U PD=11.14U
* device instance $5203 r90 *1 575.025,102.715 pfet_05v0
M$5203 \$4 \$I4676 \$I490 VDD_DEC pfet_05v0 L=0.5U W=6U AS=3.14P AD=3.14P
+ PS=11.14U PD=11.14U
* device instance $5206 r90 *1 255.025,414.715 pfet_05v0
M$5206 \$4 \$I4677 \$I489 VDD_DEC pfet_05v0 L=0.5U W=6U AS=3.14P AD=3.14P
+ PS=11.14U PD=11.14U
* device instance $5209 r90 *1 615.025,102.715 pfet_05v0
M$5209 \$4 \$I4678 \$I488 VDD_DEC pfet_05v0 L=0.5U W=6U AS=3.14P AD=3.14P
+ PS=11.14U PD=11.14U
* device instance $5212 r90 *1 135.025,414.715 pfet_05v0
M$5212 \$4 \$I4679 \$I487 VDD_DEC pfet_05v0 L=0.5U W=6U AS=3.14P AD=3.14P
+ PS=11.14U PD=11.14U
* device instance $5215 r90 *1 655.025,102.715 pfet_05v0
M$5215 \$4 \$I4680 \$I486 VDD_DEC pfet_05v0 L=0.5U W=6U AS=3.14P AD=3.14P
+ PS=11.14U PD=11.14U
* device instance $5218 r90 *1 215.025,336.715 pfet_05v0
M$5218 \$4 \$I4681 \$I485 VDD_DEC pfet_05v0 L=0.5U W=6U AS=3.14P AD=3.14P
+ PS=11.14U PD=11.14U
* device instance $5221 r90 *1 215.025,414.715 pfet_05v0
M$5221 \$4 \$I4682 \$I484 VDD_DEC pfet_05v0 L=0.5U W=6U AS=3.14P AD=3.14P
+ PS=11.14U PD=11.14U
* device instance $5224 r90 *1 335.025,570.715 pfet_05v0
M$5224 \$4 \$I4683 \$I483 VDD_DEC pfet_05v0 L=0.5U W=6U AS=3.14P AD=3.14P
+ PS=11.14U PD=11.14U
* device instance $5227 r90 *1 135.025,336.715 pfet_05v0
M$5227 \$4 \$I4684 \$I482 VDD_DEC pfet_05v0 L=0.5U W=6U AS=3.14P AD=3.14P
+ PS=11.14U PD=11.14U
* device instance $5230 r90 *1 335.025,414.715 pfet_05v0
M$5230 \$4 \$I4685 \$I481 VDD_DEC pfet_05v0 L=0.5U W=6U AS=3.14P AD=3.14P
+ PS=11.14U PD=11.14U
* device instance $5233 r90 *1 335.025,336.715 pfet_05v0
M$5233 \$4 \$I4686 \$I480 VDD_DEC pfet_05v0 L=0.5U W=6U AS=3.14P AD=3.14P
+ PS=11.14U PD=11.14U
* device instance $5236 r90 *1 335.025,258.715 pfet_05v0
M$5236 \$4 \$I4687 \$I479 VDD_DEC pfet_05v0 L=0.5U W=6U AS=3.14P AD=3.14P
+ PS=11.14U PD=11.14U
* device instance $5239 r90 *1 335.025,180.715 pfet_05v0
M$5239 \$4 \$I4688 \$I478 VDD_DEC pfet_05v0 L=0.5U W=6U AS=3.14P AD=3.14P
+ PS=11.14U PD=11.14U
* device instance $5242 r90 *1 335.025,102.715 pfet_05v0
M$5242 \$4 \$I4689 \$I477 VDD_DEC pfet_05v0 L=0.5U W=6U AS=3.14P AD=3.14P
+ PS=11.14U PD=11.14U
* device instance $5245 r90 *1 335.025,24.715 pfet_05v0
M$5245 \$4 \$I4690 \$I476 VDD_DEC pfet_05v0 L=0.5U W=6U AS=3.14P AD=3.14P
+ PS=11.14U PD=11.14U
* device instance $5248 r90 *1 375.025,492.715 pfet_05v0
M$5248 \$4 \$I4691 \$I475 VDD_DEC pfet_05v0 L=0.5U W=6U AS=3.14P AD=3.14P
+ PS=11.14U PD=11.14U
* device instance $5251 r90 *1 415.025,492.715 pfet_05v0
M$5251 \$4 \$I4692 \$I474 VDD_DEC pfet_05v0 L=0.5U W=6U AS=3.14P AD=3.14P
+ PS=11.14U PD=11.14U
* device instance $5254 r90 *1 455.025,492.715 pfet_05v0
M$5254 \$4 \$I4693 \$I473 VDD_DEC pfet_05v0 L=0.5U W=6U AS=3.14P AD=3.14P
+ PS=11.14U PD=11.14U
* device instance $5257 r90 *1 495.025,492.715 pfet_05v0
M$5257 \$4 \$I4694 \$I472 VDD_DEC pfet_05v0 L=0.5U W=6U AS=3.14P AD=3.14P
+ PS=11.14U PD=11.14U
* device instance $5260 r90 *1 615.025,492.715 pfet_05v0
M$5260 \$4 \$I4695 \$I471 VDD_DEC pfet_05v0 L=0.5U W=6U AS=3.14P AD=3.14P
+ PS=11.14U PD=11.14U
* device instance $5263 r90 *1 655.025,492.715 pfet_05v0
M$5263 \$4 \$I4696 \$I470 VDD_DEC pfet_05v0 L=0.5U W=6U AS=3.14P AD=3.14P
+ PS=11.14U PD=11.14U
* device instance $5266 r90 *1 535.025,492.715 pfet_05v0
M$5266 \$4 \$I4697 \$I469 VDD_DEC pfet_05v0 L=0.5U W=6U AS=3.14P AD=3.14P
+ PS=11.14U PD=11.14U
* device instance $5269 r90 *1 575.025,492.715 pfet_05v0
M$5269 \$4 \$I4698 \$I468 VDD_DEC pfet_05v0 L=0.5U W=6U AS=3.14P AD=3.14P
+ PS=11.14U PD=11.14U
* device instance $5272 r90 *1 175.025,492.715 pfet_05v0
M$5272 \$4 \$I4699 \$I467 VDD_DEC pfet_05v0 L=0.5U W=6U AS=3.14P AD=3.14P
+ PS=11.14U PD=11.14U
* device instance $5275 r90 *1 135.025,570.715 pfet_05v0
M$5275 \$4 \$I4700 \$I466 VDD_DEC pfet_05v0 L=0.5U W=6U AS=3.14P AD=3.14P
+ PS=11.14U PD=11.14U
* device instance $5278 r90 *1 55.025,492.715 pfet_05v0
M$5278 \$4 \$I4701 \$I465 VDD_DEC pfet_05v0 L=0.5U W=6U AS=3.14P AD=3.14P
+ PS=11.14U PD=11.14U
* device instance $5281 r90 *1 95.025,492.715 pfet_05v0
M$5281 \$4 \$I4702 \$I464 VDD_DEC pfet_05v0 L=0.5U W=6U AS=3.14P AD=3.14P
+ PS=11.14U PD=11.14U
* device instance $5284 r90 *1 135.025,492.715 pfet_05v0
M$5284 \$4 \$I4703 \$I463 VDD_DEC pfet_05v0 L=0.5U W=6U AS=3.14P AD=3.14P
+ PS=11.14U PD=11.14U
* device instance $5287 r90 *1 215.025,492.715 pfet_05v0
M$5287 \$4 \$I4704 \$I462 VDD_DEC pfet_05v0 L=0.5U W=6U AS=3.14P AD=3.14P
+ PS=11.14U PD=11.14U
* device instance $5290 r90 *1 255.025,492.715 pfet_05v0
M$5290 \$4 \$I4705 \$I461 VDD_DEC pfet_05v0 L=0.5U W=6U AS=3.14P AD=3.14P
+ PS=11.14U PD=11.14U
* device instance $5293 r90 *1 295.025,492.715 pfet_05v0
M$5293 \$4 \$I4706 \$I460 VDD_DEC pfet_05v0 L=0.5U W=6U AS=3.14P AD=3.14P
+ PS=11.14U PD=11.14U
* device instance $5296 r90 *1 295.025,570.715 pfet_05v0
M$5296 \$4 \$I4707 \$I459 VDD_DEC pfet_05v0 L=0.5U W=6U AS=3.14P AD=3.14P
+ PS=11.14U PD=11.14U
* device instance $5299 r90 *1 255.025,258.715 pfet_05v0
M$5299 \$4 \$I4708 \$I458 VDD_DEC pfet_05v0 L=0.5U W=6U AS=3.14P AD=3.14P
+ PS=11.14U PD=11.14U
* device instance $5302 r90 *1 295.025,258.715 pfet_05v0
M$5302 \$4 \$I4709 \$I457 VDD_DEC pfet_05v0 L=0.5U W=6U AS=3.14P AD=3.14P
+ PS=11.14U PD=11.14U
* device instance $5305 r90 *1 135.025,258.715 pfet_05v0
M$5305 \$4 \$I4710 \$I456 VDD_DEC pfet_05v0 L=0.5U W=6U AS=3.14P AD=3.14P
+ PS=11.14U PD=11.14U
* device instance $5308 r90 *1 95.025,258.715 pfet_05v0
M$5308 \$4 \$I4711 \$I455 VDD_DEC pfet_05v0 L=0.5U W=6U AS=3.14P AD=3.14P
+ PS=11.14U PD=11.14U
* device instance $5311 r90 *1 255.025,570.715 pfet_05v0
M$5311 \$4 \$I4712 \$I454 VDD_DEC pfet_05v0 L=0.5U W=6U AS=3.14P AD=3.14P
+ PS=11.14U PD=11.14U
* device instance $5314 r90 *1 55.025,258.715 pfet_05v0
M$5314 \$4 \$I4713 \$I453 VDD_DEC pfet_05v0 L=0.5U W=6U AS=3.14P AD=3.14P
+ PS=11.14U PD=11.14U
* device instance $5317 r90 *1 175.025,414.715 pfet_05v0
M$5317 \$4 \$I4714 \$I452 VDD_DEC pfet_05v0 L=0.5U W=6U AS=3.14P AD=3.14P
+ PS=11.14U PD=11.14U
* device instance $5320 r90 *1 175.025,258.715 pfet_05v0
M$5320 \$4 \$I4715 \$I451 VDD_DEC pfet_05v0 L=0.5U W=6U AS=3.14P AD=3.14P
+ PS=11.14U PD=11.14U
* device instance $5323 r90 *1 215.025,258.715 pfet_05v0
M$5323 \$4 \$I4716 \$I450 VDD_DEC pfet_05v0 L=0.5U W=6U AS=3.14P AD=3.14P
+ PS=11.14U PD=11.14U
* device instance $5326 r90 *1 255.025,180.715 pfet_05v0
M$5326 \$4 \$I4717 \$I449 VDD_DEC pfet_05v0 L=0.5U W=6U AS=3.14P AD=3.14P
+ PS=11.14U PD=11.14U
* device instance $5329 r90 *1 455.025,570.715 pfet_05v0
M$5329 \$4 \$I4718 \$I448 VDD_DEC pfet_05v0 L=0.5U W=6U AS=3.14P AD=3.14P
+ PS=11.14U PD=11.14U
* device instance $5332 r90 *1 495.025,570.715 pfet_05v0
M$5332 \$4 \$I4719 \$I447 VDD_DEC pfet_05v0 L=0.5U W=6U AS=3.14P AD=3.14P
+ PS=11.14U PD=11.14U
* device instance $5335 r90 *1 375.025,336.715 pfet_05v0
M$5335 \$4 \$I4720 \$I446 VDD_DEC pfet_05v0 L=0.5U W=6U AS=3.14P AD=3.14P
+ PS=11.14U PD=11.14U
* device instance $5338 r90 *1 375.025,414.715 pfet_05v0
M$5338 \$4 \$I4721 \$I445 VDD_DEC pfet_05v0 L=0.5U W=6U AS=3.14P AD=3.14P
+ PS=11.14U PD=11.14U
* device instance $5341 r90 *1 495.025,414.715 pfet_05v0
M$5341 \$4 \$I4722 \$I444 VDD_DEC pfet_05v0 L=0.5U W=6U AS=3.14P AD=3.14P
+ PS=11.14U PD=11.14U
* device instance $5344 r90 *1 255.025,24.715 pfet_05v0
M$5344 \$4 \$I4723 \$I443 VDD_DEC pfet_05v0 L=0.5U W=6U AS=3.14P AD=3.14P
+ PS=11.14U PD=11.14U
* device instance $5347 r90 *1 495.025,336.715 pfet_05v0
M$5347 \$4 \$I4724 \$I442 VDD_DEC pfet_05v0 L=0.5U W=6U AS=3.14P AD=3.14P
+ PS=11.14U PD=11.14U
* device instance $5350 r90 *1 455.025,414.715 pfet_05v0
M$5350 \$4 \$I4725 \$I441 VDD_DEC pfet_05v0 L=0.5U W=6U AS=3.14P AD=3.14P
+ PS=11.14U PD=11.14U
* device instance $5353 r90 *1 415.025,414.715 pfet_05v0
M$5353 \$4 \$I4726 \$I440 VDD_DEC pfet_05v0 L=0.5U W=6U AS=3.14P AD=3.14P
+ PS=11.14U PD=11.14U
* device instance $5356 r90 *1 615.025,414.715 pfet_05v0
M$5356 \$4 \$I4727 \$I439 VDD_DEC pfet_05v0 L=0.5U W=6U AS=3.14P AD=3.14P
+ PS=11.14U PD=11.14U
* device instance $5359 r90 *1 575.025,414.715 pfet_05v0
M$5359 \$4 \$I4728 \$I438 VDD_DEC pfet_05v0 L=0.5U W=6U AS=3.14P AD=3.14P
+ PS=11.14U PD=11.14U
* device instance $5362 r90 *1 535.025,414.715 pfet_05v0
M$5362 \$4 \$I4729 \$I437 VDD_DEC pfet_05v0 L=0.5U W=6U AS=3.14P AD=3.14P
+ PS=11.14U PD=11.14U
* device instance $5365 r90 *1 535.025,570.715 pfet_05v0
M$5365 \$4 \$I4730 \$I436 VDD_DEC pfet_05v0 L=0.5U W=6U AS=3.14P AD=3.14P
+ PS=11.14U PD=11.14U
* device instance $5368 r90 *1 575.025,570.715 pfet_05v0
M$5368 \$4 \$I4731 \$I435 VDD_DEC pfet_05v0 L=0.5U W=6U AS=3.14P AD=3.14P
+ PS=11.14U PD=11.14U
* device instance $5371 r90 *1 335.025,492.715 pfet_05v0
M$5371 \$4 \$I4732 \$I434 VDD_DEC pfet_05v0 L=0.5U W=6U AS=3.14P AD=3.14P
+ PS=11.14U PD=11.14U
* device instance $5374 r90 *1 615.025,570.715 pfet_05v0
M$5374 \$4 \$I4733 \$I433 VDD_DEC pfet_05v0 L=0.5U W=6U AS=3.14P AD=3.14P
+ PS=11.14U PD=11.14U
* device instance $5377 r90 *1 215.025,24.715 pfet_05v0
M$5377 \$4 \$I4734 \$I432 VDD_DEC pfet_05v0 L=0.5U W=6U AS=3.14P AD=3.14P
+ PS=11.14U PD=11.14U
* device instance $5380 r90 *1 575.025,336.715 pfet_05v0
M$5380 \$4 \$I4735 \$I431 VDD_DEC pfet_05v0 L=0.5U W=6U AS=3.14P AD=3.14P
+ PS=11.14U PD=11.14U
* device instance $5383 r90 *1 655.025,414.715 pfet_05v0
M$5383 \$4 \$I4736 \$I430 VDD_DEC pfet_05v0 L=0.5U W=6U AS=3.14P AD=3.14P
+ PS=11.14U PD=11.14U
* device instance $5386 r90 *1 575.025,258.715 pfet_05v0
M$5386 \$4 \$I4737 \$I429 VDD_DEC pfet_05v0 L=0.5U W=6U AS=3.14P AD=3.14P
+ PS=11.14U PD=11.14U
* device instance $5389 r90 *1 615.025,258.715 pfet_05v0
M$5389 \$4 \$I4738 \$I428 VDD_DEC pfet_05v0 L=0.5U W=6U AS=3.14P AD=3.14P
+ PS=11.14U PD=11.14U
* device instance $5392 r90 *1 655.025,258.715 pfet_05v0
M$5392 \$4 \$I4739 \$I427 VDD_DEC pfet_05v0 L=0.5U W=6U AS=3.14P AD=3.14P
+ PS=11.14U PD=11.14U
* device instance $5395 r90 *1 535.025,258.715 pfet_05v0
M$5395 \$4 \$I4740 \$I426 VDD_DEC pfet_05v0 L=0.5U W=6U AS=3.14P AD=3.14P
+ PS=11.14U PD=11.14U
* device instance $5398 r90 *1 495.025,258.715 pfet_05v0
M$5398 \$4 \$I4741 \$I425 VDD_DEC pfet_05v0 L=0.5U W=6U AS=3.14P AD=3.14P
+ PS=11.14U PD=11.14U
* device instance $5401 r90 *1 655.025,336.715 pfet_05v0
M$5401 \$4 \$I4742 \$I424 VDD_DEC pfet_05v0 L=0.5U W=6U AS=3.14P AD=3.14P
+ PS=11.14U PD=11.14U
* device instance $5404 r90 *1 455.025,258.715 pfet_05v0
M$5404 \$4 \$I4743 \$I423 VDD_DEC pfet_05v0 L=0.5U W=6U AS=3.14P AD=3.14P
+ PS=11.14U PD=11.14U
* device instance $5407 r90 *1 375.025,258.715 pfet_05v0
M$5407 \$4 \$I4744 \$I422 VDD_DEC pfet_05v0 L=0.5U W=6U AS=3.14P AD=3.14P
+ PS=11.14U PD=11.14U
* device instance $5410 r90 *1 615.025,336.715 pfet_05v0
M$5410 \$4 \$I4745 \$I421 VDD_DEC pfet_05v0 L=0.5U W=6U AS=3.14P AD=3.14P
+ PS=11.14U PD=11.14U
* device instance $5413 r90 *1 415.025,258.715 pfet_05v0
M$5413 \$4 \$I4746 \$I420 VDD_DEC pfet_05v0 L=0.5U W=6U AS=3.14P AD=3.14P
+ PS=11.14U PD=11.14U
* device instance $5416 r90 *1 535.025,336.715 pfet_05v0
M$5416 \$4 \$I4747 \$I419 VDD_DEC pfet_05v0 L=0.5U W=6U AS=3.14P AD=3.14P
+ PS=11.14U PD=11.14U
* device instance $5419 r90 *1 655.025,570.715 pfet_05v0
M$5419 \$4 \$I4748 \$I418 VDD_DEC pfet_05v0 L=0.5U W=6U AS=3.14P AD=3.14P
+ PS=11.14U PD=11.14U
* device instance $5422 r90 *1 95.025,570.715 pfet_05v0
M$5422 \$4 \$I4749 \$I417 VDD_DEC pfet_05v0 L=0.5U W=6U AS=3.14P AD=3.14P
+ PS=11.14U PD=11.14U
* device instance $5425 r90 *1 95.025,414.715 pfet_05v0
M$5425 \$4 \$I4750 \$I416 VDD_DEC pfet_05v0 L=0.5U W=6U AS=3.14P AD=3.14P
+ PS=11.14U PD=11.14U
* device instance $5428 r90 *1 55.025,414.715 pfet_05v0
M$5428 \$4 \$I4751 \$I415 VDD_DEC pfet_05v0 L=0.5U W=6U AS=3.14P AD=3.14P
+ PS=11.14U PD=11.14U
* device instance $5431 r90 *1 135.025,24.715 pfet_05v0
M$5431 \$4 \$I4752 \$I414 VDD_DEC pfet_05v0 L=0.5U W=6U AS=3.14P AD=3.14P
+ PS=11.14U PD=11.14U
* device instance $5434 r90 *1 55.025,102.715 pfet_05v0
M$5434 \$4 \$I4753 \$I413 VDD_DEC pfet_05v0 L=0.5U W=6U AS=3.14P AD=3.14P
+ PS=11.14U PD=11.14U
* device instance $5437 r90 *1 95.025,102.715 pfet_05v0
M$5437 \$4 \$I4754 \$I412 VDD_DEC pfet_05v0 L=0.5U W=6U AS=3.14P AD=3.14P
+ PS=11.14U PD=11.14U
* device instance $5440 r90 *1 135.025,102.715 pfet_05v0
M$5440 \$4 \$I4755 \$I411 VDD_DEC pfet_05v0 L=0.5U W=6U AS=3.14P AD=3.14P
+ PS=11.14U PD=11.14U
* device instance $5443 r90 *1 455.025,24.715 pfet_05v0
M$5443 \$4 \$I4756 \$I410 VDD_DEC pfet_05v0 L=0.5U W=6U AS=3.14P AD=3.14P
+ PS=11.14U PD=11.14U
* device instance $5446 r90 *1 95.025,24.715 pfet_05v0
M$5446 \$4 \$I4757 \$I409 VDD_DEC pfet_05v0 L=0.5U W=6U AS=3.14P AD=3.14P
+ PS=11.14U PD=11.14U
* device instance $5449 r90 *1 55.025,180.715 pfet_05v0
M$5449 \$4 \$I4758 \$I408 VDD_DEC pfet_05v0 L=0.5U W=6U AS=3.14P AD=3.14P
+ PS=11.14U PD=11.14U
* device instance $5452 r90 *1 95.025,180.715 pfet_05v0
M$5452 \$4 \$I4759 \$I407 VDD_DEC pfet_05v0 L=0.5U W=6U AS=3.14P AD=3.14P
+ PS=11.14U PD=11.14U
* device instance $5455 r90 *1 135.025,180.715 pfet_05v0
M$5455 \$4 \$I4760 \$I406 VDD_DEC pfet_05v0 L=0.5U W=6U AS=3.14P AD=3.14P
+ PS=11.14U PD=11.14U
* device instance $5458 r90 *1 495.025,24.715 pfet_05v0
M$5458 \$4 \$I4761 \$I405 VDD_DEC pfet_05v0 L=0.5U W=6U AS=3.14P AD=3.14P
+ PS=11.14U PD=11.14U
* device instance $5461 r90 *1 295.025,24.715 pfet_05v0
M$5461 \$4 \$I4762 \$I404 VDD_DEC pfet_05v0 L=0.5U W=6U AS=3.14P AD=3.14P
+ PS=11.14U PD=11.14U
* device instance $5464 r90 *1 415.025,570.715 pfet_05v0
M$5464 \$4 \$I4763 \$I403 VDD_DEC pfet_05v0 L=0.5U W=6U AS=3.14P AD=3.14P
+ PS=11.14U PD=11.14U
* device instance $5467 r90 *1 415.025,336.715 pfet_05v0
M$5467 \$4 \$I4764 \$I402 VDD_DEC pfet_05v0 L=0.5U W=6U AS=3.14P AD=3.14P
+ PS=11.14U PD=11.14U
* device instance $5470 r90 *1 215.025,180.715 pfet_05v0
M$5470 \$4 \$I4765 \$I401 VDD_DEC pfet_05v0 L=0.5U W=6U AS=3.14P AD=3.14P
+ PS=11.14U PD=11.14U
* device instance $5473 r90 *1 295.025,180.715 pfet_05v0
M$5473 \$4 \$I4766 \$I400 VDD_DEC pfet_05v0 L=0.5U W=6U AS=3.14P AD=3.14P
+ PS=11.14U PD=11.14U
* device instance $5476 r90 *1 295.025,102.715 pfet_05v0
M$5476 \$4 \$I4767 \$I399 VDD_DEC pfet_05v0 L=0.5U W=6U AS=3.14P AD=3.14P
+ PS=11.14U PD=11.14U
* device instance $5479 r90 *1 455.025,336.715 pfet_05v0
M$5479 \$4 \$I4768 \$I398 VDD_DEC pfet_05v0 L=0.5U W=6U AS=3.14P AD=3.14P
+ PS=11.14U PD=11.14U
* device instance $5482 r90 *1 375.025,570.715 pfet_05v0
M$5482 \$4 \$I4769 \$I397 VDD_DEC pfet_05v0 L=0.5U W=6U AS=3.14P AD=3.14P
+ PS=11.14U PD=11.14U
* device instance $5485 r90 *1 215.025,102.715 pfet_05v0
M$5485 \$4 \$I4770 \$I396 VDD_DEC pfet_05v0 L=0.5U W=6U AS=3.14P AD=3.14P
+ PS=11.14U PD=11.14U
* device instance $5488 r90 *1 255.025,102.715 pfet_05v0
M$5488 \$4 \$I4771 \$I395 VDD_DEC pfet_05v0 L=0.5U W=6U AS=3.14P AD=3.14P
+ PS=11.14U PD=11.14U
* device instance $5491 r90 *1 415.025,180.715 pfet_05v0
M$5491 \$4 \$I4772 \$I394 VDD_DEC pfet_05v0 L=0.5U W=6U AS=3.14P AD=3.14P
+ PS=11.14U PD=11.14U
* device instance $5494 r90 *1 455.025,180.715 pfet_05v0
M$5494 \$4 \$I4773 \$I393 VDD_DEC pfet_05v0 L=0.5U W=6U AS=3.14P AD=3.14P
+ PS=11.14U PD=11.14U
* device instance $5497 r90 *1 495.025,180.715 pfet_05v0
M$5497 \$4 \$I4774 \$I392 VDD_DEC pfet_05v0 L=0.5U W=6U AS=3.14P AD=3.14P
+ PS=11.14U PD=11.14U
* device instance $5500 r90 *1 415.025,102.715 pfet_05v0
M$5500 \$4 \$I4775 \$I391 VDD_DEC pfet_05v0 L=0.5U W=6U AS=3.14P AD=3.14P
+ PS=11.14U PD=11.14U
* device instance $5503 r90 *1 455.025,102.715 pfet_05v0
M$5503 \$4 \$I4776 \$I390 VDD_DEC pfet_05v0 L=0.5U W=6U AS=3.14P AD=3.14P
+ PS=11.14U PD=11.14U
* device instance $5506 r90 *1 495.025,102.715 pfet_05v0
M$5506 \$4 \$I4777 \$I389 VDD_DEC pfet_05v0 L=0.5U W=6U AS=3.14P AD=3.14P
+ PS=11.14U PD=11.14U
* device instance $5509 r90 *1 175.025,570.715 pfet_05v0
M$5509 \$4 \$I4778 \$I388 VDD_DEC pfet_05v0 L=0.5U W=6U AS=3.14P AD=3.14P
+ PS=11.14U PD=11.14U
* device instance $5512 r90 *1 415.025,24.715 pfet_05v0
M$5512 \$4 \$I4779 \$I387 VDD_DEC pfet_05v0 L=0.5U W=6U AS=3.14P AD=3.14P
+ PS=11.14U PD=11.14U
* device instance $5515 r90 *1 375.025,180.715 pfet_05v0
M$5515 \$4 \$I4780 \$I386 VDD_DEC pfet_05v0 L=0.5U W=6U AS=3.14P AD=3.14P
+ PS=11.14U PD=11.14U
* device instance $5518 r90 *1 58.535,24.745 nfet_05v0
M$5518 \$4 \$6 \$I513 VSS nfet_05v0 L=0.6U W=2U AS=1.46P AD=1.46P PS=5.46U
+ PD=5.46U
* device instance $5519 r90 *1 178.535,102.745 nfet_05v0
M$5519 \$4 \$28 \$I512 VSS nfet_05v0 L=0.6U W=2U AS=1.46P AD=1.46P PS=5.46U
+ PD=5.46U
* device instance $5520 r90 *1 178.535,24.745 nfet_05v0
M$5520 \$4 \$9 \$I511 VSS nfet_05v0 L=0.6U W=2U AS=1.46P AD=1.46P PS=5.46U
+ PD=5.46U
* device instance $5521 r90 *1 218.535,570.745 nfet_05v0
M$5521 \$4 \$269 \$I510 VSS nfet_05v0 L=0.6U W=2U AS=1.46P AD=1.46P PS=5.46U
+ PD=5.46U
* device instance $5522 r90 *1 298.535,336.745 nfet_05v0
M$5522 \$4 \$165 \$I509 VSS nfet_05v0 L=0.6U W=2U AS=1.46P AD=1.46P PS=5.46U
+ PD=5.46U
* device instance $5523 r90 *1 538.535,24.745 nfet_05v0
M$5523 \$4 \$18 \$I508 VSS nfet_05v0 L=0.6U W=2U AS=1.46P AD=1.46P PS=5.46U
+ PD=5.46U
* device instance $5524 r90 *1 178.535,336.745 nfet_05v0
M$5524 \$4 \$156 \$I507 VSS nfet_05v0 L=0.6U W=2U AS=1.46P AD=1.46P PS=5.46U
+ PD=5.46U
* device instance $5525 r90 *1 258.535,336.745 nfet_05v0
M$5525 \$4 \$162 \$I506 VSS nfet_05v0 L=0.6U W=2U AS=1.46P AD=1.46P PS=5.46U
+ PD=5.46U
* device instance $5526 r90 *1 658.535,24.745 nfet_05v0
M$5526 \$4 \$21 \$I505 VSS nfet_05v0 L=0.6U W=2U AS=1.46P AD=1.46P PS=5.46U
+ PD=5.46U
* device instance $5527 r90 *1 298.535,414.745 nfet_05v0
M$5527 \$4 \$164 \$I504 VSS nfet_05v0 L=0.6U W=2U AS=1.46P AD=1.46P PS=5.46U
+ PD=5.46U
* device instance $5528 r90 *1 178.535,180.745 nfet_05v0
M$5528 \$4 \$89 \$I503 VSS nfet_05v0 L=0.6U W=2U AS=1.46P AD=1.46P PS=5.46U
+ PD=5.46U
* device instance $5529 r90 *1 658.535,180.745 nfet_05v0
M$5529 \$4 \$113 \$I502 VSS nfet_05v0 L=0.6U W=2U AS=1.46P AD=1.46P PS=5.46U
+ PD=5.46U
* device instance $5530 r90 *1 58.535,570.745 nfet_05v0
M$5530 \$4 \$265 \$I501 VSS nfet_05v0 L=0.6U W=2U AS=1.46P AD=1.46P PS=5.46U
+ PD=5.46U
* device instance $5531 r90 *1 618.535,180.745 nfet_05v0
M$5531 \$4 \$111 \$I500 VSS nfet_05v0 L=0.6U W=2U AS=1.46P AD=1.46P PS=5.46U
+ PD=5.46U
* device instance $5532 r90 *1 578.535,180.745 nfet_05v0
M$5532 \$4 \$109 \$I499 VSS nfet_05v0 L=0.6U W=2U AS=1.46P AD=1.46P PS=5.46U
+ PD=5.46U
* device instance $5533 r90 *1 538.535,180.745 nfet_05v0
M$5533 \$4 \$107 \$I498 VSS nfet_05v0 L=0.6U W=2U AS=1.46P AD=1.46P PS=5.46U
+ PD=5.46U
* device instance $5534 r90 *1 378.535,102.745 nfet_05v0
M$5534 \$4 \$33 \$I497 VSS nfet_05v0 L=0.6U W=2U AS=1.46P AD=1.46P PS=5.46U
+ PD=5.46U
* device instance $5535 r90 *1 98.535,336.745 nfet_05v0
M$5535 \$4 \$150 \$I496 VSS nfet_05v0 L=0.6U W=2U AS=1.46P AD=1.46P PS=5.46U
+ PD=5.46U
* device instance $5536 r90 *1 378.535,24.745 nfet_05v0
M$5536 \$4 \$14 \$I495 VSS nfet_05v0 L=0.6U W=2U AS=1.46P AD=1.46P PS=5.46U
+ PD=5.46U
* device instance $5537 r90 *1 58.535,336.745 nfet_05v0
M$5537 \$4 \$147 \$I494 VSS nfet_05v0 L=0.6U W=2U AS=1.46P AD=1.46P PS=5.46U
+ PD=5.46U
* device instance $5538 r90 *1 578.535,24.745 nfet_05v0
M$5538 \$4 \$19 \$I493 VSS nfet_05v0 L=0.6U W=2U AS=1.46P AD=1.46P PS=5.46U
+ PD=5.46U
* device instance $5539 r90 *1 618.535,24.745 nfet_05v0
M$5539 \$4 \$20 \$I492 VSS nfet_05v0 L=0.6U W=2U AS=1.46P AD=1.46P PS=5.46U
+ PD=5.46U
* device instance $5540 r90 *1 538.535,102.745 nfet_05v0
M$5540 \$4 \$37 \$I491 VSS nfet_05v0 L=0.6U W=2U AS=1.46P AD=1.46P PS=5.46U
+ PD=5.46U
* device instance $5541 r90 *1 578.535,102.745 nfet_05v0
M$5541 \$4 \$38 \$I490 VSS nfet_05v0 L=0.6U W=2U AS=1.46P AD=1.46P PS=5.46U
+ PD=5.46U
* device instance $5542 r90 *1 258.535,414.745 nfet_05v0
M$5542 \$4 \$161 \$I489 VSS nfet_05v0 L=0.6U W=2U AS=1.46P AD=1.46P PS=5.46U
+ PD=5.46U
* device instance $5543 r90 *1 618.535,102.745 nfet_05v0
M$5543 \$4 \$39 \$I488 VSS nfet_05v0 L=0.6U W=2U AS=1.46P AD=1.46P PS=5.46U
+ PD=5.46U
* device instance $5544 r90 *1 138.535,414.745 nfet_05v0
M$5544 \$4 \$152 \$I487 VSS nfet_05v0 L=0.6U W=2U AS=1.46P AD=1.46P PS=5.46U
+ PD=5.46U
* device instance $5545 r90 *1 658.535,102.745 nfet_05v0
M$5545 \$4 \$40 \$I486 VSS nfet_05v0 L=0.6U W=2U AS=1.46P AD=1.46P PS=5.46U
+ PD=5.46U
* device instance $5546 r90 *1 218.535,336.745 nfet_05v0
M$5546 \$4 \$159 \$I485 VSS nfet_05v0 L=0.6U W=2U AS=1.46P AD=1.46P PS=5.46U
+ PD=5.46U
* device instance $5547 r90 *1 218.535,414.745 nfet_05v0
M$5547 \$4 \$158 \$I484 VSS nfet_05v0 L=0.6U W=2U AS=1.46P AD=1.46P PS=5.46U
+ PD=5.46U
* device instance $5548 r90 *1 338.535,570.745 nfet_05v0
M$5548 \$4 \$272 \$I483 VSS nfet_05v0 L=0.6U W=2U AS=1.46P AD=1.46P PS=5.46U
+ PD=5.46U
* device instance $5549 r90 *1 138.535,336.745 nfet_05v0
M$5549 \$4 \$153 \$I482 VSS nfet_05v0 L=0.6U W=2U AS=1.46P AD=1.46P PS=5.46U
+ PD=5.46U
* device instance $5550 r90 *1 338.535,414.745 nfet_05v0
M$5550 \$4 \$167 \$I481 VSS nfet_05v0 L=0.6U W=2U AS=1.46P AD=1.46P PS=5.46U
+ PD=5.46U
* device instance $5551 r90 *1 338.535,336.745 nfet_05v0
M$5551 \$4 \$168 \$I480 VSS nfet_05v0 L=0.6U W=2U AS=1.46P AD=1.46P PS=5.46U
+ PD=5.46U
* device instance $5552 r90 *1 338.535,258.745 nfet_05v0
M$5552 \$4 \$96 \$I479 VSS nfet_05v0 L=0.6U W=2U AS=1.46P AD=1.46P PS=5.46U
+ PD=5.46U
* device instance $5553 r90 *1 338.535,180.745 nfet_05v0
M$5553 \$4 \$97 \$I478 VSS nfet_05v0 L=0.6U W=2U AS=1.46P AD=1.46P PS=5.46U
+ PD=5.46U
* device instance $5554 r90 *1 338.535,102.745 nfet_05v0
M$5554 \$4 \$32 \$I477 VSS nfet_05v0 L=0.6U W=2U AS=1.46P AD=1.46P PS=5.46U
+ PD=5.46U
* device instance $5555 r90 *1 338.535,24.745 nfet_05v0
M$5555 \$4 \$13 \$I476 VSS nfet_05v0 L=0.6U W=2U AS=1.46P AD=1.46P PS=5.46U
+ PD=5.46U
* device instance $5556 r90 *1 378.535,492.745 nfet_05v0
M$5556 \$4 \$169 \$I475 VSS nfet_05v0 L=0.6U W=2U AS=1.46P AD=1.46P PS=5.46U
+ PD=5.46U
* device instance $5557 r90 *1 418.535,492.745 nfet_05v0
M$5557 \$4 \$172 \$I474 VSS nfet_05v0 L=0.6U W=2U AS=1.46P AD=1.46P PS=5.46U
+ PD=5.46U
* device instance $5558 r90 *1 458.535,492.745 nfet_05v0
M$5558 \$4 \$175 \$I473 VSS nfet_05v0 L=0.6U W=2U AS=1.46P AD=1.46P PS=5.46U
+ PD=5.46U
* device instance $5559 r90 *1 498.535,492.745 nfet_05v0
M$5559 \$4 \$178 \$I472 VSS nfet_05v0 L=0.6U W=2U AS=1.46P AD=1.46P PS=5.46U
+ PD=5.46U
* device instance $5560 r90 *1 618.535,492.745 nfet_05v0
M$5560 \$4 \$187 \$I471 VSS nfet_05v0 L=0.6U W=2U AS=1.46P AD=1.46P PS=5.46U
+ PD=5.46U
* device instance $5561 r90 *1 658.535,492.745 nfet_05v0
M$5561 \$4 \$190 \$I470 VSS nfet_05v0 L=0.6U W=2U AS=1.46P AD=1.46P PS=5.46U
+ PD=5.46U
* device instance $5562 r90 *1 538.535,492.745 nfet_05v0
M$5562 \$4 \$181 \$I469 VSS nfet_05v0 L=0.6U W=2U AS=1.46P AD=1.46P PS=5.46U
+ PD=5.46U
* device instance $5563 r90 *1 578.535,492.745 nfet_05v0
M$5563 \$4 \$184 \$I468 VSS nfet_05v0 L=0.6U W=2U AS=1.46P AD=1.46P PS=5.46U
+ PD=5.46U
* device instance $5564 r90 *1 178.535,492.745 nfet_05v0
M$5564 \$4 \$154 \$I467 VSS nfet_05v0 L=0.6U W=2U AS=1.46P AD=1.46P PS=5.46U
+ PD=5.46U
* device instance $5565 r90 *1 138.535,570.745 nfet_05v0
M$5565 \$4 \$267 \$I466 VSS nfet_05v0 L=0.6U W=2U AS=1.46P AD=1.46P PS=5.46U
+ PD=5.46U
* device instance $5566 r90 *1 58.535,492.745 nfet_05v0
M$5566 \$4 \$145 \$I465 VSS nfet_05v0 L=0.6U W=2U AS=1.46P AD=1.46P PS=5.46U
+ PD=5.46U
* device instance $5567 r90 *1 98.535,492.745 nfet_05v0
M$5567 \$4 \$148 \$I464 VSS nfet_05v0 L=0.6U W=2U AS=1.46P AD=1.46P PS=5.46U
+ PD=5.46U
* device instance $5568 r90 *1 138.535,492.745 nfet_05v0
M$5568 \$4 \$151 \$I463 VSS nfet_05v0 L=0.6U W=2U AS=1.46P AD=1.46P PS=5.46U
+ PD=5.46U
* device instance $5569 r90 *1 218.535,492.745 nfet_05v0
M$5569 \$4 \$157 \$I462 VSS nfet_05v0 L=0.6U W=2U AS=1.46P AD=1.46P PS=5.46U
+ PD=5.46U
* device instance $5570 r90 *1 258.535,492.745 nfet_05v0
M$5570 \$4 \$160 \$I461 VSS nfet_05v0 L=0.6U W=2U AS=1.46P AD=1.46P PS=5.46U
+ PD=5.46U
* device instance $5571 r90 *1 298.535,492.745 nfet_05v0
M$5571 \$4 \$163 \$I460 VSS nfet_05v0 L=0.6U W=2U AS=1.46P AD=1.46P PS=5.46U
+ PD=5.46U
* device instance $5572 r90 *1 298.535,570.745 nfet_05v0
M$5572 \$4 \$271 \$I459 VSS nfet_05v0 L=0.6U W=2U AS=1.46P AD=1.46P PS=5.46U
+ PD=5.46U
* device instance $5573 r90 *1 258.535,258.745 nfet_05v0
M$5573 \$4 \$92 \$I458 VSS nfet_05v0 L=0.6U W=2U AS=1.46P AD=1.46P PS=5.46U
+ PD=5.46U
* device instance $5574 r90 *1 298.535,258.745 nfet_05v0
M$5574 \$4 \$94 \$I457 VSS nfet_05v0 L=0.6U W=2U AS=1.46P AD=1.46P PS=5.46U
+ PD=5.46U
* device instance $5575 r90 *1 138.535,258.745 nfet_05v0
M$5575 \$4 \$86 \$I456 VSS nfet_05v0 L=0.6U W=2U AS=1.46P AD=1.46P PS=5.46U
+ PD=5.46U
* device instance $5576 r90 *1 98.535,258.745 nfet_05v0
M$5576 \$4 \$84 \$I455 VSS nfet_05v0 L=0.6U W=2U AS=1.46P AD=1.46P PS=5.46U
+ PD=5.46U
* device instance $5577 r90 *1 258.535,570.745 nfet_05v0
M$5577 \$4 \$270 \$I454 VSS nfet_05v0 L=0.6U W=2U AS=1.46P AD=1.46P PS=5.46U
+ PD=5.46U
* device instance $5578 r90 *1 58.535,258.745 nfet_05v0
M$5578 \$4 \$82 \$I453 VSS nfet_05v0 L=0.6U W=2U AS=1.46P AD=1.46P PS=5.46U
+ PD=5.46U
* device instance $5579 r90 *1 178.535,414.745 nfet_05v0
M$5579 \$4 \$155 \$I452 VSS nfet_05v0 L=0.6U W=2U AS=1.46P AD=1.46P PS=5.46U
+ PD=5.46U
* device instance $5580 r90 *1 178.535,258.745 nfet_05v0
M$5580 \$4 \$88 \$I451 VSS nfet_05v0 L=0.6U W=2U AS=1.46P AD=1.46P PS=5.46U
+ PD=5.46U
* device instance $5581 r90 *1 218.535,258.745 nfet_05v0
M$5581 \$4 \$90 \$I450 VSS nfet_05v0 L=0.6U W=2U AS=1.46P AD=1.46P PS=5.46U
+ PD=5.46U
* device instance $5582 r90 *1 258.535,180.745 nfet_05v0
M$5582 \$4 \$93 \$I449 VSS nfet_05v0 L=0.6U W=2U AS=1.46P AD=1.46P PS=5.46U
+ PD=5.46U
* device instance $5583 r90 *1 458.535,570.745 nfet_05v0
M$5583 \$4 \$275 \$I448 VSS nfet_05v0 L=0.6U W=2U AS=1.46P AD=1.46P PS=5.46U
+ PD=5.46U
* device instance $5584 r90 *1 498.535,570.745 nfet_05v0
M$5584 \$4 \$276 \$I447 VSS nfet_05v0 L=0.6U W=2U AS=1.46P AD=1.46P PS=5.46U
+ PD=5.46U
* device instance $5585 r90 *1 378.535,336.745 nfet_05v0
M$5585 \$4 \$171 \$I446 VSS nfet_05v0 L=0.6U W=2U AS=1.46P AD=1.46P PS=5.46U
+ PD=5.46U
* device instance $5586 r90 *1 378.535,414.745 nfet_05v0
M$5586 \$4 \$170 \$I445 VSS nfet_05v0 L=0.6U W=2U AS=1.46P AD=1.46P PS=5.46U
+ PD=5.46U
* device instance $5587 r90 *1 498.535,414.745 nfet_05v0
M$5587 \$4 \$179 \$I444 VSS nfet_05v0 L=0.6U W=2U AS=1.46P AD=1.46P PS=5.46U
+ PD=5.46U
* device instance $5588 r90 *1 258.535,24.745 nfet_05v0
M$5588 \$4 \$11 \$I443 VSS nfet_05v0 L=0.6U W=2U AS=1.46P AD=1.46P PS=5.46U
+ PD=5.46U
* device instance $5589 r90 *1 498.535,336.745 nfet_05v0
M$5589 \$4 \$180 \$I442 VSS nfet_05v0 L=0.6U W=2U AS=1.46P AD=1.46P PS=5.46U
+ PD=5.46U
* device instance $5590 r90 *1 458.535,414.745 nfet_05v0
M$5590 \$4 \$176 \$I441 VSS nfet_05v0 L=0.6U W=2U AS=1.46P AD=1.46P PS=5.46U
+ PD=5.46U
* device instance $5591 r90 *1 418.535,414.745 nfet_05v0
M$5591 \$4 \$173 \$I440 VSS nfet_05v0 L=0.6U W=2U AS=1.46P AD=1.46P PS=5.46U
+ PD=5.46U
* device instance $5592 r90 *1 618.535,414.745 nfet_05v0
M$5592 \$4 \$188 \$I439 VSS nfet_05v0 L=0.6U W=2U AS=1.46P AD=1.46P PS=5.46U
+ PD=5.46U
* device instance $5593 r90 *1 578.535,414.745 nfet_05v0
M$5593 \$4 \$185 \$I438 VSS nfet_05v0 L=0.6U W=2U AS=1.46P AD=1.46P PS=5.46U
+ PD=5.46U
* device instance $5594 r90 *1 538.535,414.745 nfet_05v0
M$5594 \$4 \$182 \$I437 VSS nfet_05v0 L=0.6U W=2U AS=1.46P AD=1.46P PS=5.46U
+ PD=5.46U
* device instance $5595 r90 *1 538.535,570.745 nfet_05v0
M$5595 \$4 \$277 \$I436 VSS nfet_05v0 L=0.6U W=2U AS=1.46P AD=1.46P PS=5.46U
+ PD=5.46U
* device instance $5596 r90 *1 578.535,570.745 nfet_05v0
M$5596 \$4 \$278 \$I435 VSS nfet_05v0 L=0.6U W=2U AS=1.46P AD=1.46P PS=5.46U
+ PD=5.46U
* device instance $5597 r90 *1 338.535,492.745 nfet_05v0
M$5597 \$4 \$166 \$I434 VSS nfet_05v0 L=0.6U W=2U AS=1.46P AD=1.46P PS=5.46U
+ PD=5.46U
* device instance $5598 r90 *1 618.535,570.745 nfet_05v0
M$5598 \$4 \$279 \$I433 VSS nfet_05v0 L=0.6U W=2U AS=1.46P AD=1.46P PS=5.46U
+ PD=5.46U
* device instance $5599 r90 *1 218.535,24.745 nfet_05v0
M$5599 \$4 \$10 \$I432 VSS nfet_05v0 L=0.6U W=2U AS=1.46P AD=1.46P PS=5.46U
+ PD=5.46U
* device instance $5600 r90 *1 578.535,336.745 nfet_05v0
M$5600 \$4 \$186 \$I431 VSS nfet_05v0 L=0.6U W=2U AS=1.46P AD=1.46P PS=5.46U
+ PD=5.46U
* device instance $5601 r90 *1 658.535,414.745 nfet_05v0
M$5601 \$4 \$191 \$I430 VSS nfet_05v0 L=0.6U W=2U AS=1.46P AD=1.46P PS=5.46U
+ PD=5.46U
* device instance $5602 r90 *1 578.535,258.745 nfet_05v0
M$5602 \$4 \$108 \$I429 VSS nfet_05v0 L=0.6U W=2U AS=1.46P AD=1.46P PS=5.46U
+ PD=5.46U
* device instance $5603 r90 *1 618.535,258.745 nfet_05v0
M$5603 \$4 \$110 \$I428 VSS nfet_05v0 L=0.6U W=2U AS=1.46P AD=1.46P PS=5.46U
+ PD=5.46U
* device instance $5604 r90 *1 658.535,258.745 nfet_05v0
M$5604 \$4 \$112 \$I427 VSS nfet_05v0 L=0.6U W=2U AS=1.46P AD=1.46P PS=5.46U
+ PD=5.46U
* device instance $5605 r90 *1 538.535,258.745 nfet_05v0
M$5605 \$4 \$106 \$I426 VSS nfet_05v0 L=0.6U W=2U AS=1.46P AD=1.46P PS=5.46U
+ PD=5.46U
* device instance $5606 r90 *1 498.535,258.745 nfet_05v0
M$5606 \$4 \$104 \$I425 VSS nfet_05v0 L=0.6U W=2U AS=1.46P AD=1.46P PS=5.46U
+ PD=5.46U
* device instance $5607 r90 *1 658.535,336.745 nfet_05v0
M$5607 \$4 \$192 \$I424 VSS nfet_05v0 L=0.6U W=2U AS=1.46P AD=1.46P PS=5.46U
+ PD=5.46U
* device instance $5608 r90 *1 458.535,258.745 nfet_05v0
M$5608 \$4 \$102 \$I423 VSS nfet_05v0 L=0.6U W=2U AS=1.46P AD=1.46P PS=5.46U
+ PD=5.46U
* device instance $5609 r90 *1 378.535,258.745 nfet_05v0
M$5609 \$4 \$98 \$I422 VSS nfet_05v0 L=0.6U W=2U AS=1.46P AD=1.46P PS=5.46U
+ PD=5.46U
* device instance $5610 r90 *1 618.535,336.745 nfet_05v0
M$5610 \$4 \$189 \$I421 VSS nfet_05v0 L=0.6U W=2U AS=1.46P AD=1.46P PS=5.46U
+ PD=5.46U
* device instance $5611 r90 *1 418.535,258.745 nfet_05v0
M$5611 \$4 \$100 \$I420 VSS nfet_05v0 L=0.6U W=2U AS=1.46P AD=1.46P PS=5.46U
+ PD=5.46U
* device instance $5612 r90 *1 538.535,336.745 nfet_05v0
M$5612 \$4 \$183 \$I419 VSS nfet_05v0 L=0.6U W=2U AS=1.46P AD=1.46P PS=5.46U
+ PD=5.46U
* device instance $5613 r90 *1 658.535,570.745 nfet_05v0
M$5613 \$4 \$280 \$I418 VSS nfet_05v0 L=0.6U W=2U AS=1.46P AD=1.46P PS=5.46U
+ PD=5.46U
* device instance $5614 r90 *1 98.535,570.745 nfet_05v0
M$5614 \$4 \$266 \$I417 VSS nfet_05v0 L=0.6U W=2U AS=1.46P AD=1.46P PS=5.46U
+ PD=5.46U
* device instance $5615 r90 *1 98.535,414.745 nfet_05v0
M$5615 \$4 \$149 \$I416 VSS nfet_05v0 L=0.6U W=2U AS=1.46P AD=1.46P PS=5.46U
+ PD=5.46U
* device instance $5616 r90 *1 58.535,414.745 nfet_05v0
M$5616 \$4 \$146 \$I415 VSS nfet_05v0 L=0.6U W=2U AS=1.46P AD=1.46P PS=5.46U
+ PD=5.46U
* device instance $5617 r90 *1 138.535,24.745 nfet_05v0
M$5617 \$4 \$8 \$I414 VSS nfet_05v0 L=0.6U W=2U AS=1.46P AD=1.46P PS=5.46U
+ PD=5.46U
* device instance $5618 r90 *1 58.535,102.745 nfet_05v0
M$5618 \$4 \$25 \$I413 VSS nfet_05v0 L=0.6U W=2U AS=1.46P AD=1.46P PS=5.46U
+ PD=5.46U
* device instance $5619 r90 *1 98.535,102.745 nfet_05v0
M$5619 \$4 \$26 \$I412 VSS nfet_05v0 L=0.6U W=2U AS=1.46P AD=1.46P PS=5.46U
+ PD=5.46U
* device instance $5620 r90 *1 138.535,102.745 nfet_05v0
M$5620 \$4 \$27 \$I411 VSS nfet_05v0 L=0.6U W=2U AS=1.46P AD=1.46P PS=5.46U
+ PD=5.46U
* device instance $5621 r90 *1 458.535,24.745 nfet_05v0
M$5621 \$4 \$16 \$I410 VSS nfet_05v0 L=0.6U W=2U AS=1.46P AD=1.46P PS=5.46U
+ PD=5.46U
* device instance $5622 r90 *1 98.535,24.745 nfet_05v0
M$5622 \$4 \$7 \$I409 VSS nfet_05v0 L=0.6U W=2U AS=1.46P AD=1.46P PS=5.46U
+ PD=5.46U
* device instance $5623 r90 *1 58.535,180.745 nfet_05v0
M$5623 \$4 \$83 \$I408 VSS nfet_05v0 L=0.6U W=2U AS=1.46P AD=1.46P PS=5.46U
+ PD=5.46U
* device instance $5624 r90 *1 98.535,180.745 nfet_05v0
M$5624 \$4 \$85 \$I407 VSS nfet_05v0 L=0.6U W=2U AS=1.46P AD=1.46P PS=5.46U
+ PD=5.46U
* device instance $5625 r90 *1 138.535,180.745 nfet_05v0
M$5625 \$4 \$87 \$I406 VSS nfet_05v0 L=0.6U W=2U AS=1.46P AD=1.46P PS=5.46U
+ PD=5.46U
* device instance $5626 r90 *1 498.535,24.745 nfet_05v0
M$5626 \$4 \$17 \$I405 VSS nfet_05v0 L=0.6U W=2U AS=1.46P AD=1.46P PS=5.46U
+ PD=5.46U
* device instance $5627 r90 *1 298.535,24.745 nfet_05v0
M$5627 \$4 \$12 \$I404 VSS nfet_05v0 L=0.6U W=2U AS=1.46P AD=1.46P PS=5.46U
+ PD=5.46U
* device instance $5628 r90 *1 418.535,570.745 nfet_05v0
M$5628 \$4 \$274 \$I403 VSS nfet_05v0 L=0.6U W=2U AS=1.46P AD=1.46P PS=5.46U
+ PD=5.46U
* device instance $5629 r90 *1 418.535,336.745 nfet_05v0
M$5629 \$4 \$174 \$I402 VSS nfet_05v0 L=0.6U W=2U AS=1.46P AD=1.46P PS=5.46U
+ PD=5.46U
* device instance $5630 r90 *1 218.535,180.745 nfet_05v0
M$5630 \$4 \$91 \$I401 VSS nfet_05v0 L=0.6U W=2U AS=1.46P AD=1.46P PS=5.46U
+ PD=5.46U
* device instance $5631 r90 *1 298.535,180.745 nfet_05v0
M$5631 \$4 \$95 \$I400 VSS nfet_05v0 L=0.6U W=2U AS=1.46P AD=1.46P PS=5.46U
+ PD=5.46U
* device instance $5632 r90 *1 298.535,102.745 nfet_05v0
M$5632 \$4 \$31 \$I399 VSS nfet_05v0 L=0.6U W=2U AS=1.46P AD=1.46P PS=5.46U
+ PD=5.46U
* device instance $5633 r90 *1 458.535,336.745 nfet_05v0
M$5633 \$4 \$177 \$I398 VSS nfet_05v0 L=0.6U W=2U AS=1.46P AD=1.46P PS=5.46U
+ PD=5.46U
* device instance $5634 r90 *1 378.535,570.745 nfet_05v0
M$5634 \$4 \$273 \$I397 VSS nfet_05v0 L=0.6U W=2U AS=1.46P AD=1.46P PS=5.46U
+ PD=5.46U
* device instance $5635 r90 *1 218.535,102.745 nfet_05v0
M$5635 \$4 \$29 \$I396 VSS nfet_05v0 L=0.6U W=2U AS=1.46P AD=1.46P PS=5.46U
+ PD=5.46U
* device instance $5636 r90 *1 258.535,102.745 nfet_05v0
M$5636 \$4 \$30 \$I395 VSS nfet_05v0 L=0.6U W=2U AS=1.46P AD=1.46P PS=5.46U
+ PD=5.46U
* device instance $5637 r90 *1 418.535,180.745 nfet_05v0
M$5637 \$4 \$101 \$I394 VSS nfet_05v0 L=0.6U W=2U AS=1.46P AD=1.46P PS=5.46U
+ PD=5.46U
* device instance $5638 r90 *1 458.535,180.745 nfet_05v0
M$5638 \$4 \$103 \$I393 VSS nfet_05v0 L=0.6U W=2U AS=1.46P AD=1.46P PS=5.46U
+ PD=5.46U
* device instance $5639 r90 *1 498.535,180.745 nfet_05v0
M$5639 \$4 \$105 \$I392 VSS nfet_05v0 L=0.6U W=2U AS=1.46P AD=1.46P PS=5.46U
+ PD=5.46U
* device instance $5640 r90 *1 418.535,102.745 nfet_05v0
M$5640 \$4 \$34 \$I391 VSS nfet_05v0 L=0.6U W=2U AS=1.46P AD=1.46P PS=5.46U
+ PD=5.46U
* device instance $5641 r90 *1 458.535,102.745 nfet_05v0
M$5641 \$4 \$35 \$I390 VSS nfet_05v0 L=0.6U W=2U AS=1.46P AD=1.46P PS=5.46U
+ PD=5.46U
* device instance $5642 r90 *1 498.535,102.745 nfet_05v0
M$5642 \$4 \$36 \$I389 VSS nfet_05v0 L=0.6U W=2U AS=1.46P AD=1.46P PS=5.46U
+ PD=5.46U
* device instance $5643 r90 *1 178.535,570.745 nfet_05v0
M$5643 \$4 \$268 \$I388 VSS nfet_05v0 L=0.6U W=2U AS=1.46P AD=1.46P PS=5.46U
+ PD=5.46U
* device instance $5644 r90 *1 418.535,24.745 nfet_05v0
M$5644 \$4 \$15 \$I387 VSS nfet_05v0 L=0.6U W=2U AS=1.46P AD=1.46P PS=5.46U
+ PD=5.46U
* device instance $5645 r90 *1 378.535,180.745 nfet_05v0
M$5645 \$4 \$99 \$I386 VSS nfet_05v0 L=0.6U W=2U AS=1.46P AD=1.46P PS=5.46U
+ PD=5.46U
* device instance $5646 r180 *1 51.51,27.82 pfet_05v0
M$5646 VDD_DEC \$6 \$I4653 VDD_DEC pfet_05v0 L=0.5U W=2U AS=1.54P AD=1.54P
+ PS=5.54U PD=5.54U
* device instance $5647 r180 *1 171.51,105.82 pfet_05v0
M$5647 VDD_DEC \$28 \$I4654 VDD_DEC pfet_05v0 L=0.5U W=2U AS=1.54P AD=1.54P
+ PS=5.54U PD=5.54U
* device instance $5648 r180 *1 171.51,27.82 pfet_05v0
M$5648 VDD_DEC \$9 \$I4655 VDD_DEC pfet_05v0 L=0.5U W=2U AS=1.54P AD=1.54P
+ PS=5.54U PD=5.54U
* device instance $5649 r180 *1 211.51,573.82 pfet_05v0
M$5649 VDD_DEC \$269 \$I4656 VDD_DEC pfet_05v0 L=0.5U W=2U AS=1.54P AD=1.54P
+ PS=5.54U PD=5.54U
* device instance $5650 r180 *1 291.51,339.82 pfet_05v0
M$5650 VDD_DEC \$165 \$I4657 VDD_DEC pfet_05v0 L=0.5U W=2U AS=1.54P AD=1.54P
+ PS=5.54U PD=5.54U
* device instance $5651 r180 *1 531.51,27.82 pfet_05v0
M$5651 VDD_DEC \$18 \$I4658 VDD_DEC pfet_05v0 L=0.5U W=2U AS=1.54P AD=1.54P
+ PS=5.54U PD=5.54U
* device instance $5652 r180 *1 171.51,339.82 pfet_05v0
M$5652 VDD_DEC \$156 \$I4659 VDD_DEC pfet_05v0 L=0.5U W=2U AS=1.54P AD=1.54P
+ PS=5.54U PD=5.54U
* device instance $5653 r180 *1 251.51,339.82 pfet_05v0
M$5653 VDD_DEC \$162 \$I4660 VDD_DEC pfet_05v0 L=0.5U W=2U AS=1.54P AD=1.54P
+ PS=5.54U PD=5.54U
* device instance $5654 r180 *1 651.51,27.82 pfet_05v0
M$5654 VDD_DEC \$21 \$I4661 VDD_DEC pfet_05v0 L=0.5U W=2U AS=1.54P AD=1.54P
+ PS=5.54U PD=5.54U
* device instance $5655 r180 *1 291.51,417.82 pfet_05v0
M$5655 VDD_DEC \$164 \$I4662 VDD_DEC pfet_05v0 L=0.5U W=2U AS=1.54P AD=1.54P
+ PS=5.54U PD=5.54U
* device instance $5656 r180 *1 171.51,183.82 pfet_05v0
M$5656 VDD_DEC \$89 \$I4663 VDD_DEC pfet_05v0 L=0.5U W=2U AS=1.54P AD=1.54P
+ PS=5.54U PD=5.54U
* device instance $5657 r180 *1 651.51,183.82 pfet_05v0
M$5657 VDD_DEC \$113 \$I4664 VDD_DEC pfet_05v0 L=0.5U W=2U AS=1.54P AD=1.54P
+ PS=5.54U PD=5.54U
* device instance $5658 r180 *1 51.51,573.82 pfet_05v0
M$5658 VDD_DEC \$265 \$I4665 VDD_DEC pfet_05v0 L=0.5U W=2U AS=1.54P AD=1.54P
+ PS=5.54U PD=5.54U
* device instance $5659 r180 *1 611.51,183.82 pfet_05v0
M$5659 VDD_DEC \$111 \$I4666 VDD_DEC pfet_05v0 L=0.5U W=2U AS=1.54P AD=1.54P
+ PS=5.54U PD=5.54U
* device instance $5660 r180 *1 571.51,183.82 pfet_05v0
M$5660 VDD_DEC \$109 \$I4667 VDD_DEC pfet_05v0 L=0.5U W=2U AS=1.54P AD=1.54P
+ PS=5.54U PD=5.54U
* device instance $5661 r180 *1 531.51,183.82 pfet_05v0
M$5661 VDD_DEC \$107 \$I4668 VDD_DEC pfet_05v0 L=0.5U W=2U AS=1.54P AD=1.54P
+ PS=5.54U PD=5.54U
* device instance $5662 r180 *1 371.51,105.82 pfet_05v0
M$5662 VDD_DEC \$33 \$I4669 VDD_DEC pfet_05v0 L=0.5U W=2U AS=1.54P AD=1.54P
+ PS=5.54U PD=5.54U
* device instance $5663 r180 *1 91.51,339.82 pfet_05v0
M$5663 VDD_DEC \$150 \$I4670 VDD_DEC pfet_05v0 L=0.5U W=2U AS=1.54P AD=1.54P
+ PS=5.54U PD=5.54U
* device instance $5664 r180 *1 371.51,27.82 pfet_05v0
M$5664 VDD_DEC \$14 \$I4671 VDD_DEC pfet_05v0 L=0.5U W=2U AS=1.54P AD=1.54P
+ PS=5.54U PD=5.54U
* device instance $5665 r180 *1 51.51,339.82 pfet_05v0
M$5665 VDD_DEC \$147 \$I4672 VDD_DEC pfet_05v0 L=0.5U W=2U AS=1.54P AD=1.54P
+ PS=5.54U PD=5.54U
* device instance $5666 r180 *1 571.51,27.82 pfet_05v0
M$5666 VDD_DEC \$19 \$I4673 VDD_DEC pfet_05v0 L=0.5U W=2U AS=1.54P AD=1.54P
+ PS=5.54U PD=5.54U
* device instance $5667 r180 *1 611.51,27.82 pfet_05v0
M$5667 VDD_DEC \$20 \$I4674 VDD_DEC pfet_05v0 L=0.5U W=2U AS=1.54P AD=1.54P
+ PS=5.54U PD=5.54U
* device instance $5668 r180 *1 531.51,105.82 pfet_05v0
M$5668 VDD_DEC \$37 \$I4675 VDD_DEC pfet_05v0 L=0.5U W=2U AS=1.54P AD=1.54P
+ PS=5.54U PD=5.54U
* device instance $5669 r180 *1 571.51,105.82 pfet_05v0
M$5669 VDD_DEC \$38 \$I4676 VDD_DEC pfet_05v0 L=0.5U W=2U AS=1.54P AD=1.54P
+ PS=5.54U PD=5.54U
* device instance $5670 r180 *1 251.51,417.82 pfet_05v0
M$5670 VDD_DEC \$161 \$I4677 VDD_DEC pfet_05v0 L=0.5U W=2U AS=1.54P AD=1.54P
+ PS=5.54U PD=5.54U
* device instance $5671 r180 *1 611.51,105.82 pfet_05v0
M$5671 VDD_DEC \$39 \$I4678 VDD_DEC pfet_05v0 L=0.5U W=2U AS=1.54P AD=1.54P
+ PS=5.54U PD=5.54U
* device instance $5672 r180 *1 131.51,417.82 pfet_05v0
M$5672 VDD_DEC \$152 \$I4679 VDD_DEC pfet_05v0 L=0.5U W=2U AS=1.54P AD=1.54P
+ PS=5.54U PD=5.54U
* device instance $5673 r180 *1 651.51,105.82 pfet_05v0
M$5673 VDD_DEC \$40 \$I4680 VDD_DEC pfet_05v0 L=0.5U W=2U AS=1.54P AD=1.54P
+ PS=5.54U PD=5.54U
* device instance $5674 r180 *1 211.51,339.82 pfet_05v0
M$5674 VDD_DEC \$159 \$I4681 VDD_DEC pfet_05v0 L=0.5U W=2U AS=1.54P AD=1.54P
+ PS=5.54U PD=5.54U
* device instance $5675 r180 *1 211.51,417.82 pfet_05v0
M$5675 VDD_DEC \$158 \$I4682 VDD_DEC pfet_05v0 L=0.5U W=2U AS=1.54P AD=1.54P
+ PS=5.54U PD=5.54U
* device instance $5676 r180 *1 331.51,573.82 pfet_05v0
M$5676 VDD_DEC \$272 \$I4683 VDD_DEC pfet_05v0 L=0.5U W=2U AS=1.54P AD=1.54P
+ PS=5.54U PD=5.54U
* device instance $5677 r180 *1 131.51,339.82 pfet_05v0
M$5677 VDD_DEC \$153 \$I4684 VDD_DEC pfet_05v0 L=0.5U W=2U AS=1.54P AD=1.54P
+ PS=5.54U PD=5.54U
* device instance $5678 r180 *1 331.51,417.82 pfet_05v0
M$5678 VDD_DEC \$167 \$I4685 VDD_DEC pfet_05v0 L=0.5U W=2U AS=1.54P AD=1.54P
+ PS=5.54U PD=5.54U
* device instance $5679 r180 *1 331.51,339.82 pfet_05v0
M$5679 VDD_DEC \$168 \$I4686 VDD_DEC pfet_05v0 L=0.5U W=2U AS=1.54P AD=1.54P
+ PS=5.54U PD=5.54U
* device instance $5680 r180 *1 331.51,261.82 pfet_05v0
M$5680 VDD_DEC \$96 \$I4687 VDD_DEC pfet_05v0 L=0.5U W=2U AS=1.54P AD=1.54P
+ PS=5.54U PD=5.54U
* device instance $5681 r180 *1 331.51,183.82 pfet_05v0
M$5681 VDD_DEC \$97 \$I4688 VDD_DEC pfet_05v0 L=0.5U W=2U AS=1.54P AD=1.54P
+ PS=5.54U PD=5.54U
* device instance $5682 r180 *1 331.51,105.82 pfet_05v0
M$5682 VDD_DEC \$32 \$I4689 VDD_DEC pfet_05v0 L=0.5U W=2U AS=1.54P AD=1.54P
+ PS=5.54U PD=5.54U
* device instance $5683 r180 *1 331.51,27.82 pfet_05v0
M$5683 VDD_DEC \$13 \$I4690 VDD_DEC pfet_05v0 L=0.5U W=2U AS=1.54P AD=1.54P
+ PS=5.54U PD=5.54U
* device instance $5684 r180 *1 371.51,495.82 pfet_05v0
M$5684 VDD_DEC \$169 \$I4691 VDD_DEC pfet_05v0 L=0.5U W=2U AS=1.54P AD=1.54P
+ PS=5.54U PD=5.54U
* device instance $5685 r180 *1 411.51,495.82 pfet_05v0
M$5685 VDD_DEC \$172 \$I4692 VDD_DEC pfet_05v0 L=0.5U W=2U AS=1.54P AD=1.54P
+ PS=5.54U PD=5.54U
* device instance $5686 r180 *1 451.51,495.82 pfet_05v0
M$5686 VDD_DEC \$175 \$I4693 VDD_DEC pfet_05v0 L=0.5U W=2U AS=1.54P AD=1.54P
+ PS=5.54U PD=5.54U
* device instance $5687 r180 *1 491.51,495.82 pfet_05v0
M$5687 VDD_DEC \$178 \$I4694 VDD_DEC pfet_05v0 L=0.5U W=2U AS=1.54P AD=1.54P
+ PS=5.54U PD=5.54U
* device instance $5688 r180 *1 611.51,495.82 pfet_05v0
M$5688 VDD_DEC \$187 \$I4695 VDD_DEC pfet_05v0 L=0.5U W=2U AS=1.54P AD=1.54P
+ PS=5.54U PD=5.54U
* device instance $5689 r180 *1 651.51,495.82 pfet_05v0
M$5689 VDD_DEC \$190 \$I4696 VDD_DEC pfet_05v0 L=0.5U W=2U AS=1.54P AD=1.54P
+ PS=5.54U PD=5.54U
* device instance $5690 r180 *1 531.51,495.82 pfet_05v0
M$5690 VDD_DEC \$181 \$I4697 VDD_DEC pfet_05v0 L=0.5U W=2U AS=1.54P AD=1.54P
+ PS=5.54U PD=5.54U
* device instance $5691 r180 *1 571.51,495.82 pfet_05v0
M$5691 VDD_DEC \$184 \$I4698 VDD_DEC pfet_05v0 L=0.5U W=2U AS=1.54P AD=1.54P
+ PS=5.54U PD=5.54U
* device instance $5692 r180 *1 171.51,495.82 pfet_05v0
M$5692 VDD_DEC \$154 \$I4699 VDD_DEC pfet_05v0 L=0.5U W=2U AS=1.54P AD=1.54P
+ PS=5.54U PD=5.54U
* device instance $5693 r180 *1 131.51,573.82 pfet_05v0
M$5693 VDD_DEC \$267 \$I4700 VDD_DEC pfet_05v0 L=0.5U W=2U AS=1.54P AD=1.54P
+ PS=5.54U PD=5.54U
* device instance $5694 r180 *1 51.51,495.82 pfet_05v0
M$5694 VDD_DEC \$145 \$I4701 VDD_DEC pfet_05v0 L=0.5U W=2U AS=1.54P AD=1.54P
+ PS=5.54U PD=5.54U
* device instance $5695 r180 *1 91.51,495.82 pfet_05v0
M$5695 VDD_DEC \$148 \$I4702 VDD_DEC pfet_05v0 L=0.5U W=2U AS=1.54P AD=1.54P
+ PS=5.54U PD=5.54U
* device instance $5696 r180 *1 131.51,495.82 pfet_05v0
M$5696 VDD_DEC \$151 \$I4703 VDD_DEC pfet_05v0 L=0.5U W=2U AS=1.54P AD=1.54P
+ PS=5.54U PD=5.54U
* device instance $5697 r180 *1 211.51,495.82 pfet_05v0
M$5697 VDD_DEC \$157 \$I4704 VDD_DEC pfet_05v0 L=0.5U W=2U AS=1.54P AD=1.54P
+ PS=5.54U PD=5.54U
* device instance $5698 r180 *1 251.51,495.82 pfet_05v0
M$5698 VDD_DEC \$160 \$I4705 VDD_DEC pfet_05v0 L=0.5U W=2U AS=1.54P AD=1.54P
+ PS=5.54U PD=5.54U
* device instance $5699 r180 *1 291.51,495.82 pfet_05v0
M$5699 VDD_DEC \$163 \$I4706 VDD_DEC pfet_05v0 L=0.5U W=2U AS=1.54P AD=1.54P
+ PS=5.54U PD=5.54U
* device instance $5700 r180 *1 291.51,573.82 pfet_05v0
M$5700 VDD_DEC \$271 \$I4707 VDD_DEC pfet_05v0 L=0.5U W=2U AS=1.54P AD=1.54P
+ PS=5.54U PD=5.54U
* device instance $5701 r180 *1 251.51,261.82 pfet_05v0
M$5701 VDD_DEC \$92 \$I4708 VDD_DEC pfet_05v0 L=0.5U W=2U AS=1.54P AD=1.54P
+ PS=5.54U PD=5.54U
* device instance $5702 r180 *1 291.51,261.82 pfet_05v0
M$5702 VDD_DEC \$94 \$I4709 VDD_DEC pfet_05v0 L=0.5U W=2U AS=1.54P AD=1.54P
+ PS=5.54U PD=5.54U
* device instance $5703 r180 *1 131.51,261.82 pfet_05v0
M$5703 VDD_DEC \$86 \$I4710 VDD_DEC pfet_05v0 L=0.5U W=2U AS=1.54P AD=1.54P
+ PS=5.54U PD=5.54U
* device instance $5704 r180 *1 91.51,261.82 pfet_05v0
M$5704 VDD_DEC \$84 \$I4711 VDD_DEC pfet_05v0 L=0.5U W=2U AS=1.54P AD=1.54P
+ PS=5.54U PD=5.54U
* device instance $5705 r180 *1 251.51,573.82 pfet_05v0
M$5705 VDD_DEC \$270 \$I4712 VDD_DEC pfet_05v0 L=0.5U W=2U AS=1.54P AD=1.54P
+ PS=5.54U PD=5.54U
* device instance $5706 r180 *1 51.51,261.82 pfet_05v0
M$5706 VDD_DEC \$82 \$I4713 VDD_DEC pfet_05v0 L=0.5U W=2U AS=1.54P AD=1.54P
+ PS=5.54U PD=5.54U
* device instance $5707 r180 *1 171.51,417.82 pfet_05v0
M$5707 VDD_DEC \$155 \$I4714 VDD_DEC pfet_05v0 L=0.5U W=2U AS=1.54P AD=1.54P
+ PS=5.54U PD=5.54U
* device instance $5708 r180 *1 171.51,261.82 pfet_05v0
M$5708 VDD_DEC \$88 \$I4715 VDD_DEC pfet_05v0 L=0.5U W=2U AS=1.54P AD=1.54P
+ PS=5.54U PD=5.54U
* device instance $5709 r180 *1 211.51,261.82 pfet_05v0
M$5709 VDD_DEC \$90 \$I4716 VDD_DEC pfet_05v0 L=0.5U W=2U AS=1.54P AD=1.54P
+ PS=5.54U PD=5.54U
* device instance $5710 r180 *1 251.51,183.82 pfet_05v0
M$5710 VDD_DEC \$93 \$I4717 VDD_DEC pfet_05v0 L=0.5U W=2U AS=1.54P AD=1.54P
+ PS=5.54U PD=5.54U
* device instance $5711 r180 *1 451.51,573.82 pfet_05v0
M$5711 VDD_DEC \$275 \$I4718 VDD_DEC pfet_05v0 L=0.5U W=2U AS=1.54P AD=1.54P
+ PS=5.54U PD=5.54U
* device instance $5712 r180 *1 491.51,573.82 pfet_05v0
M$5712 VDD_DEC \$276 \$I4719 VDD_DEC pfet_05v0 L=0.5U W=2U AS=1.54P AD=1.54P
+ PS=5.54U PD=5.54U
* device instance $5713 r180 *1 371.51,339.82 pfet_05v0
M$5713 VDD_DEC \$171 \$I4720 VDD_DEC pfet_05v0 L=0.5U W=2U AS=1.54P AD=1.54P
+ PS=5.54U PD=5.54U
* device instance $5714 r180 *1 371.51,417.82 pfet_05v0
M$5714 VDD_DEC \$170 \$I4721 VDD_DEC pfet_05v0 L=0.5U W=2U AS=1.54P AD=1.54P
+ PS=5.54U PD=5.54U
* device instance $5715 r180 *1 491.51,417.82 pfet_05v0
M$5715 VDD_DEC \$179 \$I4722 VDD_DEC pfet_05v0 L=0.5U W=2U AS=1.54P AD=1.54P
+ PS=5.54U PD=5.54U
* device instance $5716 r180 *1 251.51,27.82 pfet_05v0
M$5716 VDD_DEC \$11 \$I4723 VDD_DEC pfet_05v0 L=0.5U W=2U AS=1.54P AD=1.54P
+ PS=5.54U PD=5.54U
* device instance $5717 r180 *1 491.51,339.82 pfet_05v0
M$5717 VDD_DEC \$180 \$I4724 VDD_DEC pfet_05v0 L=0.5U W=2U AS=1.54P AD=1.54P
+ PS=5.54U PD=5.54U
* device instance $5718 r180 *1 451.51,417.82 pfet_05v0
M$5718 VDD_DEC \$176 \$I4725 VDD_DEC pfet_05v0 L=0.5U W=2U AS=1.54P AD=1.54P
+ PS=5.54U PD=5.54U
* device instance $5719 r180 *1 411.51,417.82 pfet_05v0
M$5719 VDD_DEC \$173 \$I4726 VDD_DEC pfet_05v0 L=0.5U W=2U AS=1.54P AD=1.54P
+ PS=5.54U PD=5.54U
* device instance $5720 r180 *1 611.51,417.82 pfet_05v0
M$5720 VDD_DEC \$188 \$I4727 VDD_DEC pfet_05v0 L=0.5U W=2U AS=1.54P AD=1.54P
+ PS=5.54U PD=5.54U
* device instance $5721 r180 *1 571.51,417.82 pfet_05v0
M$5721 VDD_DEC \$185 \$I4728 VDD_DEC pfet_05v0 L=0.5U W=2U AS=1.54P AD=1.54P
+ PS=5.54U PD=5.54U
* device instance $5722 r180 *1 531.51,417.82 pfet_05v0
M$5722 VDD_DEC \$182 \$I4729 VDD_DEC pfet_05v0 L=0.5U W=2U AS=1.54P AD=1.54P
+ PS=5.54U PD=5.54U
* device instance $5723 r180 *1 531.51,573.82 pfet_05v0
M$5723 VDD_DEC \$277 \$I4730 VDD_DEC pfet_05v0 L=0.5U W=2U AS=1.54P AD=1.54P
+ PS=5.54U PD=5.54U
* device instance $5724 r180 *1 571.51,573.82 pfet_05v0
M$5724 VDD_DEC \$278 \$I4731 VDD_DEC pfet_05v0 L=0.5U W=2U AS=1.54P AD=1.54P
+ PS=5.54U PD=5.54U
* device instance $5725 r180 *1 331.51,495.82 pfet_05v0
M$5725 VDD_DEC \$166 \$I4732 VDD_DEC pfet_05v0 L=0.5U W=2U AS=1.54P AD=1.54P
+ PS=5.54U PD=5.54U
* device instance $5726 r180 *1 611.51,573.82 pfet_05v0
M$5726 VDD_DEC \$279 \$I4733 VDD_DEC pfet_05v0 L=0.5U W=2U AS=1.54P AD=1.54P
+ PS=5.54U PD=5.54U
* device instance $5727 r180 *1 211.51,27.82 pfet_05v0
M$5727 VDD_DEC \$10 \$I4734 VDD_DEC pfet_05v0 L=0.5U W=2U AS=1.54P AD=1.54P
+ PS=5.54U PD=5.54U
* device instance $5728 r180 *1 571.51,339.82 pfet_05v0
M$5728 VDD_DEC \$186 \$I4735 VDD_DEC pfet_05v0 L=0.5U W=2U AS=1.54P AD=1.54P
+ PS=5.54U PD=5.54U
* device instance $5729 r180 *1 651.51,417.82 pfet_05v0
M$5729 VDD_DEC \$191 \$I4736 VDD_DEC pfet_05v0 L=0.5U W=2U AS=1.54P AD=1.54P
+ PS=5.54U PD=5.54U
* device instance $5730 r180 *1 571.51,261.82 pfet_05v0
M$5730 VDD_DEC \$108 \$I4737 VDD_DEC pfet_05v0 L=0.5U W=2U AS=1.54P AD=1.54P
+ PS=5.54U PD=5.54U
* device instance $5731 r180 *1 611.51,261.82 pfet_05v0
M$5731 VDD_DEC \$110 \$I4738 VDD_DEC pfet_05v0 L=0.5U W=2U AS=1.54P AD=1.54P
+ PS=5.54U PD=5.54U
* device instance $5732 r180 *1 651.51,261.82 pfet_05v0
M$5732 VDD_DEC \$112 \$I4739 VDD_DEC pfet_05v0 L=0.5U W=2U AS=1.54P AD=1.54P
+ PS=5.54U PD=5.54U
* device instance $5733 r180 *1 531.51,261.82 pfet_05v0
M$5733 VDD_DEC \$106 \$I4740 VDD_DEC pfet_05v0 L=0.5U W=2U AS=1.54P AD=1.54P
+ PS=5.54U PD=5.54U
* device instance $5734 r180 *1 491.51,261.82 pfet_05v0
M$5734 VDD_DEC \$104 \$I4741 VDD_DEC pfet_05v0 L=0.5U W=2U AS=1.54P AD=1.54P
+ PS=5.54U PD=5.54U
* device instance $5735 r180 *1 651.51,339.82 pfet_05v0
M$5735 VDD_DEC \$192 \$I4742 VDD_DEC pfet_05v0 L=0.5U W=2U AS=1.54P AD=1.54P
+ PS=5.54U PD=5.54U
* device instance $5736 r180 *1 451.51,261.82 pfet_05v0
M$5736 VDD_DEC \$102 \$I4743 VDD_DEC pfet_05v0 L=0.5U W=2U AS=1.54P AD=1.54P
+ PS=5.54U PD=5.54U
* device instance $5737 r180 *1 371.51,261.82 pfet_05v0
M$5737 VDD_DEC \$98 \$I4744 VDD_DEC pfet_05v0 L=0.5U W=2U AS=1.54P AD=1.54P
+ PS=5.54U PD=5.54U
* device instance $5738 r180 *1 611.51,339.82 pfet_05v0
M$5738 VDD_DEC \$189 \$I4745 VDD_DEC pfet_05v0 L=0.5U W=2U AS=1.54P AD=1.54P
+ PS=5.54U PD=5.54U
* device instance $5739 r180 *1 411.51,261.82 pfet_05v0
M$5739 VDD_DEC \$100 \$I4746 VDD_DEC pfet_05v0 L=0.5U W=2U AS=1.54P AD=1.54P
+ PS=5.54U PD=5.54U
* device instance $5740 r180 *1 531.51,339.82 pfet_05v0
M$5740 VDD_DEC \$183 \$I4747 VDD_DEC pfet_05v0 L=0.5U W=2U AS=1.54P AD=1.54P
+ PS=5.54U PD=5.54U
* device instance $5741 r180 *1 651.51,573.82 pfet_05v0
M$5741 VDD_DEC \$280 \$I4748 VDD_DEC pfet_05v0 L=0.5U W=2U AS=1.54P AD=1.54P
+ PS=5.54U PD=5.54U
* device instance $5742 r180 *1 91.51,573.82 pfet_05v0
M$5742 VDD_DEC \$266 \$I4749 VDD_DEC pfet_05v0 L=0.5U W=2U AS=1.54P AD=1.54P
+ PS=5.54U PD=5.54U
* device instance $5743 r180 *1 91.51,417.82 pfet_05v0
M$5743 VDD_DEC \$149 \$I4750 VDD_DEC pfet_05v0 L=0.5U W=2U AS=1.54P AD=1.54P
+ PS=5.54U PD=5.54U
* device instance $5744 r180 *1 51.51,417.82 pfet_05v0
M$5744 VDD_DEC \$146 \$I4751 VDD_DEC pfet_05v0 L=0.5U W=2U AS=1.54P AD=1.54P
+ PS=5.54U PD=5.54U
* device instance $5745 r180 *1 131.51,27.82 pfet_05v0
M$5745 VDD_DEC \$8 \$I4752 VDD_DEC pfet_05v0 L=0.5U W=2U AS=1.54P AD=1.54P
+ PS=5.54U PD=5.54U
* device instance $5746 r180 *1 51.51,105.82 pfet_05v0
M$5746 VDD_DEC \$25 \$I4753 VDD_DEC pfet_05v0 L=0.5U W=2U AS=1.54P AD=1.54P
+ PS=5.54U PD=5.54U
* device instance $5747 r180 *1 91.51,105.82 pfet_05v0
M$5747 VDD_DEC \$26 \$I4754 VDD_DEC pfet_05v0 L=0.5U W=2U AS=1.54P AD=1.54P
+ PS=5.54U PD=5.54U
* device instance $5748 r180 *1 131.51,105.82 pfet_05v0
M$5748 VDD_DEC \$27 \$I4755 VDD_DEC pfet_05v0 L=0.5U W=2U AS=1.54P AD=1.54P
+ PS=5.54U PD=5.54U
* device instance $5749 r180 *1 451.51,27.82 pfet_05v0
M$5749 VDD_DEC \$16 \$I4756 VDD_DEC pfet_05v0 L=0.5U W=2U AS=1.54P AD=1.54P
+ PS=5.54U PD=5.54U
* device instance $5750 r180 *1 91.51,27.82 pfet_05v0
M$5750 VDD_DEC \$7 \$I4757 VDD_DEC pfet_05v0 L=0.5U W=2U AS=1.54P AD=1.54P
+ PS=5.54U PD=5.54U
* device instance $5751 r180 *1 51.51,183.82 pfet_05v0
M$5751 VDD_DEC \$83 \$I4758 VDD_DEC pfet_05v0 L=0.5U W=2U AS=1.54P AD=1.54P
+ PS=5.54U PD=5.54U
* device instance $5752 r180 *1 91.51,183.82 pfet_05v0
M$5752 VDD_DEC \$85 \$I4759 VDD_DEC pfet_05v0 L=0.5U W=2U AS=1.54P AD=1.54P
+ PS=5.54U PD=5.54U
* device instance $5753 r180 *1 131.51,183.82 pfet_05v0
M$5753 VDD_DEC \$87 \$I4760 VDD_DEC pfet_05v0 L=0.5U W=2U AS=1.54P AD=1.54P
+ PS=5.54U PD=5.54U
* device instance $5754 r180 *1 491.51,27.82 pfet_05v0
M$5754 VDD_DEC \$17 \$I4761 VDD_DEC pfet_05v0 L=0.5U W=2U AS=1.54P AD=1.54P
+ PS=5.54U PD=5.54U
* device instance $5755 r180 *1 291.51,27.82 pfet_05v0
M$5755 VDD_DEC \$12 \$I4762 VDD_DEC pfet_05v0 L=0.5U W=2U AS=1.54P AD=1.54P
+ PS=5.54U PD=5.54U
* device instance $5756 r180 *1 411.51,573.82 pfet_05v0
M$5756 VDD_DEC \$274 \$I4763 VDD_DEC pfet_05v0 L=0.5U W=2U AS=1.54P AD=1.54P
+ PS=5.54U PD=5.54U
* device instance $5757 r180 *1 411.51,339.82 pfet_05v0
M$5757 VDD_DEC \$174 \$I4764 VDD_DEC pfet_05v0 L=0.5U W=2U AS=1.54P AD=1.54P
+ PS=5.54U PD=5.54U
* device instance $5758 r180 *1 211.51,183.82 pfet_05v0
M$5758 VDD_DEC \$91 \$I4765 VDD_DEC pfet_05v0 L=0.5U W=2U AS=1.54P AD=1.54P
+ PS=5.54U PD=5.54U
* device instance $5759 r180 *1 291.51,183.82 pfet_05v0
M$5759 VDD_DEC \$95 \$I4766 VDD_DEC pfet_05v0 L=0.5U W=2U AS=1.54P AD=1.54P
+ PS=5.54U PD=5.54U
* device instance $5760 r180 *1 291.51,105.82 pfet_05v0
M$5760 VDD_DEC \$31 \$I4767 VDD_DEC pfet_05v0 L=0.5U W=2U AS=1.54P AD=1.54P
+ PS=5.54U PD=5.54U
* device instance $5761 r180 *1 451.51,339.82 pfet_05v0
M$5761 VDD_DEC \$177 \$I4768 VDD_DEC pfet_05v0 L=0.5U W=2U AS=1.54P AD=1.54P
+ PS=5.54U PD=5.54U
* device instance $5762 r180 *1 371.51,573.82 pfet_05v0
M$5762 VDD_DEC \$273 \$I4769 VDD_DEC pfet_05v0 L=0.5U W=2U AS=1.54P AD=1.54P
+ PS=5.54U PD=5.54U
* device instance $5763 r180 *1 211.51,105.82 pfet_05v0
M$5763 VDD_DEC \$29 \$I4770 VDD_DEC pfet_05v0 L=0.5U W=2U AS=1.54P AD=1.54P
+ PS=5.54U PD=5.54U
* device instance $5764 r180 *1 251.51,105.82 pfet_05v0
M$5764 VDD_DEC \$30 \$I4771 VDD_DEC pfet_05v0 L=0.5U W=2U AS=1.54P AD=1.54P
+ PS=5.54U PD=5.54U
* device instance $5765 r180 *1 411.51,183.82 pfet_05v0
M$5765 VDD_DEC \$101 \$I4772 VDD_DEC pfet_05v0 L=0.5U W=2U AS=1.54P AD=1.54P
+ PS=5.54U PD=5.54U
* device instance $5766 r180 *1 451.51,183.82 pfet_05v0
M$5766 VDD_DEC \$103 \$I4773 VDD_DEC pfet_05v0 L=0.5U W=2U AS=1.54P AD=1.54P
+ PS=5.54U PD=5.54U
* device instance $5767 r180 *1 491.51,183.82 pfet_05v0
M$5767 VDD_DEC \$105 \$I4774 VDD_DEC pfet_05v0 L=0.5U W=2U AS=1.54P AD=1.54P
+ PS=5.54U PD=5.54U
* device instance $5768 r180 *1 411.51,105.82 pfet_05v0
M$5768 VDD_DEC \$34 \$I4775 VDD_DEC pfet_05v0 L=0.5U W=2U AS=1.54P AD=1.54P
+ PS=5.54U PD=5.54U
* device instance $5769 r180 *1 451.51,105.82 pfet_05v0
M$5769 VDD_DEC \$35 \$I4776 VDD_DEC pfet_05v0 L=0.5U W=2U AS=1.54P AD=1.54P
+ PS=5.54U PD=5.54U
* device instance $5770 r180 *1 491.51,105.82 pfet_05v0
M$5770 VDD_DEC \$36 \$I4777 VDD_DEC pfet_05v0 L=0.5U W=2U AS=1.54P AD=1.54P
+ PS=5.54U PD=5.54U
* device instance $5771 r180 *1 171.51,573.82 pfet_05v0
M$5771 VDD_DEC \$268 \$I4778 VDD_DEC pfet_05v0 L=0.5U W=2U AS=1.54P AD=1.54P
+ PS=5.54U PD=5.54U
* device instance $5772 r180 *1 411.51,27.82 pfet_05v0
M$5772 VDD_DEC \$15 \$I4779 VDD_DEC pfet_05v0 L=0.5U W=2U AS=1.54P AD=1.54P
+ PS=5.54U PD=5.54U
* device instance $5773 r180 *1 371.51,183.82 pfet_05v0
M$5773 VDD_DEC \$99 \$I4780 VDD_DEC pfet_05v0 L=0.5U W=2U AS=1.54P AD=1.54P
+ PS=5.54U PD=5.54U
.ENDS workshop_inverter

* cell cs_inv_5v0
* pin
* pin
* pin
* pin
* pin
* pin SUB
.SUBCKT cs_inv_5v0 \$2 \$4 \$15 \$25 \$26 SUB
* device instance $1 r0 *1 2.97,7.835 pfet_05v0
M$1 \$2 \$26 \$1 \$2 pfet_05v0 L=1U W=16U AS=6.2P AD=5.28P PS=23.1U PD=18.64U
* device instance $5 r0 *1 9.36,7.835 pfet_05v0
M$5 \$4 \$15 \$1 \$2 pfet_05v0 L=0.5U W=4U AS=2.16P AD=3.08P PS=5.08U PD=9.54U
* device instance $6 r0 *1 6,1.775 nfet_05v0
M$6 SUB \$25 \$5 SUB nfet_05v0 L=1U W=4U AS=1.98P AD=1.56P PS=7.98U PD=5.56U
* device instance $8 r0 *1 9.36,1.775 nfet_05v0
M$8 \$4 \$15 \$5 SUB nfet_05v0 L=0.6U W=2U AS=1.04P AD=1.46P PS=3.04U PD=5.46U
.ENDS cs_inv_5v0

* cell cs_inv_x4_5v0
* pin
* pin
* pin
* pin
* pin
* pin SUB
.SUBCKT cs_inv_x4_5v0 \$1 \$4 \$18 \$52 \$53 SUB
* device instance $1 r0 *1 2.97,7.835 pfet_05v0
M$1 \$4 \$53 \$3 \$4 pfet_05v0 L=1U W=64U AS=18.68P AD=17.76P PS=77.34U
+ PD=72.88U
* device instance $17 r0 *1 27.6,7.835 pfet_05v0
M$17 \$1 \$18 \$3 \$4 pfet_05v0 L=0.5U W=12U AS=5.36P AD=6.28P PS=14.68U
+ PD=19.14U
* device instance $20 r0 *1 15.07,1.775 nfet_05v0
M$20 SUB \$52 \$2 SUB nfet_05v0 L=1U W=16U AS=5.1P AD=4.68P PS=23.1U PD=20.68U
* device instance $28 r0 *1 27.55,1.775 nfet_05v0
M$28 \$1 \$18 \$2 SUB nfet_05v0 L=0.6U W=6U AS=2.64P AD=3.06P PS=8.64U PD=11.06U
.ENDS cs_inv_x4_5v0

* cell vco_bias_5v0
* pin
* pin
* pin
* pin
* pin SUB
.SUBCKT vco_bias_5v0 \$1 \$2 \$7 \$8 SUB
* device instance $1 r0 *1 2.97,7.835 pfet_05v0
M$1 \$7 \$7 \$2 \$2 pfet_05v0 L=1U W=16U AS=6.2P AD=5.28P PS=23.1U PD=18.64U
* device instance $5 r0 *1 9.61,7.835 pfet_05v0
M$5 \$1 \$7 \$2 \$2 pfet_05v0 L=1U W=16U AS=5.28P AD=6.2P PS=18.64U PD=23.1U
* device instance $9 r0 *1 8.29,1.775 nfet_05v0
M$9 SUB \$8 \$7 SUB nfet_05v0 L=2U W=2U AS=1.46P AD=1.04P PS=5.46U PD=3.04U
* device instance $10 r0 *1 10.83,1.775 nfet_05v0
M$10 \$1 \$1 SUB SUB nfet_05v0 L=1U W=4U AS=1.56P AD=1.98P PS=5.56U PD=7.98U
.ENDS vco_bias_5v0
